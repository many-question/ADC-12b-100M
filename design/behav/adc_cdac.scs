// adc_cdac, behavioral view: one side of the split-capacitor redundant CDAC
// @RNL(type="header") {
//   @VERSION("0.4");
//   @USE-PACKAGE(name="adc28", version="0.2", path="../rnl/0.4/adc28.rnl")
// }
// generated by `python -m adcflow gen` from specs/ -- do not edit (specs/arch.yaml, cdac section)
// Uses the deck globals noise_en and tempc.
simulator lang=spectre

subckt adc_cdac (VIN VG TOP VCM VREFP VREFN PHI_S PHI_SB CONV \
        DH12 DH11 DH10 DH9 DH8 DH7 DH6 DH5 DH4 DH3 DH2 DH1 DH0 \
        RL12 RL11 RL10 RL9 RL8 RL7 RL6 RL5 RL4 RL3 RL2 RL1 RL0 DVDD VSS)
parameters cu=1e-15 cp_ratio=0.1 ron_in=12.5 tau_drv=12p ron_top=10 \
        cin_ctrl=4.5f cin_phs=30f cin_phsb=30f cin_conv=60f
// input switches (gate VG), tri-state VREFP/VREFN drivers, neutral states
ISW (VIN VG VREFP VREFN CONV \
        DH12 DH11 DH10 DH9 DH8 DH7 DH6 DH5 DH4 DH3 DH2 DH1 DH0 \
        RL12 RL11 RL10 RL9 RL8 RL7 RL6 RL5 RL4 RL3 RL2 RL1 RL0 \
        BH12 BL12 BH11 BL11 BH10 BL10 BH9 BL9 BH8 BL8 BH7 BL7 BH6 \
        BL6 BH5 BL5 BH4 BL4 BH3 BL3 BH2 BL2 BH1 BL1 BH0 BL0 VSS) adc_cdac_sw_va cu=cu ron_in=ron_in tau_drv=tau_drv \
        cin_ctrl=cin_ctrl
// capacitor array: weight w = two halves of w*cu/2 (H: neutral VREFP, L: neutral VREFN)
CH12 (BH12 TOP) capacitor c=490*cu
CL12 (BL12 TOP) capacitor c=490*cu
CH11 (BH11 TOP) capacitor c=280*cu
CL11 (BL11 TOP) capacitor c=280*cu
CH10 (BH10 TOP) capacitor c=159*cu
CL10 (BL10 TOP) capacitor c=159*cu
CH9 (BH9 TOP) capacitor c=90*cu
CL9 (BL9 TOP) capacitor c=90*cu
CH8 (BH8 TOP) capacitor c=51*cu
CL8 (BL8 TOP) capacitor c=51*cu
CH7 (BH7 TOP) capacitor c=28.5*cu
CL7 (BL7 TOP) capacitor c=28.5*cu
CH6 (BH6 TOP) capacitor c=16*cu
CL6 (BL6 TOP) capacitor c=16*cu
CH5 (BH5 TOP) capacitor c=9*cu
CL5 (BL5 TOP) capacitor c=9*cu
CH4 (BH4 TOP) capacitor c=5*cu
CL4 (BL4 TOP) capacitor c=5*cu
CH3 (BH3 TOP) capacitor c=3*cu
CL3 (BL3 TOP) capacitor c=3*cu
CH2 (BH2 TOP) capacitor c=1.5*cu
CL2 (BL2 TOP) capacitor c=1.5*cu
CH1 (BH1 TOP) capacitor c=1*cu
CL1 (BL1 TOP) capacitor c=1*cu
CH0 (BH0 TOP) capacitor c=0.5*cu
CL0 (BL0 TOP) capacitor c=0.5*cu
// top-plate parasitic: routing, switch junctions, comparator input
CP (TOP VSS) capacitor c=cp_ratio*2269*cu
// top-plate reset switch (PHI_S high = track) in series with the sampled kT/C source
STOP (TOP NK PHI_S VSS) relay vt1=0.35 vt2=0.55 ropen=1e12 rclosed=ron_top
IKTC (NK VCM PHI_S VSS) adc_ktc_va ctot=(1+cp_ratio)*2269*cu tempc=tempc en=noise_en
// clock input capacitances
CPHS (PHI_S VSS) capacitor c=cin_phs
CPHSB (PHI_SB VSS) capacitor c=cin_phsb
CCONV (CONV VSS) capacitor c=cin_conv
// @RNL {
//   /* every pin is wired here or labelled with its net: no net-label stubs from the fill */
//   # @SELECT-PIN => @REMOVE-FROM $LABEL_FILL_SET;
//   /* --- semantics --- */
//   &VSS @ADD-TO $GROUND_NET_SET;
//   /* one array: every half is a matched multiple of the unit cu; each weight is an H/L pair */
//   {#CH12 #CL12 #CH11 #CL11 #CH10 #CL10 #CH9 #CL9 #CH8 #CL8 #CH7 #CL7 #CH6 #CL6 #CH5 #CL5 #CH4 #CL4 #CH3 #CL3 #CH2 #CL2 #CH1 #CL1 #CH0 #CL0} @AS $MATCHED;
//   {#CH12 #CL12} @AS $MATCHED;
//   {#CH12 #CL12} @GROUP;
//   {#CH11 #CL11} @AS $MATCHED;
//   {#CH11 #CL11} @GROUP;
//   {#CH10 #CL10} @AS $MATCHED;
//   {#CH10 #CL10} @GROUP;
//   {#CH9 #CL9} @AS $MATCHED;
//   {#CH9 #CL9} @GROUP;
//   {#CH8 #CL8} @AS $MATCHED;
//   {#CH8 #CL8} @GROUP;
//   {#CH7 #CL7} @AS $MATCHED;
//   {#CH7 #CL7} @GROUP;
//   {#CH6 #CL6} @AS $MATCHED;
//   {#CH6 #CL6} @GROUP;
//   {#CH5 #CL5} @AS $MATCHED;
//   {#CH5 #CL5} @GROUP;
//   {#CH4 #CL4} @AS $MATCHED;
//   {#CH4 #CL4} @GROUP;
//   {#CH3 #CL3} @AS $MATCHED;
//   {#CH3 #CL3} @GROUP;
//   {#CH2 #CL2} @AS $MATCHED;
//   {#CH2 #CL2} @GROUP;
//   {#CH1 #CL1} @AS $MATCHED;
//   {#CH1 #CL1} @GROUP;
//   {#CH0 #CL0} @AS $MATCHED;
//   {#CH0 #CL0} @GROUP;
//   /* the top plate: the array, its parasitic, the reset switch and the sampled kT/C noise */
//   {#CP #STOP #IKTC} @AS $SIGNAL_FLOW;
//   /* --- placement: switch matrix at the bottom, each half above its bottom-plate pin --- */
//   #ISW @PLACE(0, 0);
//   #CH12 @PLACE(0, 13) => @ORIENT("MX");
//   #CL12 @PLACE(3, 13) => @ORIENT("MX");
//   #CH11 @PLACE(6, 13) => @ORIENT("MX");
//   #CL11 @PLACE(9, 13) => @ORIENT("MX");
//   #CH10 @PLACE(12, 13) => @ORIENT("MX");
//   #CL10 @PLACE(15, 13) => @ORIENT("MX");
//   #CH9 @PLACE(18, 13) => @ORIENT("MX");
//   #CL9 @PLACE(21, 13) => @ORIENT("MX");
//   #CH8 @PLACE(24, 13) => @ORIENT("MX");
//   #CL8 @PLACE(27, 13) => @ORIENT("MX");
//   #CH7 @PLACE(30, 13) => @ORIENT("MX");
//   #CL7 @PLACE(33, 13) => @ORIENT("MX");
//   #CH6 @PLACE(36, 13) => @ORIENT("MX");
//   #CL6 @PLACE(39, 13) => @ORIENT("MX");
//   #CH5 @PLACE(42, 13) => @ORIENT("MX");
//   #CL5 @PLACE(45, 13) => @ORIENT("MX");
//   #CH4 @PLACE(48, 13) => @ORIENT("MX");
//   #CL4 @PLACE(51, 13) => @ORIENT("MX");
//   #CH3 @PLACE(54, 13) => @ORIENT("MX");
//   #CL3 @PLACE(57, 13) => @ORIENT("MX");
//   #CH2 @PLACE(60, 13) => @ORIENT("MX");
//   #CL2 @PLACE(63, 13) => @ORIENT("MX");
//   #CH1 @PLACE(66, 13) => @ORIENT("MX");
//   #CL1 @PLACE(69, 13) => @ORIENT("MX");
//   #CH0 @PLACE(72, 13) => @ORIENT("MX");
//   #CL0 @PLACE(75, 13) => @ORIENT("MX");
//   #CP @PLACE(84, 13);
//   #STOP @PLACE(94, 17);
//   #STOP @SET-SYMBOL $VOLTAGE_CONTROLLED_SWITCH;    /* 0.4 draws a relay controlled from ground otherwise */
//   #IKTC @PLACE(104, 9);
//   #CPHS @PLACE(93, 3);
//   #CPHSB @PLACE(-22, 11);
//   #CCONV @PLACE(-22, -11);
//   /* --- bottom plates --- */
//   &BH12 @WIRE {#ISW:BH12 #CH12:1};
//   &BL12 @WIRE {#ISW:BL12 #CL12:1};
//   &BH11 @WIRE {#ISW:BH11 #CH11:1};
//   &BL11 @WIRE {#ISW:BL11 #CL11:1};
//   &BH10 @WIRE {#ISW:BH10 #CH10:1};
//   &BL10 @WIRE {#ISW:BL10 #CL10:1};
//   &BH9 @WIRE {#ISW:BH9 #CH9:1};
//   &BL9 @WIRE {#ISW:BL9 #CL9:1};
//   &BH8 @WIRE {#ISW:BH8 #CH8:1};
//   &BL8 @WIRE {#ISW:BL8 #CL8:1};
//   &BH7 @WIRE {#ISW:BH7 #CH7:1};
//   &BL7 @WIRE {#ISW:BL7 #CL7:1};
//   &BH6 @WIRE {#ISW:BH6 #CH6:1};
//   &BL6 @WIRE {#ISW:BL6 #CL6:1};
//   &BH5 @WIRE {#ISW:BH5 #CH5:1};
//   &BL5 @WIRE {#ISW:BL5 #CL5:1};
//   &BH4 @WIRE {#ISW:BH4 #CH4:1};
//   &BL4 @WIRE {#ISW:BL4 #CL4:1};
//   &BH3 @WIRE {#ISW:BH3 #CH3:1};
//   &BL3 @WIRE {#ISW:BL3 #CL3:1};
//   &BH2 @WIRE {#ISW:BH2 #CH2:1};
//   &BL2 @WIRE {#ISW:BL2 #CL2:1};
//   &BH1 @WIRE {#ISW:BH1 #CH1:1};
//   &BL1 @WIRE {#ISW:BL1 #CL1:1};
//   &BH0 @WIRE {#ISW:BH0 #CH0:1};
//   &BL0 @WIRE {#ISW:BL0 #CL0:1};
//   /* --- top plate: one line across the array to the reset switch --- */
//   %t0 = (0, 17);
//   &TOP @WIRE {%t0 #CH12:2};
//   %t1 = (3, 17);
//   $JUNCTION @ATTACH %t1 => @PLACE(3, 17);
//   &TOP @WIRE {%t1 #CL12:2};
//   %t2 = (6, 17);
//   $JUNCTION @ATTACH %t2 => @PLACE(6, 17);
//   &TOP @WIRE {%t2 #CH11:2};
//   %t3 = (9, 17);
//   $JUNCTION @ATTACH %t3 => @PLACE(9, 17);
//   &TOP @WIRE {%t3 #CL11:2};
//   %t4 = (12, 17);
//   $JUNCTION @ATTACH %t4 => @PLACE(12, 17);
//   &TOP @WIRE {%t4 #CH10:2};
//   %t5 = (15, 17);
//   $JUNCTION @ATTACH %t5 => @PLACE(15, 17);
//   &TOP @WIRE {%t5 #CL10:2};
//   %t6 = (18, 17);
//   $JUNCTION @ATTACH %t6 => @PLACE(18, 17);
//   &TOP @WIRE {%t6 #CH9:2};
//   %t7 = (21, 17);
//   $JUNCTION @ATTACH %t7 => @PLACE(21, 17);
//   &TOP @WIRE {%t7 #CL9:2};
//   %t8 = (24, 17);
//   $JUNCTION @ATTACH %t8 => @PLACE(24, 17);
//   &TOP @WIRE {%t8 #CH8:2};
//   %t9 = (27, 17);
//   $JUNCTION @ATTACH %t9 => @PLACE(27, 17);
//   &TOP @WIRE {%t9 #CL8:2};
//   %t10 = (30, 17);
//   $JUNCTION @ATTACH %t10 => @PLACE(30, 17);
//   &TOP @WIRE {%t10 #CH7:2};
//   %t11 = (33, 17);
//   $JUNCTION @ATTACH %t11 => @PLACE(33, 17);
//   &TOP @WIRE {%t11 #CL7:2};
//   %t12 = (36, 17);
//   $JUNCTION @ATTACH %t12 => @PLACE(36, 17);
//   &TOP @WIRE {%t12 #CH6:2};
//   %t13 = (39, 17);
//   $JUNCTION @ATTACH %t13 => @PLACE(39, 17);
//   &TOP @WIRE {%t13 #CL6:2};
//   %t14 = (42, 17);
//   $JUNCTION @ATTACH %t14 => @PLACE(42, 17);
//   &TOP @WIRE {%t14 #CH5:2};
//   %t15 = (45, 17);
//   $JUNCTION @ATTACH %t15 => @PLACE(45, 17);
//   &TOP @WIRE {%t15 #CL5:2};
//   %t16 = (48, 17);
//   $JUNCTION @ATTACH %t16 => @PLACE(48, 17);
//   &TOP @WIRE {%t16 #CH4:2};
//   %t17 = (51, 17);
//   $JUNCTION @ATTACH %t17 => @PLACE(51, 17);
//   &TOP @WIRE {%t17 #CL4:2};
//   %t18 = (54, 17);
//   $JUNCTION @ATTACH %t18 => @PLACE(54, 17);
//   &TOP @WIRE {%t18 #CH3:2};
//   %t19 = (57, 17);
//   $JUNCTION @ATTACH %t19 => @PLACE(57, 17);
//   &TOP @WIRE {%t19 #CL3:2};
//   %t20 = (60, 17);
//   $JUNCTION @ATTACH %t20 => @PLACE(60, 17);
//   &TOP @WIRE {%t20 #CH2:2};
//   %t21 = (63, 17);
//   $JUNCTION @ATTACH %t21 => @PLACE(63, 17);
//   &TOP @WIRE {%t21 #CL2:2};
//   %t22 = (66, 17);
//   $JUNCTION @ATTACH %t22 => @PLACE(66, 17);
//   &TOP @WIRE {%t22 #CH1:2};
//   %t23 = (69, 17);
//   $JUNCTION @ATTACH %t23 => @PLACE(69, 17);
//   &TOP @WIRE {%t23 #CL1:2};
//   %t24 = (72, 17);
//   $JUNCTION @ATTACH %t24 => @PLACE(72, 17);
//   &TOP @WIRE {%t24 #CH0:2};
//   %t25 = (75, 17);
//   $JUNCTION @ATTACH %t25 => @PLACE(75, 17);
//   &TOP @WIRE {%t25 #CL0:2};
//   %tcp = (84, 17);
//   $JUNCTION @ATTACH %tcp => @PLACE(84, 17);
//   %ttop = (88, 17);
//   $JUNCTION @ATTACH %ttop => @PLACE(88, 17);
//   &TOP @WIRE {%t0 %t1 %t2 %t3 %t4 %t5 %t6 %t7 %t8 %t9 %t10 %t11 %t12 %t13 %t14 %t15 %t16 %t17 %t18 %t19 %t20 %t21 %t22 %t23 %t24 %t25 %tcp %ttop #STOP:1};
//   &TOP @WIRE {%tcp #CP:1};
//   %p_top = $IO_PORT @ATTACH &TOP => @PLACE(88, 21) => @ORIENT("R270");
//   &TOP @WIRE {%p_top::pin %ttop};
//   &NK @WIRE {#STOP:2 (104, 17) #IKTC:1};
//   /* --- sampling phase and VCM --- */
//   %phs = (90, 9);
//   $JUNCTION @ATTACH %phs => @PLACE(90, 9);
//   %phc = (90, 7);
//   $JUNCTION @ATTACH %phc => @PLACE(90, 7);
//   %p_phi_s = $IO_PORT @ATTACH &PHI_S => @PLACE(90, 4) => @ORIENT("R90");
//   &PHI_S @WIRE {%p_phi_s::pin %phc %phs (90, 14) #STOP:3};
//   &PHI_S @WIRE {%phs #IKTC:3};
//   &PHI_S @WIRE {%phc (93, 7) #CPHS:1};
//   %p_vcm = $IO_PORT @ATTACH &VCM => @PLACE(104, 2) => @ORIENT("R90");
//   &VCM @WIRE {%p_vcm::pin #IKTC:2};
//   /* --- grounds --- */
//   %g_cp = $GROUND @ATTACH &VSS => @PLACE(84, 9);
//   &VSS @WIRE {#CP:2 %g_cp::pin};
//   %g_sw = $GROUND @ATTACH &VSS => @PLACE(81, -4);
//   &VSS @WIRE {#ISW:VSS %g_sw::pin};
//   %g_st = $GROUND @ATTACH &VSS => @PLACE(98, 14);
//   &VSS @WIRE {#STOP:4 %g_st::pin};
//   %g_ktc = $GROUND @ATTACH &VSS => @PLACE(109, 9);
//   &VSS @WIRE {#IKTC:4 %g_ktc::pin};
//   %g_cphs = $GROUND @ATTACH &VSS => @PLACE(93, -1);
//   &VSS @WIRE {#CPHS:2 %g_cphs::pin};
//   %g_cphsb = $GROUND @ATTACH &VSS => @PLACE(-22, 7);
//   &VSS @WIRE {#CPHSB:2 %g_cphsb::pin};
//   %g_cconv = $GROUND @ATTACH &VSS => @PLACE(-22, -15);
//   &VSS @WIRE {#CCONV:2 %g_cconv::pin};
//   /* --- inputs and references on the left --- */
//   %p_vrefp = $IO_PORT @ATTACH &VREFP => @PLACE(-11, 5) => @ORIENT("R0");
//   &VREFP @WIRE {%p_vrefp::pin #ISW:VREFP};
//   %p_vin = $IO_PORT @ATTACH &VIN => @PLACE(-11, 3) => @ORIENT("R0");
//   &VIN @WIRE {%p_vin::pin #ISW:VIN};
//   %p_vrefn = $IO_PORT @ATTACH &VREFN => @PLACE(-11, 1) => @ORIENT("R0");
//   &VREFN @WIRE {%p_vrefn::pin #ISW:VREFN};
//   %p_vg = $IO_PORT @ATTACH &VG => @PLACE(-11, -2) => @ORIENT("R0");
//   &VG @WIRE {%p_vg::pin #ISW:VG};
//   /* CONV and PHI_SB with their input capacitances; DVDD is not used by the behavioral view */
//   %jconv = (-22, -7);
//   $JUNCTION @ATTACH %jconv => @PLACE(-22, -7);
//   %p_conv = $IO_PORT @ATTACH &CONV => @PLACE(-25, -7) => @ORIENT("R0");
//   &CONV @WIRE {%p_conv::pin %jconv #ISW:CONV};
//   &CONV @WIRE {%jconv #CCONV:1};
//   %p_phi_sb = $IO_PORT @ATTACH &PHI_SB => @PLACE(-25, 15) => @ORIENT("R0");
//   &PHI_SB @WIRE {%p_phi_sb::pin (-22, 15) #CPHSB:1};
//   %p_dvdd = $IO_PORT @ATTACH &DVDD => @PLACE(-11, 17) => @ORIENT("R0");
//   /* --- control buses: each control pin taps the DH or the RL bus below the matrix --- */
//   %dh12 = (0, -13);
//   $JUNCTION @ATTACH %dh12 => @PLACE(0, -13);
//   &DH12 @WIRE {#ISW:DH12 %dh12};
//   %dh11 = (6, -13);
//   $JUNCTION @ATTACH %dh11 => @PLACE(6, -13);
//   &DH11 @WIRE {#ISW:DH11 %dh11};
//   %dh10 = (12, -13);
//   $JUNCTION @ATTACH %dh10 => @PLACE(12, -13);
//   &DH10 @WIRE {#ISW:DH10 %dh10};
//   %dh9 = (18, -13);
//   $JUNCTION @ATTACH %dh9 => @PLACE(18, -13);
//   &DH9 @WIRE {#ISW:DH9 %dh9};
//   %dh8 = (24, -13);
//   $JUNCTION @ATTACH %dh8 => @PLACE(24, -13);
//   &DH8 @WIRE {#ISW:DH8 %dh8};
//   %dh7 = (30, -13);
//   $JUNCTION @ATTACH %dh7 => @PLACE(30, -13);
//   &DH7 @WIRE {#ISW:DH7 %dh7};
//   %dh6 = (36, -13);
//   $JUNCTION @ATTACH %dh6 => @PLACE(36, -13);
//   &DH6 @WIRE {#ISW:DH6 %dh6};
//   %dh5 = (42, -13);
//   $JUNCTION @ATTACH %dh5 => @PLACE(42, -13);
//   &DH5 @WIRE {#ISW:DH5 %dh5};
//   %dh4 = (48, -13);
//   $JUNCTION @ATTACH %dh4 => @PLACE(48, -13);
//   &DH4 @WIRE {#ISW:DH4 %dh4};
//   %dh3 = (54, -13);
//   $JUNCTION @ATTACH %dh3 => @PLACE(54, -13);
//   &DH3 @WIRE {#ISW:DH3 %dh3};
//   %dh2 = (60, -13);
//   $JUNCTION @ATTACH %dh2 => @PLACE(60, -13);
//   &DH2 @WIRE {#ISW:DH2 %dh2};
//   %dh1 = (66, -13);
//   $JUNCTION @ATTACH %dh1 => @PLACE(66, -13);
//   &DH1 @WIRE {#ISW:DH1 %dh1};
//   %dh0 = (72, -13);
//   &DH0 @WIRE {#ISW:DH0 %dh0};
//   %p_dh = {&DH12 &DH11 &DH10 &DH9 &DH8 &DH7 &DH6 &DH5 &DH4 &DH3 &DH2 &DH1 &DH0}(nets) @AS $BUS_PORT => @PLACE(-11, -13) => @ORIENT("R0");
//   %p_dh @TEXT("DH<12:0>", key="name");
//   %bus_dh = {&DH12 &DH11 &DH10 &DH9 &DH8 &DH7 &DH6 &DH5 &DH4 &DH3 &DH2 &DH1 &DH0} @WIRE {%p_dh::pin %dh12 %dh11 %dh10 %dh9 %dh8 %dh7 %dh6 %dh5 %dh4 %dh3 %dh2 %dh1 %dh0};
//   %rl12 = (3, -15);
//   $JUNCTION @ATTACH %rl12 => @PLACE(3, -15);
//   &RL12 @WIRE {#ISW:RL12 %rl12};
//   %rl11 = (9, -15);
//   $JUNCTION @ATTACH %rl11 => @PLACE(9, -15);
//   &RL11 @WIRE {#ISW:RL11 %rl11};
//   %rl10 = (15, -15);
//   $JUNCTION @ATTACH %rl10 => @PLACE(15, -15);
//   &RL10 @WIRE {#ISW:RL10 %rl10};
//   %rl9 = (21, -15);
//   $JUNCTION @ATTACH %rl9 => @PLACE(21, -15);
//   &RL9 @WIRE {#ISW:RL9 %rl9};
//   %rl8 = (27, -15);
//   $JUNCTION @ATTACH %rl8 => @PLACE(27, -15);
//   &RL8 @WIRE {#ISW:RL8 %rl8};
//   %rl7 = (33, -15);
//   $JUNCTION @ATTACH %rl7 => @PLACE(33, -15);
//   &RL7 @WIRE {#ISW:RL7 %rl7};
//   %rl6 = (39, -15);
//   $JUNCTION @ATTACH %rl6 => @PLACE(39, -15);
//   &RL6 @WIRE {#ISW:RL6 %rl6};
//   %rl5 = (45, -15);
//   $JUNCTION @ATTACH %rl5 => @PLACE(45, -15);
//   &RL5 @WIRE {#ISW:RL5 %rl5};
//   %rl4 = (51, -15);
//   $JUNCTION @ATTACH %rl4 => @PLACE(51, -15);
//   &RL4 @WIRE {#ISW:RL4 %rl4};
//   %rl3 = (57, -15);
//   $JUNCTION @ATTACH %rl3 => @PLACE(57, -15);
//   &RL3 @WIRE {#ISW:RL3 %rl3};
//   %rl2 = (63, -15);
//   $JUNCTION @ATTACH %rl2 => @PLACE(63, -15);
//   &RL2 @WIRE {#ISW:RL2 %rl2};
//   %rl1 = (69, -15);
//   $JUNCTION @ATTACH %rl1 => @PLACE(69, -15);
//   &RL1 @WIRE {#ISW:RL1 %rl1};
//   %rl0 = (75, -15);
//   &RL0 @WIRE {#ISW:RL0 %rl0};
//   %p_rl = {&RL12 &RL11 &RL10 &RL9 &RL8 &RL7 &RL6 &RL5 &RL4 &RL3 &RL2 &RL1 &RL0}(nets) @AS $BUS_PORT => @PLACE(-11, -15) => @ORIENT("R0");
//   %p_rl @TEXT("RL<12:0>", key="name");
//   %bus_rl = {&RL12 &RL11 &RL10 &RL9 &RL8 &RL7 &RL6 &RL5 &RL4 &RL3 &RL2 &RL1 &RL0} @WIRE {%p_rl::pin %rl12 %rl11 %rl10 %rl9 %rl8 %rl7 %rl6 %rl5 %rl4 %rl3 %rl2 %rl1 %rl0};
//   /* --- annotations: half names beside each capacitor, the weight above each pair --- */
//   #CH12 @TEXT("", key="value");
//   #CH12 @TEXT("${name}", key="name", size=0.5, rotate=90, halign="middle") => @PLACE(1.3, 13);
//   #CL12 @TEXT("", key="value");
//   #CL12 @TEXT("${name}", key="name", size=0.5, rotate=90, halign="middle") => @PLACE(4.3, 13);
//   #CH11 @TEXT("", key="value");
//   #CH11 @TEXT("${name}", key="name", size=0.5, rotate=90, halign="middle") => @PLACE(7.3, 13);
//   #CL11 @TEXT("", key="value");
//   #CL11 @TEXT("${name}", key="name", size=0.5, rotate=90, halign="middle") => @PLACE(10.3, 13);
//   #CH10 @TEXT("", key="value");
//   #CH10 @TEXT("${name}", key="name", size=0.5, rotate=90, halign="middle") => @PLACE(13.3, 13);
//   #CL10 @TEXT("", key="value");
//   #CL10 @TEXT("${name}", key="name", size=0.5, rotate=90, halign="middle") => @PLACE(16.3, 13);
//   #CH9 @TEXT("", key="value");
//   #CH9 @TEXT("${name}", key="name", size=0.5, rotate=90, halign="middle") => @PLACE(19.3, 13);
//   #CL9 @TEXT("", key="value");
//   #CL9 @TEXT("${name}", key="name", size=0.5, rotate=90, halign="middle") => @PLACE(22.3, 13);
//   #CH8 @TEXT("", key="value");
//   #CH8 @TEXT("${name}", key="name", size=0.5, rotate=90, halign="middle") => @PLACE(25.3, 13);
//   #CL8 @TEXT("", key="value");
//   #CL8 @TEXT("${name}", key="name", size=0.5, rotate=90, halign="middle") => @PLACE(28.3, 13);
//   #CH7 @TEXT("", key="value");
//   #CH7 @TEXT("${name}", key="name", size=0.5, rotate=90, halign="middle") => @PLACE(31.3, 13);
//   #CL7 @TEXT("", key="value");
//   #CL7 @TEXT("${name}", key="name", size=0.5, rotate=90, halign="middle") => @PLACE(34.3, 13);
//   #CH6 @TEXT("", key="value");
//   #CH6 @TEXT("${name}", key="name", size=0.5, rotate=90, halign="middle") => @PLACE(37.3, 13);
//   #CL6 @TEXT("", key="value");
//   #CL6 @TEXT("${name}", key="name", size=0.5, rotate=90, halign="middle") => @PLACE(40.3, 13);
//   #CH5 @TEXT("", key="value");
//   #CH5 @TEXT("${name}", key="name", size=0.5, rotate=90, halign="middle") => @PLACE(43.3, 13);
//   #CL5 @TEXT("", key="value");
//   #CL5 @TEXT("${name}", key="name", size=0.5, rotate=90, halign="middle") => @PLACE(46.3, 13);
//   #CH4 @TEXT("", key="value");
//   #CH4 @TEXT("${name}", key="name", size=0.5, rotate=90, halign="middle") => @PLACE(49.3, 13);
//   #CL4 @TEXT("", key="value");
//   #CL4 @TEXT("${name}", key="name", size=0.5, rotate=90, halign="middle") => @PLACE(52.3, 13);
//   #CH3 @TEXT("", key="value");
//   #CH3 @TEXT("${name}", key="name", size=0.5, rotate=90, halign="middle") => @PLACE(55.3, 13);
//   #CL3 @TEXT("", key="value");
//   #CL3 @TEXT("${name}", key="name", size=0.5, rotate=90, halign="middle") => @PLACE(58.3, 13);
//   #CH2 @TEXT("", key="value");
//   #CH2 @TEXT("${name}", key="name", size=0.5, rotate=90, halign="middle") => @PLACE(61.3, 13);
//   #CL2 @TEXT("", key="value");
//   #CL2 @TEXT("${name}", key="name", size=0.5, rotate=90, halign="middle") => @PLACE(64.3, 13);
//   #CH1 @TEXT("", key="value");
//   #CH1 @TEXT("${name}", key="name", size=0.5, rotate=90, halign="middle") => @PLACE(67.3, 13);
//   #CL1 @TEXT("", key="value");
//   #CL1 @TEXT("${name}", key="name", size=0.5, rotate=90, halign="middle") => @PLACE(70.3, 13);
//   #CH0 @TEXT("", key="value");
//   #CH0 @TEXT("${name}", key="name", size=0.5, rotate=90, halign="middle") => @PLACE(73.3, 13);
//   #CL0 @TEXT("", key="value");
//   #CL0 @TEXT("${name}", key="name", size=0.5, rotate=90, halign="middle") => @PLACE(76.3, 13);
//   (1.5, 17.4) @TEXT("980", size=0.6, halign="middle");
//   (7.5, 17.4) @TEXT("560", size=0.6, halign="middle");
//   (13.5, 17.4) @TEXT("318", size=0.6, halign="middle");
//   (19.5, 17.4) @TEXT("180*", size=0.6, halign="middle");
//   (25.5, 17.4) @TEXT("102", size=0.6, halign="middle");
//   (31.5, 17.4) @TEXT("57", size=0.6, halign="middle");
//   (37.5, 17.4) @TEXT("32*", size=0.6, halign="middle");
//   (43.5, 17.4) @TEXT("18", size=0.6, halign="middle");
//   (49.5, 17.4) @TEXT("10", size=0.6, halign="middle");
//   (55.5, 17.4) @TEXT("6", size=0.6, halign="middle");
//   (61.5, 17.4) @TEXT("3", size=0.6, halign="middle");
//   (67.5, 17.4) @TEXT("2", size=0.6, halign="middle");
//   (73.5, 17.4) @TEXT("1", size=0.6, halign="middle");
//   (-29, -20.5) @TEXT("adc_cdac ports", halign="start", bold=true) => @SET-STYLE $note_style;
//   @RECTANGLE {(-29, -21) (10.728, -37.17)} => @SET-STYLE $table_style;
//   @LINE {(-29, -22.155) (10.728, -22.155)} => @SET-STYLE $table_style;
//   @LINE {(-25.448, -21) (-25.448, -37.17)} => @SET-STYLE $table_style;
//   @LINE {(-21.577, -21) (-21.577, -37.17)} => @SET-STYLE $table_style;
//   @LINE {(-18.344, -21) (-18.344, -37.17)} => @SET-STYLE $table_style;
//   (-28.5, -21.5775) @TEXT("pin", halign="start", valign="middle", size=0.55, bold=true) => @SET-STYLE $table_style;
//   (-24.948, -21.5775) @TEXT("direction", halign="start", valign="middle", size=0.55, bold=true) => @SET-STYLE $table_style;
//   (-21.077, -21.5775) @TEXT("type", halign="start", valign="middle", size=0.55, bold=true) => @SET-STYLE $table_style;
//   (-17.844, -21.5775) @TEXT("description", halign="start", valign="middle", size=0.55, bold=true) => @SET-STYLE $table_style;
//   (-28.5, -22.7325) @TEXT("VIN", halign="start", valign="middle", size=0.55) => @SET-STYLE $table_style;
//   (-24.948, -22.7325) @TEXT("input", halign="start", valign="middle", size=0.55) => @SET-STYLE $table_style;
//   (-21.077, -22.7325) @TEXT("analog", halign="start", valign="middle", size=0.55) => @SET-STYLE $table_style;
//   (-17.844, -22.7325) @TEXT("input (after the 50 ohm source)", halign="start", valign="middle", size=0.55) => @SET-STYLE $table_style;
//   (-28.5, -23.8875) @TEXT("VG", halign="start", valign="middle", size=0.55) => @SET-STYLE $table_style;
//   (-24.948, -23.8875) @TEXT("input", halign="start", valign="middle", size=0.55) => @SET-STYLE $table_style;
//   (-21.077, -23.8875) @TEXT("analog", halign="start", valign="middle", size=0.55) => @SET-STYLE $table_style;
//   (-17.844, -23.8875) @TEXT("bootstrapped gate of the input switches (VIN + ~AVDD while tracking, 0 while converting)", halign="start", valign="middle", size=0.55) => @SET-STYLE $table_style;
//   (-28.5, -25.0425) @TEXT("TOP", halign="start", valign="middle", size=0.55) => @SET-STYLE $table_style;
//   (-24.948, -25.0425) @TEXT("output", halign="start", valign="middle", size=0.55) => @SET-STYLE $table_style;
//   (-21.077, -25.0425) @TEXT("analog", halign="start", valign="middle", size=0.55) => @SET-STYLE $table_style;
//   (-17.844, -25.0425) @TEXT("top plate, to the comparator", halign="start", valign="middle", size=0.55) => @SET-STYLE $table_style;
//   (-28.5, -26.1975) @TEXT("VCM", halign="start", valign="middle", size=0.55) => @SET-STYLE $table_style;
//   (-24.948, -26.1975) @TEXT("input", halign="start", valign="middle", size=0.55) => @SET-STYLE $table_style;
//   (-21.077, -26.1975) @TEXT("analog", halign="start", valign="middle", size=0.55) => @SET-STYLE $table_style;
//   (-17.844, -26.1975) @TEXT("0.45 V top-plate reset level", halign="start", valign="middle", size=0.55) => @SET-STYLE $table_style;
//   (-28.5, -27.3525) @TEXT("VREFP", halign="start", valign="middle", size=0.55) => @SET-STYLE $table_style;
//   (-24.948, -27.3525) @TEXT("input", halign="start", valign="middle", size=0.55) => @SET-STYLE $table_style;
//   (-21.077, -27.3525) @TEXT("analog", halign="start", valign="middle", size=0.55) => @SET-STYLE $table_style;
//   (-17.844, -27.3525) @TEXT("0.9 V reference", halign="start", valign="middle", size=0.55) => @SET-STYLE $table_style;
//   (-28.5, -28.5075) @TEXT("VREFN", halign="start", valign="middle", size=0.55) => @SET-STYLE $table_style;
//   (-24.948, -28.5075) @TEXT("input", halign="start", valign="middle", size=0.55) => @SET-STYLE $table_style;
//   (-21.077, -28.5075) @TEXT("analog", halign="start", valign="middle", size=0.55) => @SET-STYLE $table_style;
//   (-17.844, -28.5075) @TEXT("reference ground", halign="start", valign="middle", size=0.55) => @SET-STYLE $table_style;
//   (-28.5, -29.6625) @TEXT("PHI_S", halign="start", valign="middle", size=0.55) => @SET-STYLE $table_style;
//   (-24.948, -29.6625) @TEXT("input", halign="start", valign="middle", size=0.55) => @SET-STYLE $table_style;
//   (-21.077, -29.6625) @TEXT("clock", halign="start", valign="middle", size=0.55) => @SET-STYLE $table_style;
//   (-17.844, -29.6625) @TEXT("top-plate switch, high = track (opens first: sampling instant)", halign="start", valign="middle", size=0.55) => @SET-STYLE $table_style;
//   (-28.5, -30.8175) @TEXT("PHI_SB", halign="start", valign="middle", size=0.55) => @SET-STYLE $table_style;
//   (-24.948, -30.8175) @TEXT("input", halign="start", valign="middle", size=0.55) => @SET-STYLE $table_style;
//   (-21.077, -30.8175) @TEXT("clock", halign="start", valign="middle", size=0.55) => @SET-STYLE $table_style;
//   (-17.844, -30.8175) @TEXT("complement of PHI_S", halign="start", valign="middle", size=0.55) => @SET-STYLE $table_style;
//   (-28.5, -31.9725) @TEXT("CONV", halign="start", valign="middle", size=0.55) => @SET-STYLE $table_style;
//   (-24.948, -31.9725) @TEXT("input", halign="start", valign="middle", size=0.55) => @SET-STYLE $table_style;
//   (-21.077, -31.9725) @TEXT("clock", halign="start", valign="middle", size=0.55) => @SET-STYLE $table_style;
//   (-17.844, -31.9725) @TEXT("high = drivers enabled (convert); low = sampled halves tri-stated", halign="start", valign="middle", size=0.55) => @SET-STYLE $table_style;
//   (-28.5, -33.1275) @TEXT("DH<12:0>", halign="start", valign="middle", size=0.55) => @SET-STYLE $table_style;
//   (-24.948, -33.1275) @TEXT("input", halign="start", valign="middle", size=0.55) => @SET-STYLE $table_style;
//   (-21.077, -33.1275) @TEXT("digital", halign="start", valign="middle", size=0.55) => @SET-STYLE $table_style;
//   (-17.844, -33.1275) @TEXT("drop H half of weight j=12 to VREFN", halign="start", valign="middle", size=0.55) => @SET-STYLE $table_style;
//   (-28.5, -34.2825) @TEXT("RL<12:0>", halign="start", valign="middle", size=0.55) => @SET-STYLE $table_style;
//   (-24.948, -34.2825) @TEXT("input", halign="start", valign="middle", size=0.55) => @SET-STYLE $table_style;
//   (-21.077, -34.2825) @TEXT("digital", halign="start", valign="middle", size=0.55) => @SET-STYLE $table_style;
//   (-17.844, -34.2825) @TEXT("raise L half of weight j=12 to VREFP", halign="start", valign="middle", size=0.55) => @SET-STYLE $table_style;
//   (-28.5, -35.4375) @TEXT("DVDD", halign="start", valign="middle", size=0.55) => @SET-STYLE $table_style;
//   (-24.948, -35.4375) @TEXT("inout", halign="start", valign="middle", size=0.55) => @SET-STYLE $table_style;
//   (-21.077, -35.4375) @TEXT("supply", halign="start", valign="middle", size=0.55) => @SET-STYLE $table_style;
//   (-17.844, -35.4375) @TEXT("0.9 V supply of the driver pre-logic", halign="start", valign="middle", size=0.55) => @SET-STYLE $table_style;
//   (-28.5, -36.5925) @TEXT("VSS", halign="start", valign="middle", size=0.55) => @SET-STYLE $table_style;
//   (-24.948, -36.5925) @TEXT("inout", halign="start", valign="middle", size=0.55) => @SET-STYLE $table_style;
//   (-21.077, -36.5925) @TEXT("ground", halign="start", valign="middle", size=0.55) => @SET-STYLE $table_style;
//   (-17.844, -36.5925) @TEXT("ground", halign="start", valign="middle", size=0.55) => @SET-STYLE $table_style;
//   (-29, 26) @TEXT("adc_cdac (behavioral): 13 weights x 2 halves, cu = 1 fF, C_S = 2.0570 pF, C_DAC = 2.2690 pF", halign="start") => @SET-STYLE $title_style;
//   (-29, 24.3) @TEXT("numbers above the array: the weight of each H/L pair, each half is w*cu/2; * = not sampled (range extension). H halves: neutral VREFP, dropped by DH; L halves: neutral VREFN, raised by RL", halign="start") => @SET-STYLE $note_style;
//   (-29, 22.8) @TEXT("CPHS, CPHSB and CCONV model the clock input capacitances; every DH / RL control input loads cin_ctrl inside adc_cdac_sw_va", halign="start") => @SET-STYLE $note_style
// }
// @RNL(author="adcflow gen") {
//   /* block symbol of adc_cdac, generated from tools/adcflow/symbols.py by `python -m adcflow gen` -- do not edit this record */
//   %adc_cdac = @DEFINE-SYMBOL(box=[-11, -8, 11, 8]) {
//     @LINE(linewidth=0.24) {(-10, -6) (10, -6) (10, 7) (-10, 7) (-10, -6)};
//     (-11, 4) @PIN(terminal=1, direction="left");
//     @LINE {(-11, 4) (-10, 4)};
//     (-9.65, 4) @TEXT("VIN", size=0.55, halign="start", valign="middle");
//     (-11, 2) @PIN(terminal=7, direction="left");
//     @LINE {(-11, 2) (-10, 2)};
//     (-9.65, 2) @TEXT("PHI_S", size=0.55, halign="start", valign="middle");
//     (-11, 0) @PIN(terminal=8, direction="left");
//     @LINE {(-11, 0) (-10, 0)};
//     (-9.65, 0) @TEXT("PHI_SB", size=0.55, halign="start", valign="middle");
//     (-11, -2) @PIN(terminal=9, direction="left");
//     @LINE {(-11, -2) (-10, -2)};
//     (-9.65, -2) @TEXT("CONV", size=0.55, halign="start", valign="middle");
//     (-11, -4) @PIN(terminal=2, direction="left");
//     @LINE {(-11, -4) (-10, -4)};
//     (-9.65, -4) @TEXT("VG", size=0.55, halign="start", valign="middle");
//     (11, 5) @PIN(terminal=3, direction="right");
//     @LINE {(11, 5) (10, 5)};
//     (9.65, 5.25) @TEXT("TOP", size=0.55, halign="end", valign="bottom");
//     (11, 0) @PIN(terminal=36, direction="right");
//     @LINE {(11, 0) (10, 0)};
//     (9.65, 0) @TEXT("DVDD", size=0.55, halign="end", valign="middle");
//     (11, -4) @PIN(terminal=37, direction="right");
//     @LINE {(11, -4) (10, -4)};
//     (9.65, -4) @TEXT("VSS", size=0.55, halign="end", valign="middle");
//     (-5, 8) @PIN(terminal=4, direction="up");
//     @LINE {(-5, 8) (-5, 7)};
//     (-5, 6.65) @TEXT("VCM", size=0.55, halign="middle", valign="top");
//     (-1, 8) @PIN(terminal=5, direction="up");
//     @LINE {(-1, 8) (-1, 7)};
//     (-1, 6.65) @TEXT("VREFP", size=0.55, halign="middle", valign="top");
//     (3, 8) @PIN(terminal=6, direction="up");
//     @LINE {(3, 8) (3, 7)};
//     (3, 6.65) @TEXT("VREFN", size=0.55, halign="middle", valign="top");
//     (-4, -8) @PIN(terminal=[10, 11, 12, 13, 14, 15, 16, 17, 18, 19, 20, 21, 22], direction="down");
//     @LINE(linewidth=0.32) {(-4, -8) (-4, -6)};
//     @LINE {(-4.35, -7.25) (-3.65, -6.75)};
//     (-3.5, -7) @TEXT("13", size=0.45, valign="middle");
//     (-4.35, -5.1) @TEXT("DH<12:0>", size=0.55, halign="end", valign="middle");
//     (2, -8) @PIN(terminal=[23, 24, 25, 26, 27, 28, 29, 30, 31, 32, 33, 34, 35], direction="down");
//     @LINE(linewidth=0.32) {(2, -8) (2, -6)};
//     @LINE {(1.65, -7.25) (2.35, -6.75)};
//     (2.5, -7) @TEXT("13", size=0.45, valign="middle");
//     (2.35, -5.1) @TEXT("RL<12:0>", size=0.55, halign="start", valign="middle");
//     @LINE(linewidth=0.24) {(-7, 5) (10, 5)};
//     (-6, 5) @CIRCLE(radius=0.16, fill="linecolor", linestyle="none");
//     @LINE {(-6, 5) (-6, 3.9)};
//     @LINE(linewidth=0.24) {(-7, 3.9) (-5, 3.9)};
//     @LINE(linewidth=0.24) {(-7, 3.35) (-5, 3.35)};
//     @LINE {(-6, 3.35) (-6, 2.4)};
//     (-6, 2.25) @CIRCLE(radius=0.15);
//     @LINE {(-6.07, 2.11) (-6.5, 1.13)};
//     (-6.6, 1) @CIRCLE(radius=0.11);
//     (-6, 1) @CIRCLE(radius=0.11);
//     (-5.4, 1) @CIRCLE(radius=0.11);
//     (-3.5, 5) @CIRCLE(radius=0.16, fill="linecolor", linestyle="none");
//     @LINE {(-3.5, 5) (-3.5, 3.9)};
//     @LINE(linewidth=0.24) {(-4.3, 3.9) (-2.7, 3.9)};
//     @LINE(linewidth=0.24) {(-4.3, 3.35) (-2.7, 3.35)};
//     @LINE {(-3.5, 3.35) (-3.5, 2.4)};
//     (-3.5, 2.25) @CIRCLE(radius=0.15);
//     @LINE {(-3.57, 2.11) (-4, 1.13)};
//     (-4.1, 1) @CIRCLE(radius=0.11);
//     (-3.5, 1) @CIRCLE(radius=0.11);
//     (-2.9, 1) @CIRCLE(radius=0.11);
//     (-1, 5) @CIRCLE(radius=0.16, fill="linecolor", linestyle="none");
//     @LINE {(-1, 5) (-1, 3.9)};
//     @LINE(linewidth=0.24) {(-1.6, 3.9) (-0.4, 3.9)};
//     @LINE(linewidth=0.24) {(-1.6, 3.35) (-0.4, 3.35)};
//     @LINE {(-1, 3.35) (-1, 2.4)};
//     (-1, 2.25) @CIRCLE(radius=0.15);
//     @LINE {(-1.07, 2.11) (-1.5, 1.13)};
//     (-1.6, 1) @CIRCLE(radius=0.11);
//     (-1, 1) @CIRCLE(radius=0.11);
//     (-0.4, 1) @CIRCLE(radius=0.11);
//     (1.5, 5) @CIRCLE(radius=0.16, fill="linecolor", linestyle="none");
//     @LINE {(1.5, 5) (1.5, 3.9)};
//     @LINE(linewidth=0.24) {(1.05, 3.9) (1.95, 3.9)};
//     @LINE(linewidth=0.24) {(1.05, 3.35) (1.95, 3.35)};
//     @LINE {(1.5, 3.35) (1.5, 2.4)};
//     (1.5, 2.25) @CIRCLE(radius=0.15);
//     @LINE {(1.43, 2.11) (1, 1.13)};
//     (0.9, 1) @CIRCLE(radius=0.11);
//     (1.5, 1) @CIRCLE(radius=0.11);
//     (2.1, 1) @CIRCLE(radius=0.11);
//     (4, 5) @CIRCLE(radius=0.16, fill="linecolor", linestyle="none");
//     @LINE {(4, 5) (4, 3.9)};
//     @LINE(linewidth=0.24) {(3.7, 3.9) (4.3, 3.9)};
//     @LINE(linewidth=0.24) {(3.7, 3.35) (4.3, 3.35)};
//     @LINE {(4, 3.35) (4, 2.4)};
//     (4, 2.25) @CIRCLE(radius=0.15);
//     @LINE {(3.93, 2.11) (3.5, 1.13)};
//     (3.4, 1) @CIRCLE(radius=0.11);
//     (4, 1) @CIRCLE(radius=0.11);
//     (4.6, 1) @CIRCLE(radius=0.11);
//     (-6, 0.6) @TEXT("V_{RP} V_{IN} V_{RN}", size=0.4, halign="middle", valign="top");
//     (7.5, 3.3) @TEXT("CDAC", size=1, bold=true, halign="middle", valign="middle");
//     (7.5, 2.2) @TEXT("13 \times{} 2 halves", size=0.45, halign="middle", valign="middle");
//     @LINE {(-7, -4.2) (5, -4.2) (5, -2.6) (-7, -2.6) (-7, -4.2)};
//     (-1, -3.4) @TEXT("drivers: DH drops an H half, RL raises an L half", size=0.45, halign="middle", valign="middle");
//     @LINE(linewidth=0.32) {(-4, -4.2) (-4, -6)};
//     @LINE(linewidth=0.32) {(2, -4.2) (2, -6)};
//     ? @TEXT("${name}", key="name", size=0.8, valign="bottom") => @PLACE(-10, 7.5);
//     ? @TEXT("${model}", key="model", size=0.5, valign="top") => @PLACE(-10, -6.5)
//   };
//   # @SET-SYMBOL %adc_cdac
// }
ends adc_cdac
