// adc_clkgen, behavioral view: sampling phase generator
// @RNL(type="header") {
//   @VERSION("0.3");
//   @USE-PACKAGE(name="adc28", version="0.1", path="../rnl/adc28.rnl")
// }
simulator lang=spectre

subckt adc_clkgen (CLK PHI_S PHI_SB PHI_B PHI_BB CONV AVDD VSS)
// Behavioral view. Uses the deck globals noise_en and beh_speed.
parameters td_s=40p dt_b=40p dt_conv=30p td_r=40p dt_rise=30p jitter=50f iavg=70u
I0 (CLK PHI_S PHI_SB PHI_B PHI_BB CONV AVDD VSS) adc_clkgen_va \
        td_s=td_s*beh_speed dt_b=dt_b*beh_speed dt_conv=dt_conv*beh_speed td_r=td_r*beh_speed \
        dt_rise=dt_rise*beh_speed jitter=jitter*noise_en iavg=iavg
// @RNL {
//   /* --- semantics --- */
//   &AVDD @ADD-TO $SUPPLY_NET_SET;
//   &VSS @ADD-TO $GROUND_NET_SET;
//   /* --- placement and wires --- */
//   #I0 @PLACE(0, 0);
//   %p_clk = $IO_PORT @ATTACH &CLK => @PLACE(-10, 0) => @ORIENT("R0");
//   &CLK @WIRE {%p_clk:p #I0:CLK};
//   %p_phi_s = $IO_PORT @ATTACH &PHI_S => @PLACE(10, 4) => @ORIENT("MY");
//   &PHI_S @WIRE {#I0:PHI_S %p_phi_s:p};
//   %p_phi_sb = $IO_PORT @ATTACH &PHI_SB => @PLACE(10, 2) => @ORIENT("MY");
//   &PHI_SB @WIRE {#I0:PHI_SB %p_phi_sb:p};
//   %p_phi_b = $IO_PORT @ATTACH &PHI_B => @PLACE(10, 0) => @ORIENT("MY");
//   &PHI_B @WIRE {#I0:PHI_B %p_phi_b:p};
//   %p_phi_bb = $IO_PORT @ATTACH &PHI_BB => @PLACE(10, -2) => @ORIENT("MY");
//   &PHI_BB @WIRE {#I0:PHI_BB %p_phi_bb:p};
//   %p_conv = $IO_PORT @ATTACH &CONV => @PLACE(10, -4) => @ORIENT("MY");
//   &CONV @WIRE {#I0:CONV %p_conv:p};
//   %s1 = $SUPPLY @ATTACH &AVDD => @PLACE(0, 9);
//   &AVDD @WIRE {#I0:AVDD %s1:p};
//   %g1 = $GROUND @ATTACH &VSS => @PLACE(0, -9);
//   &VSS @WIRE {#I0:VSS %g1:p};
//   /* --- annotations --- */
//   (-12, 15.5) @TEXT("adc_clkgen (behavioral): CLK fall -> PHI_S fall -> PHI_B fall -> CONV rise", halign="start") => @SET-STYLE $title_style;
//   (-12, 14) @TEXT("CLK rise -> CONV fall -> PHI_B, PHI_S rise (break before make); delays scaled by beh_speed", halign="start") => @SET-STYLE $note_style;
//   (15, 10.5) @TEXT("adc_clkgen ports", halign="start", bold=true) => @SET-STYLE $note_style;
//   @RECTANGLE {(15, 10) (44.201, -0.395)} => @SET-STYLE $table_style;
//   @LINE {(15, 8.845) (44.201, 8.845)} => @SET-STYLE $table_style;
//   @LINE {(17.914, 10) (17.914, -0.395)} => @SET-STYLE $table_style;
//   @LINE {(21.785, 10) (21.785, -0.395)} => @SET-STYLE $table_style;
//   @LINE {(24.699, 10) (24.699, -0.395)} => @SET-STYLE $table_style;
//   (15.5, 9.4225) @TEXT("pin", halign="start", valign="middle", size=0.55, bold=true) => @SET-STYLE $table_style;
//   (18.414, 9.4225) @TEXT("direction", halign="start", valign="middle", size=0.55, bold=true) => @SET-STYLE $table_style;
//   (22.285, 9.4225) @TEXT("type", halign="start", valign="middle", size=0.55, bold=true) => @SET-STYLE $table_style;
//   (25.199, 9.4225) @TEXT("description", halign="start", valign="middle", size=0.55, bold=true) => @SET-STYLE $table_style;
//   (15.5, 8.2675) @TEXT("CLK", halign="start", valign="middle", size=0.55) => @SET-STYLE $table_style;
//   (18.414, 8.2675) @TEXT("input", halign="start", valign="middle", size=0.55) => @SET-STYLE $table_style;
//   (22.285, 8.2675) @TEXT("clock", halign="start", valign="middle", size=0.55) => @SET-STYLE $table_style;
//   (25.199, 8.2675) @TEXT("external sampling clock, 0.9 V CMOS, 100 MHz, duty 45-55 %", halign="start", valign="middle", size=0.55) => @SET-STYLE $table_style;
//   (15.5, 7.1125) @TEXT("PHI_S", halign="start", valign="middle", size=0.55) => @SET-STYLE $table_style;
//   (18.414, 7.1125) @TEXT("output", halign="start", valign="middle", size=0.55) => @SET-STYLE $table_style;
//   (22.285, 7.1125) @TEXT("clock", halign="start", valign="middle", size=0.55) => @SET-STYLE $table_style;
//   (25.199, 7.1125) @TEXT("top-plate sampling phase", halign="start", valign="middle", size=0.55) => @SET-STYLE $table_style;
//   (15.5, 5.9575) @TEXT("PHI_SB", halign="start", valign="middle", size=0.55) => @SET-STYLE $table_style;
//   (18.414, 5.9575) @TEXT("output", halign="start", valign="middle", size=0.55) => @SET-STYLE $table_style;
//   (22.285, 5.9575) @TEXT("clock", halign="start", valign="middle", size=0.55) => @SET-STYLE $table_style;
//   (25.199, 5.9575) @TEXT("complement of PHI_S", halign="start", valign="middle", size=0.55) => @SET-STYLE $table_style;
//   (15.5, 4.8025) @TEXT("PHI_B", halign="start", valign="middle", size=0.55) => @SET-STYLE $table_style;
//   (18.414, 4.8025) @TEXT("output", halign="start", valign="middle", size=0.55) => @SET-STYLE $table_style;
//   (22.285, 4.8025) @TEXT("clock", halign="start", valign="middle", size=0.55) => @SET-STYLE $table_style;
//   (25.199, 4.8025) @TEXT("bottom-plate (bootstrap) phase", halign="start", valign="middle", size=0.55) => @SET-STYLE $table_style;
//   (15.5, 3.6475) @TEXT("PHI_BB", halign="start", valign="middle", size=0.55) => @SET-STYLE $table_style;
//   (18.414, 3.6475) @TEXT("output", halign="start", valign="middle", size=0.55) => @SET-STYLE $table_style;
//   (22.285, 3.6475) @TEXT("clock", halign="start", valign="middle", size=0.55) => @SET-STYLE $table_style;
//   (25.199, 3.6475) @TEXT("complement of PHI_B", halign="start", valign="middle", size=0.55) => @SET-STYLE $table_style;
//   (15.5, 2.4925) @TEXT("CONV", halign="start", valign="middle", size=0.55) => @SET-STYLE $table_style;
//   (18.414, 2.4925) @TEXT("output", halign="start", valign="middle", size=0.55) => @SET-STYLE $table_style;
//   (22.285, 2.4925) @TEXT("clock", halign="start", valign="middle", size=0.55) => @SET-STYLE $table_style;
//   (25.199, 2.4925) @TEXT("conversion window", halign="start", valign="middle", size=0.55) => @SET-STYLE $table_style;
//   (15.5, 1.3375) @TEXT("AVDD", halign="start", valign="middle", size=0.55) => @SET-STYLE $table_style;
//   (18.414, 1.3375) @TEXT("inout", halign="start", valign="middle", size=0.55) => @SET-STYLE $table_style;
//   (22.285, 1.3375) @TEXT("supply", halign="start", valign="middle", size=0.55) => @SET-STYLE $table_style;
//   (25.199, 1.3375) @TEXT("0.9 V", halign="start", valign="middle", size=0.55) => @SET-STYLE $table_style;
//   (15.5, 0.1825) @TEXT("VSS", halign="start", valign="middle", size=0.55) => @SET-STYLE $table_style;
//   (18.414, 0.1825) @TEXT("inout", halign="start", valign="middle", size=0.55) => @SET-STYLE $table_style;
//   (22.285, 0.1825) @TEXT("ground", halign="start", valign="middle", size=0.55) => @SET-STYLE $table_style;
//   (25.199, 0.1825) @TEXT("ground", halign="start", valign="middle", size=0.55) => @SET-STYLE $table_style
// }
// @RNL(author="adcflow gen") {
//   /* block symbol of adc_clkgen, generated from tools/adcflow/symbols.py by `python -m adcflow gen` -- do not edit this record */
//   %adc_clkgen = @DEFINE-SYMBOL(box=[-6, -7, 6, 7]) {
//     @LINE(linewidth=0.24) {(-5, -6) (5, -6) (5, 6) (-5, 6) (-5, -6)};
//     (-6, 0) @PIN(terminal=1, direction="left");
//     @LINE {(-6, 0) (-5, 0)};
//     (-4.65, -0.75) @TEXT("CLK", size=0.55, halign="start", valign="top");
//     @LINE {(-4.6, -0.3) (-4.1, -0.3) (-4.1, 0.4) (-3.4, 0.4) (-3.4, -0.3) (-2.7, -0.3) (-2.7, 0.4) (-2, 0.4) (-2, -0.3) (-1.5, -0.3)};
//     (-3.2, 3.3) @TEXT("\Phi", size=1.8, bold=true, halign="middle", valign="middle");
//     (6, 4) @PIN(terminal=2, direction="right");
//     @LINE {(6, 4) (5, 4)};
//     (4.65, 4) @TEXT("PHI_S", size=0.55, halign="end", valign="middle");
//     @LINE {(-0.9, 4.3) (-0, 4.3) (-0, 3.7) (1.7, 3.7)};
//     (6, 2) @PIN(terminal=3, direction="right");
//     @LINE {(6, 2) (5, 2)};
//     (4.65, 2) @TEXT("PHI_SB", size=0.55, halign="end", valign="middle");
//     @LINE {(-0.9, 1.7) (-0, 1.7) (-0, 2.3) (1.7, 2.3)};
//     (6, 0) @PIN(terminal=4, direction="right");
//     @LINE {(6, 0) (5, 0)};
//     (4.65, 0) @TEXT("PHI_B", size=0.55, halign="end", valign="middle");
//     @LINE {(-0.9, 0.3) (0.45, 0.3) (0.45, -0.3) (1.7, -0.3)};
//     (6, -2) @PIN(terminal=5, direction="right");
//     @LINE {(6, -2) (5, -2)};
//     (4.65, -2) @TEXT("PHI_BB", size=0.55, halign="end", valign="middle");
//     @LINE {(-0.9, -2.3) (0.45, -2.3) (0.45, -1.7) (1.7, -1.7)};
//     (6, -4) @PIN(terminal=6, direction="right");
//     @LINE {(6, -4) (5, -4)};
//     (4.65, -4) @TEXT("CONV", size=0.55, halign="end", valign="middle");
//     @LINE {(-0.9, -4.3) (0.9, -4.3) (0.9, -3.7) (1.7, -3.7)};
//     (0, 7) @PIN(terminal=7, direction="up");
//     @LINE {(0, 7) (0, 6)};
//     (0, -7) @PIN(terminal=8, direction="down");
//     @LINE {(0, -7) (0, -6)};
//     ? @TEXT("${name}", key="name", size=0.8, valign="bottom") => @PLACE(-5, 6.5);
//     ? @TEXT("${model}", key="model", size=0.5, valign="bottom") => @PLACE(-4.65, -5.65)
//   };
//   # @SET-SYMBOL %adc_clkgen
// }
ends adc_clkgen
