// Split-stage comparator A6: physical integrator, independent latch and physical clock.
// @RNL(type="header") {
// @VERSION("0.3");
// @USE-PACKAGE(name="adc28", version="0.1", path="../../../rnl/adc28.rnl")
// }
simulator lang=spectre
subckt adc_comp (INP INN CLKC OUTP OUTN AVDD VSS)
// All geometry comes from successful device callbacks. No ideal timing or bias elements.
MINP (DP INP FT VSS) nch_ulvt_mac l=3e-08 w=5.6e-05 nf=56 m=1 ad=2.8e-12 as=2.85e-12 pd=6.16e-05 ps=6.37e-05 nrd=0.009138 nrs=0.009138 sa=1.36619e-06 sb=1.36619e-06 sd=1e-07
MINN (DN INN FT VSS) nch_ulvt_mac l=3e-08 w=5.6e-05 nf=56 m=1 ad=2.8e-12 as=2.85e-12 pd=6.16e-05 ps=6.37e-05 nrd=0.009138 nrs=0.009138 sa=1.36619e-06 sb=1.36619e-06 sd=1e-07
MFT1 (FT CKE VSS VSS) nch_ulvt_mac l=3e-08 w=3e-06 nf=3 m=1 ad=1.75e-13 as=1.75e-13 pd=4.35e-06 ps=4.35e-06 nrd=0.136842 nrs=0.136842 sa=1.47042e-07 sb=1.47042e-07 sd=1e-07
MFT2 (FT CKE VSS VSS) nch_ulvt_mac l=3e-08 w=3e-06 nf=3 m=1 ad=1.75e-13 as=1.75e-13 pd=4.35e-06 ps=4.35e-06 nrd=0.136842 nrs=0.136842 sa=1.47042e-07 sb=1.47042e-07 sd=1e-07
MRDP (DP CKF AVDD AVDD) pch_ulvt_mac l=3e-08 w=1.6e-05 nf=16 m=1 ad=8e-13 as=8.5e-13 pd=1.76e-05 ps=1.97e-05 nrd=0.012674 nrs=0.012674 sa=5.01551e-07 sb=5.01551e-07 sd=1e-07
MRDN (DN CKF AVDD AVDD) pch_ulvt_mac l=3e-08 w=1.6e-05 nf=16 m=1 ad=8e-13 as=8.5e-13 pd=1.76e-05 ps=1.97e-05 nrd=0.012674 nrs=0.012674 sa=5.01551e-07 sb=5.01551e-07 sd=1e-07
CDP1 (DP VSS) cfmom_2t nr=52 lr=1e-06 w=5e-08 s=5e-08 stm=1 spm=3 multi=1
CDP2 (DP VSS) cfmom_2t nr=52 lr=1e-06 w=5e-08 s=5e-08 stm=1 spm=3 multi=1
CDP3 (DP VSS) cfmom_2t nr=52 lr=1e-06 w=5e-08 s=5e-08 stm=1 spm=3 multi=1
CDP4 (DP VSS) cfmom_2t nr=52 lr=1e-06 w=5e-08 s=5e-08 stm=1 spm=3 multi=1
CDP5 (DP VSS) cfmom_2t nr=52 lr=1e-06 w=5e-08 s=5e-08 stm=1 spm=3 multi=1
CDN1 (DN VSS) cfmom_2t nr=52 lr=1e-06 w=5e-08 s=5e-08 stm=1 spm=3 multi=1
CDN2 (DN VSS) cfmom_2t nr=52 lr=1e-06 w=5e-08 s=5e-08 stm=1 spm=3 multi=1
CDN3 (DN VSS) cfmom_2t nr=52 lr=1e-06 w=5e-08 s=5e-08 stm=1 spm=3 multi=1
CDN4 (DN VSS) cfmom_2t nr=52 lr=1e-06 w=5e-08 s=5e-08 stm=1 spm=3 multi=1
CDN5 (DN VSS) cfmom_2t nr=52 lr=1e-06 w=5e-08 s=5e-08 stm=1 spm=3 multi=1
MSIP (XP DN ST VSS) nch_ulvt_mac l=3e-08 w=6e-06 nf=6 m=1 ad=3e-13 as=3.5e-13 pd=6.6e-06 ps=8.7e-06 nrd=0.076404 nrs=0.076404 sa=2.39369e-07 sb=2.39369e-07 sd=1e-07
MSIN (XN DP ST VSS) nch_ulvt_mac l=3e-08 w=6e-06 nf=6 m=1 ad=3e-13 as=3.5e-13 pd=6.6e-06 ps=8.7e-06 nrd=0.076404 nrs=0.076404 sa=2.39369e-07 sb=2.39369e-07 sd=1e-07
MST1 (ST CKL VSS VSS) nch_ulvt_mac l=3e-08 w=3e-06 nf=3 m=1 ad=1.75e-13 as=1.75e-13 pd=4.35e-06 ps=4.35e-06 nrd=0.136842 nrs=0.136842 sa=1.47042e-07 sb=1.47042e-07 sd=1e-07
MST2 (ST CKL VSS VSS) nch_ulvt_mac l=3e-08 w=3e-06 nf=3 m=1 ad=1.75e-13 as=1.75e-13 pd=4.35e-06 ps=4.35e-06 nrd=0.136842 nrs=0.136842 sa=1.47042e-07 sb=1.47042e-07 sd=1e-07
MLNP (QP QN XP VSS) nch_ulvt_mac l=3e-08 w=1.2e-05 nf=12 m=1 ad=6e-13 as=6.5e-13 pd=1.32e-05 ps=1.53e-05 nrd=0.040569 nrs=0.040569 sa=4.01767e-07 sb=4.01767e-07 sd=1e-07
MLNN (QN QP XN VSS) nch_ulvt_mac l=3e-08 w=1.2e-05 nf=12 m=1 ad=6e-13 as=6.5e-13 pd=1.32e-05 ps=1.53e-05 nrd=0.040569 nrs=0.040569 sa=4.01767e-07 sb=4.01767e-07 sd=1e-07
MLPP (QP QN AVDD AVDD) pch_ulvt_mac l=3e-08 w=8e-06 nf=8 m=1 ad=4e-13 as=4.5e-13 pd=8.8e-06 ps=1.09e-05 nrd=0.024976 nrs=0.024976 sa=2.95835e-07 sb=2.95835e-07 sd=1e-07
MLPN (QN QP AVDD AVDD) pch_ulvt_mac l=3e-08 w=8e-06 nf=8 m=1 ad=4e-13 as=4.5e-13 pd=8.8e-06 ps=1.09e-05 nrd=0.024976 nrs=0.024976 sa=2.95835e-07 sb=2.95835e-07 sd=1e-07
MRXP (XP CKL AVDD AVDD) pch_ulvt_mac l=3e-08 w=4e-06 nf=4 m=1 ad=2e-13 as=2.5e-13 pd=4.4e-06 ps=6.5e-06 nrd=0.048530 nrs=0.048530 sa=1.79203e-07 sb=1.79203e-07 sd=1e-07
MRXN (XN CKL AVDD AVDD) pch_ulvt_mac l=3e-08 w=4e-06 nf=4 m=1 ad=2e-13 as=2.5e-13 pd=4.4e-06 ps=6.5e-06 nrd=0.048530 nrs=0.048530 sa=1.79203e-07 sb=1.79203e-07 sd=1e-07
MRQP (QP CKL AVDD AVDD) pch_ulvt_mac l=3e-08 w=1.6e-05 nf=16 m=1 ad=8e-13 as=8.5e-13 pd=1.76e-05 ps=1.97e-05 nrd=0.012674 nrs=0.012674 sa=5.01551e-07 sb=5.01551e-07 sd=1e-07
MRQN (QN CKL AVDD AVDD) pch_ulvt_mac l=3e-08 w=1.6e-05 nf=16 m=1 ad=8e-13 as=8.5e-13 pd=1.76e-05 ps=1.97e-05 nrd=0.012674 nrs=0.012674 sa=5.01551e-07 sb=5.01551e-07 sd=1e-07
MOPP (OUTP QP AVDD AVDD) pch_ulvt_mac l=3e-08 w=4e-06 nf=4 m=1 ad=2e-13 as=2.5e-13 pd=4.4e-06 ps=6.5e-06 nrd=0.048530 nrs=0.048530 sa=1.79203e-07 sb=1.79203e-07 sd=1e-07
MOPN (OUTP QP VSS VSS) nch_ulvt_mac l=3e-08 w=3e-06 nf=3 m=1 ad=1.75e-13 as=1.75e-13 pd=4.35e-06 ps=4.35e-06 nrd=0.136842 nrs=0.136842 sa=1.47042e-07 sb=1.47042e-07 sd=1e-07
MONP (OUTN QN AVDD AVDD) pch_ulvt_mac l=3e-08 w=4e-06 nf=4 m=1 ad=2e-13 as=2.5e-13 pd=4.4e-06 ps=6.5e-06 nrd=0.048530 nrs=0.048530 sa=1.79203e-07 sb=1.79203e-07 sd=1e-07
MONN (OUTN QN VSS VSS) nch_ulvt_mac l=3e-08 w=3e-06 nf=3 m=1 ad=1.75e-13 as=1.75e-13 pd=4.35e-06 ps=4.35e-06 nrd=0.136842 nrs=0.136842 sa=1.47042e-07 sb=1.47042e-07 sd=1e-07
MB0P (CKB CLKC AVDD AVDD) pch_ulvt_mac l=3e-08 w=4e-06 nf=4 m=1 ad=2e-13 as=2.5e-13 pd=4.4e-06 ps=6.5e-06 nrd=0.048530 nrs=0.048530 sa=1.79203e-07 sb=1.79203e-07 sd=1e-07
MB0N (CKB CLKC VSS VSS) nch_ulvt_mac l=3e-08 w=2e-06 nf=2 m=1 ad=1e-13 as=1.5e-13 pd=2.2e-06 ps=4.3e-06 nrd=0.185844 nrs=0.185844 sa=1.12742e-07 sb=1.12742e-07 sd=1e-07
MB1P (CKF CKB AVDD AVDD) pch_ulvt_mac l=3e-08 w=8e-06 nf=8 m=1 ad=4e-13 as=4.5e-13 pd=8.8e-06 ps=1.09e-05 nrd=0.024976 nrs=0.024976 sa=2.95835e-07 sb=2.95835e-07 sd=1e-07
MB1N (CKF CKB VSS VSS) nch_ulvt_mac l=3e-08 w=4e-06 nf=4 m=1 ad=2e-13 as=2.5e-13 pd=4.4e-06 ps=6.5e-06 nrd=0.108289 nrs=0.108289 sa=1.79203e-07 sb=1.79203e-07 sd=1e-07
MD3P (D3 CKF AVDD AVDD) pch_ulvt_mac l=3e-08 w=4e-06 nf=4 m=1 ad=2e-13 as=2.5e-13 pd=4.4e-06 ps=6.5e-06 nrd=0.048530 nrs=0.048530 sa=1.79203e-07 sb=1.79203e-07 sd=1e-07
MD3N (D3 CKF VSS VSS) nch_ulvt_mac l=3e-08 w=2e-06 nf=2 m=1 ad=1e-13 as=1.5e-13 pd=2.2e-06 ps=4.3e-06 nrd=0.185844 nrs=0.185844 sa=1.12742e-07 sb=1.12742e-07 sd=1e-07
MD4P (CKD D3 AVDD AVDD) pch_ulvt_mac l=3e-08 w=8e-06 nf=8 m=1 ad=4e-13 as=4.5e-13 pd=8.8e-06 ps=1.09e-05 nrd=0.024976 nrs=0.024976 sa=2.95835e-07 sb=2.95835e-07 sd=1e-07
MD4N (CKD D3 VSS VSS) nch_ulvt_mac l=3e-08 w=4e-06 nf=4 m=1 ad=2e-13 as=2.5e-13 pd=4.4e-06 ps=6.5e-06 nrd=0.108289 nrs=0.108289 sa=1.79203e-07 sb=1.79203e-07 sd=1e-07
MNG1 (CKLB CKD NG VSS) nch_ulvt_mac l=3e-08 w=4e-06 nf=4 m=1 ad=2e-13 as=2.5e-13 pd=4.4e-06 ps=6.5e-06 nrd=0.108289 nrs=0.108289 sa=1.79203e-07 sb=1.79203e-07 sd=1e-07
MNG2 (NG CLKC VSS VSS) nch_ulvt_mac l=3e-08 w=4e-06 nf=4 m=1 ad=2e-13 as=2.5e-13 pd=4.4e-06 ps=6.5e-06 nrd=0.108289 nrs=0.108289 sa=1.79203e-07 sb=1.79203e-07 sd=1e-07
MPG1 (CKLB CLKC AVDD AVDD) pch_ulvt_mac l=3e-08 w=4e-06 nf=4 m=1 ad=2e-13 as=2.5e-13 pd=4.4e-06 ps=6.5e-06 nrd=0.048530 nrs=0.048530 sa=1.79203e-07 sb=1.79203e-07 sd=1e-07
MPG2 (CKLB CKD AVDD AVDD) pch_ulvt_mac l=3e-08 w=4e-06 nf=4 m=1 ad=2e-13 as=2.5e-13 pd=4.4e-06 ps=6.5e-06 nrd=0.048530 nrs=0.048530 sa=1.79203e-07 sb=1.79203e-07 sd=1e-07
MLBP (CKL CKLB AVDD AVDD) pch_ulvt_mac l=3e-08 w=1.6e-05 nf=16 m=1 ad=8e-13 as=8.5e-13 pd=1.76e-05 ps=1.97e-05 nrd=0.012674 nrs=0.012674 sa=5.01551e-07 sb=5.01551e-07 sd=1e-07
MLBN (CKL CKLB VSS VSS) nch_ulvt_mac l=3e-08 w=8e-06 nf=8 m=1 ad=4e-13 as=4.5e-13 pd=8.8e-06 ps=1.09e-05 nrd=0.059025 nrs=0.059025 sa=2.95835e-07 sb=2.95835e-07 sd=1e-07
MHEP1 (HP CKB AVDD AVDD) pch_ulvt_mac l=3e-08 w=8e-06 nf=8 m=1 ad=4e-13 as=4.5e-13 pd=8.8e-06 ps=1.09e-05 nrd=0.024976 nrs=0.024976 sa=2.95835e-07 sb=2.95835e-07 sd=1e-07
MHEP2 (CKE CKL HP AVDD) pch_ulvt_mac l=3e-08 w=8e-06 nf=8 m=1 ad=4e-13 as=4.5e-13 pd=8.8e-06 ps=1.09e-05 nrd=0.024976 nrs=0.024976 sa=2.95835e-07 sb=2.95835e-07 sd=1e-07
MHEN1 (CKE CKB VSS VSS) nch_ulvt_mac l=3e-08 w=4e-06 nf=4 m=1 ad=2e-13 as=2.5e-13 pd=4.4e-06 ps=6.5e-06 nrd=0.108289 nrs=0.108289 sa=1.79203e-07 sb=1.79203e-07 sd=1e-07
MHEN2 (CKE CKL VSS VSS) nch_ulvt_mac l=3e-08 w=4e-06 nf=4 m=1 ad=2e-13 as=2.5e-13 pd=4.4e-06 ps=6.5e-06 nrd=0.108289 nrs=0.108289 sa=1.79203e-07 sb=1.79203e-07 sd=1e-07
// @RNL(author="a6-readable-schematic") {
// # @SELECT-INSTANCE => @TEXT("",key="model");
// # @SELECT-TERMINAL => @REMOVE-FROM $GROUND_FILL_SET;
// # @SELECT-TERMINAL => @REMOVE-FROM $SUPPLY_FILL_SET;
// # @SELECT-NET(port=true) => @REMOVE-FROM $PORT_FILL_SET;
// $LOGIC2 = @DEFINE(roles=[["a","net"],["y","net"]]) {};
// $LOGIC3 = @DEFINE(roles=[["a","net"],["b","net"],["y","net"]]) {};
// $A6_COMPARATOR = @DEFINE-SYMBOL(box=[-8,-7,7,7]) {
//  (-8,2) @PIN(terminal="INP",direction="left"); (-8,-2) @PIN(terminal="INN",direction="left");
//  (-4,-7) @PIN(terminal="CLKC",direction="down");
//  (7,1) @PIN(terminal="OUTP",direction="right"); (7,-1) @PIN(terminal="OUTN",direction="right");
//  (-1,7) @PIN(terminal="AVDD",direction="up"); (-1,-7) @PIN(terminal="VSS",direction="down");
//  @LINE(linewidth=.18) {(-6,-5) (-6,5) (4,2) (4,-2) (-6,-5)};
//  @LINE {(-8,2) (-6,2)}; @LINE {(-8,-2) (-6,-2)};
//  @LINE {(4,1) (7,1)}; @LINE {(4,-1) (7,-1)};
//  @LINE {(-4,-7) (-4,-4.4)}; @LINE {(-5,-4.7) (-4,-3.7) (-3,-4.1)};
//  @LINE {(-1,7) (-1,3.5)}; @LINE {(-1,-3.5) (-1,-7)};
//  (-5.3,1.7) @TEXT("+",size=1.2); (-5.3,-2.3) @TEXT("-",size=1.2);
//  (2,.9) @TEXT("+",size=.9); (2,-2.1) @TEXT("-",size=.9);
//  (-2,0) @TEXT("A6",size=1.1,bold=true,halign="middle");
//  ? @TEXT("${name}",key="name",size=1.1,halign="end") => @PLACE(-7,6)
// }; # @SET-SYMBOL $A6_COMPARATOR;
// (0,104) @TEXT("A6  |  dynamic integrator + independent regenerative latch",size=2,bold=true,halign="start");
// (0,100) @TEXT("All MOS L = 30 nm; W in um. NMOS bulk = VSS, PMOS bulk = AVDD (three-terminal symbols).",size=1.05,bold=false,halign="start");
// (0,95) @TEXT("1  Front integrator",size=1.6,bold=true,halign="start");
// (94,100) @TEXT("2  Regenerative latch",size=1.6,bold=true,halign="start");
// (177,95) @TEXT("3  RTZ outputs",size=1.6,bold=true,halign="start");
// #MRDP @SET-SYMBOL $PMOS; #MRDP @PLACE(24,76) => @ORIENT("R0");
// #MRDP @TEXT("MRDP",key="name",size=1,dx=1,dy=1.8,halign="start");
// #MRDP @TEXT("W16",key="dims",size=.9,dx=1,dy=-1.8,halign="start");
// #MRDN @SET-SYMBOL $PMOS; #MRDN @PLACE(60,76) => @ORIENT("MY");
// #MRDN @TEXT("MRDN",key="name",size=1,dx=-1,dy=1.8,halign="end");
// #MRDN @TEXT("W16",key="dims",size=.9,dx=-1,dy=-1.8,halign="end");
// #MINP @SET-SYMBOL $NMOS; #MINP @PLACE(24,58) => @ORIENT("R0");
// #MINP @TEXT("MINP",key="name",size=1,dx=1,dy=1.8,halign="start");
// #MINP @TEXT("W56",key="dims",size=.9,dx=1,dy=-1.8,halign="start");
// #MINN @SET-SYMBOL $NMOS; #MINN @PLACE(60,58) => @ORIENT("MY");
// #MINN @TEXT("MINN",key="name",size=1,dx=-1,dy=1.8,halign="end");
// #MINN @TEXT("W56",key="dims",size=.9,dx=-1,dy=-1.8,halign="end");
// #MFT1 @SET-SYMBOL $NMOS; #MFT1 @PLACE(35,40) => @ORIENT("R0");
// #MFT1 @TEXT("MFT1",key="name",size=1,dx=1,dy=1.8,halign="start");
// #MFT1 @TEXT("W3",key="dims",size=.9,dx=1,dy=-1.8,halign="start");
// #MFT2 @SET-SYMBOL $NMOS; #MFT2 @PLACE(49,40) => @ORIENT("MY");
// #MFT2 @TEXT("MFT2",key="name",size=1,dx=-1,dy=1.8,halign="end");
// #MFT2 @TEXT("W3",key="dims",size=.9,dx=-1,dy=-1.8,halign="end");
// %v0 = $SUPPLY @ATTACH &AVDD => @PLACE(42,90);
// (25,69) @TEXT("DP",size=1,bold=true,halign="start");
// (55,69) @TEXT("DN",size=1,bold=true,halign="start");
// (16.3,76.35) @TEXT("CKF",size=0.95,bold=true,halign="end");
// (67.7,76.35) @TEXT("CKF",size=0.95,bold=true,halign="start");
// (14.3,58.35) @TEXT("INP",size=0.95,bold=true,halign="end");
// (69.7,58.35) @TEXT("INN",size=0.95,bold=true,halign="start");
// (40,51) @TEXT("FT",size=0.95,bold=true,halign="start");
// %v1 = $GROUND @ATTACH &VSS => @PLACE(42,29);
// (27.3,40.35) @TEXT("CKE",size=0.95,bold=true,halign="end");
// (56.7,40.35) @TEXT("CKE",size=0.95,bold=true,halign="start");
// #CDP1 @SET-SYMBOL $CAPACITOR; #CDP1 @PLACE(4,9);
// #CDP1 @TEXT("CDP1",key="name",size=.7,dx=0,dy=3.4,halign="middle");
// #CDP1 @TEXT("",key="value");
// #CDP2 @SET-SYMBOL $CAPACITOR; #CDP2 @PLACE(10,9);
// #CDP2 @TEXT("CDP2",key="name",size=.7,dx=0,dy=3.4,halign="middle");
// #CDP2 @TEXT("",key="value");
// #CDP3 @SET-SYMBOL $CAPACITOR; #CDP3 @PLACE(16,9);
// #CDP3 @TEXT("CDP3",key="name",size=.7,dx=0,dy=3.4,halign="middle");
// #CDP3 @TEXT("",key="value");
// #CDP4 @SET-SYMBOL $CAPACITOR; #CDP4 @PLACE(22,9);
// #CDP4 @TEXT("CDP4",key="name",size=.7,dx=0,dy=3.4,halign="middle");
// #CDP4 @TEXT("",key="value");
// #CDP5 @SET-SYMBOL $CAPACITOR; #CDP5 @PLACE(28,9);
// #CDP5 @TEXT("CDP5",key="name",size=.7,dx=0,dy=3.4,halign="middle");
// #CDP5 @TEXT("",key="value");
// %v2 = $GROUND @ATTACH &VSS => @PLACE(16,0);
// (16,-5) @TEXT("5 x C52 / 1 um",size=1,bold=false,halign="middle");
// #CDN1 @SET-SYMBOL $CAPACITOR; #CDN1 @PLACE(56,9);
// #CDN1 @TEXT("CDN1",key="name",size=.7,dx=0,dy=3.4,halign="middle");
// #CDN1 @TEXT("",key="value");
// #CDN2 @SET-SYMBOL $CAPACITOR; #CDN2 @PLACE(62,9);
// #CDN2 @TEXT("CDN2",key="name",size=.7,dx=0,dy=3.4,halign="middle");
// #CDN2 @TEXT("",key="value");
// #CDN3 @SET-SYMBOL $CAPACITOR; #CDN3 @PLACE(68,9);
// #CDN3 @TEXT("CDN3",key="name",size=.7,dx=0,dy=3.4,halign="middle");
// #CDN3 @TEXT("",key="value");
// #CDN4 @SET-SYMBOL $CAPACITOR; #CDN4 @PLACE(74,9);
// #CDN4 @TEXT("CDN4",key="name",size=.7,dx=0,dy=3.4,halign="middle");
// #CDN4 @TEXT("",key="value");
// #CDN5 @SET-SYMBOL $CAPACITOR; #CDN5 @PLACE(80,9);
// #CDN5 @TEXT("CDN5",key="name",size=.7,dx=0,dy=3.4,halign="middle");
// #CDN5 @TEXT("",key="value");
// %v3 = $GROUND @ATTACH &VSS => @PLACE(68,0);
// (68,-5) @TEXT("5 x C52 / 1 um",size=1,bold=false,halign="middle");
// #MSIP @SET-SYMBOL $NMOS; #MSIP @PLACE(112,46) => @ORIENT("R0");
// #MSIP @TEXT("MSIP",key="name",size=1,dx=1,dy=1.8,halign="start");
// #MSIP @TEXT("W6",key="dims",size=.9,dx=1,dy=-1.8,halign="start");
// #MSIN @SET-SYMBOL $NMOS; #MSIN @PLACE(148,46) => @ORIENT("MY");
// #MSIN @TEXT("MSIN",key="name",size=1,dx=-1,dy=1.8,halign="end");
// #MSIN @TEXT("W6",key="dims",size=.9,dx=-1,dy=-1.8,halign="end");
// #MLNP @SET-SYMBOL $NMOS; #MLNP @PLACE(112,60) => @ORIENT("MY");
// #MLNP @TEXT("MLNP",key="name",size=1,dx=-1,dy=1.8,halign="end");
// #MLNP @TEXT("W12",key="dims",size=.9,dx=-1,dy=-1.8,halign="end");
// #MLNN @SET-SYMBOL $NMOS; #MLNN @PLACE(148,60) => @ORIENT("R0");
// #MLNN @TEXT("MLNN",key="name",size=1,dx=1,dy=1.8,halign="start");
// #MLNN @TEXT("W12",key="dims",size=.9,dx=1,dy=-1.8,halign="start");
// #MLPP @SET-SYMBOL $PMOS; #MLPP @PLACE(112,78) => @ORIENT("MY");
// #MLPP @TEXT("MLPP",key="name",size=1,dx=-1,dy=1.8,halign="end");
// #MLPP @TEXT("W8",key="dims",size=.9,dx=-1,dy=-1.8,halign="end");
// #MLPN @SET-SYMBOL $PMOS; #MLPN @PLACE(148,78) => @ORIENT("R0");
// #MLPN @TEXT("MLPN",key="name",size=1,dx=1,dy=1.8,halign="start");
// #MLPN @TEXT("W8",key="dims",size=.9,dx=1,dy=-1.8,halign="start");
// #MRQP @SET-SYMBOL $PMOS; #MRQP @PLACE(98,78) => @ORIENT("R0");
// #MRQP @TEXT("MRQP",key="name",size=1,dx=1,dy=1.8,halign="start");
// #MRQP @TEXT("W16",key="dims",size=.9,dx=1,dy=-1.8,halign="start");
// #MRQN @SET-SYMBOL $PMOS; #MRQN @PLACE(162,78) => @ORIENT("MY");
// #MRQN @TEXT("MRQN",key="name",size=1,dx=-1,dy=1.8,halign="end");
// #MRQN @TEXT("W16",key="dims",size=.9,dx=-1,dy=-1.8,halign="end");
// #MRXP @SET-SYMBOL $PMOS; #MRXP @PLACE(98,54) => @ORIENT("R0");
// #MRXP @TEXT("MRXP",key="name",size=1,dx=1,dy=1.8,halign="start");
// #MRXP @TEXT("W4",key="dims",size=.9,dx=1,dy=-1.8,halign="start");
// #MRXN @SET-SYMBOL $PMOS; #MRXN @PLACE(162,54) => @ORIENT("MY");
// #MRXN @TEXT("MRXN",key="name",size=1,dx=-1,dy=1.8,halign="end");
// #MRXN @TEXT("W4",key="dims",size=.9,dx=-1,dy=-1.8,halign="end");
// #MST1 @SET-SYMBOL $NMOS; #MST1 @PLACE(123,28) => @ORIENT("R0");
// #MST1 @TEXT("MST1",key="name",size=1,dx=1,dy=1.8,halign="start");
// #MST1 @TEXT("W3",key="dims",size=.9,dx=1,dy=-1.8,halign="start");
// #MST2 @SET-SYMBOL $NMOS; #MST2 @PLACE(137,28) => @ORIENT("MY");
// #MST2 @TEXT("MST2",key="name",size=1,dx=-1,dy=1.8,halign="end");
// #MST2 @TEXT("W3",key="dims",size=.9,dx=-1,dy=-1.8,halign="end");
// %v4 = $SUPPLY @ATTACH &AVDD => @PLACE(130,95);
// (108,70) @TEXT("QP",size=0.95,bold=true,halign="end");
// (152,70) @TEXT("QN",size=0.95,bold=true,halign="start");
// (113,53) @TEXT("XP",size=0.95,bold=false,halign="start");
// (143,53) @TEXT("XN",size=0.95,bold=false,halign="start");
// (91.3,78.35) @TEXT("CKL",size=0.95,bold=true,halign="end");
// (168.7,78.35) @TEXT("CKL",size=0.95,bold=true,halign="start");
// (91.3,54.35) @TEXT("CKL",size=0.95,bold=true,halign="end");
// (168.7,54.35) @TEXT("CKL",size=0.95,bold=true,halign="start");
// (104.3,46.35) @TEXT("DN",size=0.95,bold=true,halign="end");
// (155.7,46.35) @TEXT("DP",size=0.95,bold=true,halign="start");
// (128,37) @TEXT("ST",size=0.95,bold=true,halign="start");
// %v5 = $GROUND @ATTACH &VSS => @PLACE(130,17);
// (115.3,28.35) @TEXT("CKL",size=0.95,bold=true,halign="end");
// (144.7,28.35) @TEXT("CKL",size=0.95,bold=true,halign="start");
// (95,7) @TEXT("DN / DP drive only MSIP / MSIN gates.",size=1.05,bold=false,halign="start");
// (95,3) @TEXT("Cross-coupled QP / QN provide regeneration.",size=1.05,bold=false,halign="start");
// %outp = &QP &OUTP @AS $LOGIC2 => @SET-SYMBOL $INVERTER => @PLACE(190,80);
// %outp @TEXT("MOPP / MOPN",key="name",size=.95,dx=0,dy=3.6,halign="middle");
// %outn = &QN &OUTN @AS $LOGIC2 => @SET-SYMBOL $INVERTER => @PLACE(218,80);
// %outn @TEXT("MONP / MONN",key="name",size=.95,dx=0,dy=3.6,halign="middle");
// (180.5,80.5) @TEXT("QP",size=1,bold=true,halign="end");
// (198.5,80.5) @TEXT("OUTP",size=1,bold=true,halign="start");
// (208.5,80.5) @TEXT("QN",size=1,bold=true,halign="end");
// (226.5,80.5) @TEXT("OUTN",size=1,bold=true,halign="start");
// (183,62) @TEXT("P4 / N3",size=1.15,bold=true,halign="start");
// #MOPP @SET-SYMBOL $PMOS; #MOPP @PLACE(190,54) => @ORIENT("R0");
// #MOPP @TEXT("MOPP",key="name",size=1,dx=1,dy=1.8,halign="start");
// #MOPP @TEXT("W4",key="dims",size=.9,dx=1,dy=-1.8,halign="start");
// #MOPN @SET-SYMBOL $NMOS; #MOPN @PLACE(190,42) => @ORIENT("R0");
// #MOPN @TEXT("MOPN",key="name",size=1,dx=1,dy=1.8,halign="start");
// #MOPN @TEXT("W3",key="dims",size=.9,dx=1,dy=-1.8,halign="start");
// %v6 = $SUPPLY @ATTACH &AVDD => @PLACE(190,59);
// %v7 = $GROUND @ATTACH &VSS => @PLACE(190,36);
// (180.5,48.5) @TEXT("QP",size=0.95,bold=true,halign="end");
// (197.5,48.4) @TEXT("OUTP",size=0.95,bold=true,halign="start");
// (211,62) @TEXT("P4 / N3",size=1.15,bold=true,halign="start");
// #MONP @SET-SYMBOL $PMOS; #MONP @PLACE(218,54) => @ORIENT("R0");
// #MONP @TEXT("MONP",key="name",size=1,dx=1,dy=1.8,halign="start");
// #MONP @TEXT("W4",key="dims",size=.9,dx=1,dy=-1.8,halign="start");
// #MONN @SET-SYMBOL $NMOS; #MONN @PLACE(218,42) => @ORIENT("R0");
// #MONN @TEXT("MONN",key="name",size=1,dx=1,dy=1.8,halign="start");
// #MONN @TEXT("W3",key="dims",size=.9,dx=1,dy=-1.8,halign="start");
// %v8 = $SUPPLY @ATTACH &AVDD => @PLACE(218,59);
// %v9 = $GROUND @ATTACH &VSS => @PLACE(218,36);
// (208.5,48.5) @TEXT("QN",size=0.95,bold=true,halign="end");
// (225.5,48.4) @TEXT("OUTN",size=0.95,bold=true,halign="start");
// (179,20) @TEXT("OUTP / OUTN reset low.",size=1.05,bold=false,halign="start");
// (179,15) @TEXT("Gate symbols above refer to",size=1.05,bold=false,halign="start");
// (179,11) @TEXT("the same four devices below.",size=1.05,bold=false,halign="start");
// (0,-17) @TEXT("4  Clock / evaluation logic  |  standard gate symbols; physical devices below",size=1.6,bold=true,halign="start");
// %b0 = &CLKC &CKB @AS $LOGIC2 => @SET-SYMBOL $INVERTER => @PLACE(16,-32);
// %b0 @TEXT("MB0",key="name",size=.95,dx=0,dy=3.6,halign="middle");
// %b1 = &CKB &CKF @AS $LOGIC2 => @SET-SYMBOL $INVERTER => @PLACE(43,-32);
// %b1 @TEXT("MB1",key="name",size=.95,dx=0,dy=3.6,halign="middle");
// %d3 = &CKF &D3 @AS $LOGIC2 => @SET-SYMBOL $INVERTER => @PLACE(70,-32);
// %d3 @TEXT("MD3",key="name",size=.95,dx=0,dy=3.6,halign="middle");
// %d4 = &D3 &CKD @AS $LOGIC2 => @SET-SYMBOL $INVERTER => @PLACE(97,-32);
// %d4 @TEXT("MD4",key="name",size=.95,dx=0,dy=3.6,halign="middle");
// %nand = &CLKC &CKD &CKLB @AS $LOGIC3 => @SET-SYMBOL $NAND_2INPUT => @PLACE(133,-32);
// %nand @TEXT("MPG / MNG",key="name",size=.95,dx=0,dy=3.6,halign="middle");
// %lb = &CKLB &CKL @AS $LOGIC2 => @SET-SYMBOL $INVERTER => @PLACE(166,-32);
// %lb @TEXT("MLB",key="name",size=.95,dx=0,dy=3.6,halign="middle");
// %nor = &CKB &CKL &CKE @AS $LOGIC3 => @SET-SYMBOL $NOR_2INPUT => @PLACE(205,-32);
// %nor @TEXT("MHE",key="name",size=.95,dx=0,dy=3.6,halign="middle");
// (0,-31) @TEXT("CLKC",size=1.05,bold=true,halign="start");
// (27,-30) @TEXT("CKB",size=0.95,bold=true,halign="middle");
// (54,-30) @TEXT("CKF",size=0.95,bold=true,halign="middle");
// (81,-30) @TEXT("D3",size=0.95,bold=true,halign="middle");
// (109,-30) @TEXT("CKD",size=0.95,bold=true,halign="middle");
// (150,-30) @TEXT("CKLB",size=0.95,bold=true,halign="middle");
// (179,-30) @TEXT("CKL",size=0.95,bold=true,halign="middle");
// (226,-31.5) @TEXT("CKE",size=1.05,bold=true,halign="start");
// (0,-51) @TEXT("CKF: front reset   |   CKL = CLKC AND CKD: latch evaluation   |   CKE = NOR(CKB, CKL): front-tail enable",size=1.1,bold=false,halign="start");
// (0,-59) @TEXT("5  Clock transistor implementation  |  same nets and devices as the functional view",size=1.6,bold=true,halign="start");
// (9,-74) @TEXT("MB0",size=1.15,bold=true,halign="start");
// #MB0P @SET-SYMBOL $PMOS; #MB0P @PLACE(16,-82) => @ORIENT("R0");
// #MB0P @TEXT("MB0P",key="name",size=1,dx=1,dy=1.8,halign="start");
// #MB0P @TEXT("W4",key="dims",size=.9,dx=1,dy=-1.8,halign="start");
// #MB0N @SET-SYMBOL $NMOS; #MB0N @PLACE(16,-94) => @ORIENT("R0");
// #MB0N @TEXT("MB0N",key="name",size=1,dx=1,dy=1.8,halign="start");
// #MB0N @TEXT("W2",key="dims",size=.9,dx=1,dy=-1.8,halign="start");
// %v10 = $SUPPLY @ATTACH &AVDD => @PLACE(16,-77);
// %v11 = $GROUND @ATTACH &VSS => @PLACE(16,-100);
// (6.5,-87.5) @TEXT("CLKC",size=0.95,bold=true,halign="end");
// (23.5,-87.6) @TEXT("CKB",size=0.95,bold=true,halign="start");
// (39,-74) @TEXT("MB1",size=1.15,bold=true,halign="start");
// #MB1P @SET-SYMBOL $PMOS; #MB1P @PLACE(46,-82) => @ORIENT("R0");
// #MB1P @TEXT("MB1P",key="name",size=1,dx=1,dy=1.8,halign="start");
// #MB1P @TEXT("W8",key="dims",size=.9,dx=1,dy=-1.8,halign="start");
// #MB1N @SET-SYMBOL $NMOS; #MB1N @PLACE(46,-94) => @ORIENT("R0");
// #MB1N @TEXT("MB1N",key="name",size=1,dx=1,dy=1.8,halign="start");
// #MB1N @TEXT("W4",key="dims",size=.9,dx=1,dy=-1.8,halign="start");
// %v12 = $SUPPLY @ATTACH &AVDD => @PLACE(46,-77);
// %v13 = $GROUND @ATTACH &VSS => @PLACE(46,-100);
// (36.5,-87.5) @TEXT("CKB",size=0.95,bold=true,halign="end");
// (53.5,-87.6) @TEXT("CKF",size=0.95,bold=true,halign="start");
// (69,-74) @TEXT("MD3",size=1.15,bold=true,halign="start");
// #MD3P @SET-SYMBOL $PMOS; #MD3P @PLACE(76,-82) => @ORIENT("R0");
// #MD3P @TEXT("MD3P",key="name",size=1,dx=1,dy=1.8,halign="start");
// #MD3P @TEXT("W4",key="dims",size=.9,dx=1,dy=-1.8,halign="start");
// #MD3N @SET-SYMBOL $NMOS; #MD3N @PLACE(76,-94) => @ORIENT("R0");
// #MD3N @TEXT("MD3N",key="name",size=1,dx=1,dy=1.8,halign="start");
// #MD3N @TEXT("W2",key="dims",size=.9,dx=1,dy=-1.8,halign="start");
// %v14 = $SUPPLY @ATTACH &AVDD => @PLACE(76,-77);
// %v15 = $GROUND @ATTACH &VSS => @PLACE(76,-100);
// (66.5,-87.5) @TEXT("CKF",size=0.95,bold=true,halign="end");
// (83.5,-87.6) @TEXT("D3",size=0.95,bold=true,halign="start");
// (99,-74) @TEXT("MD4",size=1.15,bold=true,halign="start");
// #MD4P @SET-SYMBOL $PMOS; #MD4P @PLACE(106,-82) => @ORIENT("R0");
// #MD4P @TEXT("MD4P",key="name",size=1,dx=1,dy=1.8,halign="start");
// #MD4P @TEXT("W8",key="dims",size=.9,dx=1,dy=-1.8,halign="start");
// #MD4N @SET-SYMBOL $NMOS; #MD4N @PLACE(106,-94) => @ORIENT("R0");
// #MD4N @TEXT("MD4N",key="name",size=1,dx=1,dy=1.8,halign="start");
// #MD4N @TEXT("W4",key="dims",size=.9,dx=1,dy=-1.8,halign="start");
// %v16 = $SUPPLY @ATTACH &AVDD => @PLACE(106,-77);
// %v17 = $GROUND @ATTACH &VSS => @PLACE(106,-100);
// (96.5,-87.5) @TEXT("D3",size=0.95,bold=true,halign="end");
// (113.5,-87.6) @TEXT("CKD",size=0.95,bold=true,halign="start");
// (167,-74) @TEXT("MLB",size=1.15,bold=true,halign="start");
// #MLBP @SET-SYMBOL $PMOS; #MLBP @PLACE(174,-82) => @ORIENT("R0");
// #MLBP @TEXT("MLBP",key="name",size=1,dx=1,dy=1.8,halign="start");
// #MLBP @TEXT("W16",key="dims",size=.9,dx=1,dy=-1.8,halign="start");
// #MLBN @SET-SYMBOL $NMOS; #MLBN @PLACE(174,-94) => @ORIENT("R0");
// #MLBN @TEXT("MLBN",key="name",size=1,dx=1,dy=1.8,halign="start");
// #MLBN @TEXT("W8",key="dims",size=.9,dx=1,dy=-1.8,halign="start");
// %v18 = $SUPPLY @ATTACH &AVDD => @PLACE(174,-77);
// %v19 = $GROUND @ATTACH &VSS => @PLACE(174,-100);
// (164.5,-87.5) @TEXT("CKLB",size=0.95,bold=true,halign="end");
// (181.5,-87.6) @TEXT("CKL",size=0.95,bold=true,halign="start");
// (127,-72) @TEXT("NAND2",size=1.15,bold=true,halign="start");
// #MPG1 @SET-SYMBOL $PMOS; #MPG1 @PLACE(134,-80) => @ORIENT("R0");
// #MPG1 @TEXT("MPG1",key="name",size=1,dx=1,dy=1.8,halign="start");
// #MPG1 @TEXT("W4",key="dims",size=.9,dx=1,dy=-1.8,halign="start");
// #MPG2 @SET-SYMBOL $PMOS; #MPG2 @PLACE(149,-80) => @ORIENT("MY");
// #MPG2 @TEXT("MPG2",key="name",size=1,dx=-1,dy=1.8,halign="end");
// #MPG2 @TEXT("W4",key="dims",size=.9,dx=-1,dy=-1.8,halign="end");
// #MNG1 @SET-SYMBOL $NMOS; #MNG1 @PLACE(141,-94) => @ORIENT("R0");
// #MNG1 @TEXT("MNG1",key="name",size=1,dx=1,dy=1.8,halign="start");
// #MNG1 @TEXT("W4",key="dims",size=.9,dx=1,dy=-1.8,halign="start");
// #MNG2 @SET-SYMBOL $NMOS; #MNG2 @PLACE(141,-104) => @ORIENT("R0");
// #MNG2 @TEXT("MNG2",key="name",size=1,dx=1,dy=1.8,halign="start");
// #MNG2 @TEXT("W4",key="dims",size=.9,dx=1,dy=-1.8,halign="start");
// %v20 = $SUPPLY @ATTACH &AVDD => @PLACE(141,-72);
// (156,-86) @TEXT("CKLB",size=0.95,bold=true,halign="start");
// (142,-99) @TEXT("NG",size=0.8,bold=false,halign="start");
// %v21 = $GROUND @ATTACH &VSS => @PLACE(141,-110);
// (128.3,-79.65) @TEXT("CLKC",size=0.95,bold=true,halign="end");
// (154.7,-79.65) @TEXT("CKD",size=0.95,bold=true,halign="start");
// (133.3,-93.65) @TEXT("CKD",size=0.95,bold=true,halign="end");
// (133.3,-103.65) @TEXT("CLKC",size=0.95,bold=true,halign="end");
// (200,-72) @TEXT("NOR2",size=1.15,bold=true,halign="start");
// #MHEP1 @SET-SYMBOL $PMOS; #MHEP1 @PLACE(210,-80) => @ORIENT("R0");
// #MHEP1 @TEXT("MHEP1",key="name",size=1,dx=1,dy=1.8,halign="start");
// #MHEP1 @TEXT("W8",key="dims",size=.9,dx=1,dy=-1.8,halign="start");
// #MHEP2 @SET-SYMBOL $PMOS; #MHEP2 @PLACE(210,-90) => @ORIENT("R0");
// #MHEP2 @TEXT("MHEP2",key="name",size=1,dx=1,dy=1.8,halign="start");
// #MHEP2 @TEXT("W8",key="dims",size=.9,dx=1,dy=-1.8,halign="start");
// #MHEN1 @SET-SYMBOL $NMOS; #MHEN1 @PLACE(202,-104) => @ORIENT("R0");
// #MHEN1 @TEXT("MHEN1",key="name",size=1,dx=1,dy=1.8,halign="start");
// #MHEN1 @TEXT("W4",key="dims",size=.9,dx=1,dy=-1.8,halign="start");
// #MHEN2 @SET-SYMBOL $NMOS; #MHEN2 @PLACE(220,-104) => @ORIENT("MY");
// #MHEN2 @TEXT("MHEN2",key="name",size=1,dx=-1,dy=1.8,halign="end");
// #MHEN2 @TEXT("W4",key="dims",size=.9,dx=-1,dy=-1.8,halign="end");
// %v22 = $SUPPLY @ATTACH &AVDD => @PLACE(210,-75);
// (211,-85) @TEXT("HP",size=0.85,bold=false,halign="start");
// (226,-97) @TEXT("CKE",size=0.95,bold=true,halign="start");
// %v23 = $GROUND @ATTACH &VSS => @PLACE(210,-114);
// (203.3,-79.65) @TEXT("CKB",size=0.95,bold=true,halign="end");
// (203.3,-89.65) @TEXT("CKL",size=0.95,bold=true,halign="end");
// (195.3,-103.65) @TEXT("CKB",size=0.95,bold=true,halign="end");
// (226.7,-103.65) @TEXT("CKL",size=0.95,bold=true,halign="start");
// (0,-119) @TEXT("Equal net labels connect across panels. Dots mark only real T / cross branches; unmarked crossings do not connect.",size=1.05,bold=false,halign="start");
// (0,-124) @TEXT("Drawing-only logic views do not add devices. All 40 MOS and 10 MOM instances are shown once at transistor level.",size=1.05,bold=false,halign="start");
// {#MINP #MINN} @AS $MATCHED;
// {#MSIP #MSIN} @AS $MATCHED;
// {#MRDP #MRDN} @AS $MATCHED;
// {#MFT1 #MFT2} @AS $MATCHED;
// {#MST1 #MST2} @AS $MATCHED;
// {#MLNP #MLNN} @AS $MATCHED;
// {#MLPP #MLPN} @AS $MATCHED;
// {#MRXP #MRXN} @AS $MATCHED;
// {#MRQP #MRQN} @AS $MATCHED;
// #MINP(in_p) #MINN(in_n) @AS $DIFFERENTIAL_PAIR; #MSIP(in_p) #MSIN(in_n) @AS $DIFFERENTIAL_PAIR;
// {#MINP #MINN #MFT1 #MFT2 #MRDP #MRDN #CDP1 #CDP2 #CDP3 #CDP4 #CDP5 #CDN1 #CDN2 #CDN3 #CDN4 #CDN5} @GROUP;
// {#MSIP #MSIN #MST1 #MST2 #MLNP #MLNN #MLPP #MLPN #MRXP #MRXN #MRQP #MRQN} @GROUP;
// {#MB0P #MB0N #MB1P #MB1N #MD3P #MD3N #MD4P #MD4N #MNG1 #MNG2 #MPG1 #MPG2 #MLBP #MLBN #MHEP1 #MHEP2 #MHEN1 #MHEN2} @GROUP;
// %j0 = (24,86);
// %j1 = (42,86);
// %j2 = (60,86);
// %j3 = (24,68);
// %j4 = (60,68);
// %j5 = (17,76);
// %j6 = (67,76);
// %j7 = (15,58);
// %j8 = (69,58);
// %j9 = (24,50);
// %j10 = (35,50);
// %j11 = (49,50);
// %j12 = (60,50);
// %j13 = (35,32);
// %j14 = (49,32);
// %j15 = (42,32);
// %j16 = (28,40);
// %j17 = (56,40);
// %j18 = (4,16);
// %j19 = (4,3);
// %j20 = (10,16);
// %j21 = (10,3);
// %j22 = (16,16);
// %j23 = (16,3);
// %j24 = (22,16);
// %j25 = (22,3);
// %j26 = (28,16);
// %j27 = (28,3);
// %j28 = (56,16);
// %j29 = (56,3);
// %j30 = (62,16);
// %j31 = (62,3);
// %j32 = (68,16);
// %j33 = (68,3);
// %j34 = (74,16);
// %j35 = (74,3);
// %j36 = (80,16);
// %j37 = (80,3);
// %j38 = (0,68);
// %j39 = (0,16);
// %j40 = (84,68);
// %j41 = (84,16);
// %j42 = (86,92);
// %j43 = (98,92);
// %j44 = (112,92);
// %j45 = (130,92);
// %j46 = (148,92);
// %j47 = (162,92);
// %j48 = (174,92);
// %j49 = (86,56);
// %j50 = (174,56);
// %j51 = (112,69);
// %j52 = (148,69);
// %j53 = (98,69);
// %j54 = (162,69);
// %j55 = (112,52);
// %j56 = (148,52);
// %j57 = (116,69);
// %j58 = (116,72);
// %j59 = (140,72);
// %j60 = (140,60);
// %j61 = (140,78);
// %j62 = (144,69);
// %j63 = (144,66);
// %j64 = (120,66);
// %j65 = (120,60);
// %j66 = (120,78);
// %j67 = (92,78);
// %j68 = (168,78);
// %j69 = (92,54);
// %j70 = (168,54);
// %j71 = (105,46);
// %j72 = (155,46);
// %j73 = (112,36);
// %j74 = (123,36);
// %j75 = (137,36);
// %j76 = (148,36);
// %j77 = (123,20);
// %j78 = (137,20);
// %j79 = (130,20);
// %j80 = (116,28);
// %j81 = (144,28);
// %j82 = (181,80);
// %j83 = (198,80);
// %j84 = (209,80);
// %j85 = (226,80);
// %j86 = (185,54);
// %j87 = (185,48);
// %j88 = (185,42);
// %j89 = (181,48);
// %j90 = (190,48);
// %j91 = (197,48);
// %j92 = (213,54);
// %j93 = (213,48);
// %j94 = (213,42);
// %j95 = (209,48);
// %j96 = (218,48);
// %j97 = (225,48);
// %j98 = (0,-32);
// %j99 = (7,-32);
// %j100 = (7,-22);
// %j101 = (123,-22);
// %j102 = (123,-31);
// %j103 = (115,-32);
// %j104 = (115,-33);
// %j105 = (184,-32);
// %j106 = (184,-33);
// %j107 = (29,-32);
// %j108 = (29,-44);
// %j109 = (195,-44);
// %j110 = (195,-31);
// %j111 = (225,-32);
// %j112 = (11,-82);
// %j113 = (11,-88);
// %j114 = (11,-94);
// %j115 = (7,-88);
// %j116 = (16,-88);
// %j117 = (23,-88);
// %j118 = (41,-82);
// %j119 = (41,-88);
// %j120 = (41,-94);
// %j121 = (37,-88);
// %j122 = (46,-88);
// %j123 = (53,-88);
// %j124 = (71,-82);
// %j125 = (71,-88);
// %j126 = (71,-94);
// %j127 = (67,-88);
// %j128 = (76,-88);
// %j129 = (83,-88);
// %j130 = (101,-82);
// %j131 = (101,-88);
// %j132 = (101,-94);
// %j133 = (97,-88);
// %j134 = (106,-88);
// %j135 = (113,-88);
// %j136 = (169,-82);
// %j137 = (169,-88);
// %j138 = (169,-94);
// %j139 = (165,-88);
// %j140 = (174,-88);
// %j141 = (181,-88);
// %j142 = (134,-75);
// %j143 = (141,-75);
// %j144 = (149,-75);
// %j145 = (134,-87);
// %j146 = (141,-87);
// %j147 = (149,-87);
// %j148 = (156,-87);
// %j149 = (129,-80);
// %j150 = (154,-80);
// %j151 = (134,-94);
// %j152 = (134,-104);
// %j153 = (210,-98);
// %j154 = (202,-98);
// %j155 = (220,-98);
// %j156 = (226,-98);
// %j157 = (202,-111);
// %j158 = (210,-111);
// %j159 = (220,-111);
// %j160 = (204,-80);
// %j161 = (204,-90);
// %j162 = (196,-104);
// %j163 = (226,-104);
// &AVDD @WIRE(mode="straight") {#MRDP:3 %j0 %j1 %j2 #MRDN:3};
// &AVDD @WIRE(mode="straight") {%j1 %v0:p};
// &DP @WIRE(mode="straight") {#MRDP:1 %j3 #MINP:1};
// &DN @WIRE(mode="straight") {#MRDN:1 %j4 #MINN:1};
// &CKF @WIRE(mode="straight") {#MRDP:2 %j5};
// &CKF @WIRE(mode="straight") {#MRDN:2 %j6};
// &INP @WIRE(mode="straight") {#MINP:2 %j7};
// &INN @WIRE(mode="straight") {#MINN:2 %j8};
// &FT @WIRE(mode="straight") {#MINP:3 %j9 %j10 %j11 %j12 #MINN:3};
// &FT @WIRE(mode="straight") {%j10 #MFT1:1};
// &FT @WIRE(mode="straight") {%j11 #MFT2:1};
// &VSS @WIRE(mode="straight") {#MFT1:3 %j13};
// &VSS @WIRE(mode="straight") {#MFT2:3 %j14};
// &VSS @WIRE(mode="straight") {%j13 %j15 %j14};
// &VSS @WIRE(mode="straight") {%j15 %v1:p};
// &CKE @WIRE(mode="straight") {#MFT1:2 %j16};
// &CKE @WIRE(mode="straight") {#MFT2:2 %j17};
// &DP @WIRE(mode="straight") {%j18 #CDP1:1};
// &VSS @WIRE(mode="straight") {#CDP1:2 %j19};
// &DP @WIRE(mode="straight") {%j20 #CDP2:1};
// &VSS @WIRE(mode="straight") {#CDP2:2 %j21};
// &DP @WIRE(mode="straight") {%j22 #CDP3:1};
// &VSS @WIRE(mode="straight") {#CDP3:2 %j23};
// &DP @WIRE(mode="straight") {%j24 #CDP4:1};
// &VSS @WIRE(mode="straight") {#CDP4:2 %j25};
// &DP @WIRE(mode="straight") {%j26 #CDP5:1};
// &VSS @WIRE(mode="straight") {#CDP5:2 %j27};
// &DP @WIRE(mode="straight") {%j18 %j20 %j22 %j24 %j26};
// &VSS @WIRE(mode="straight") {%j19 %j21 %j23 %j25 %j27};
// &VSS @WIRE(mode="straight") {%j23 %v2:p};
// &DN @WIRE(mode="straight") {%j28 #CDN1:1};
// &VSS @WIRE(mode="straight") {#CDN1:2 %j29};
// &DN @WIRE(mode="straight") {%j30 #CDN2:1};
// &VSS @WIRE(mode="straight") {#CDN2:2 %j31};
// &DN @WIRE(mode="straight") {%j32 #CDN3:1};
// &VSS @WIRE(mode="straight") {#CDN3:2 %j33};
// &DN @WIRE(mode="straight") {%j34 #CDN4:1};
// &VSS @WIRE(mode="straight") {#CDN4:2 %j35};
// &DN @WIRE(mode="straight") {%j36 #CDN5:1};
// &VSS @WIRE(mode="straight") {#CDN5:2 %j37};
// &DN @WIRE(mode="straight") {%j28 %j30 %j32 %j34 %j36};
// &VSS @WIRE(mode="straight") {%j29 %j31 %j33 %j35 %j37};
// &VSS @WIRE(mode="straight") {%j33 %v3:p};
// &DP @WIRE(mode="straight") {%j3 %j38 %j39 %j18};
// &DN @WIRE(mode="straight") {%j4 %j40 %j41 %j36};
// &AVDD @WIRE(mode="straight") {%j42 %j43 %j44 %j45 %j46 %j47 %j48};
// &AVDD @WIRE(mode="straight") {%j45 %v4:p};
// &AVDD @WIRE(mode="straight") {#MLPP:3 %j44};
// &AVDD @WIRE(mode="straight") {#MLPN:3 %j46};
// &AVDD @WIRE(mode="straight") {#MRQP:3 %j43};
// &AVDD @WIRE(mode="straight") {#MRQN:3 %j47};
// &AVDD @WIRE(mode="straight") {#MRXP:3 %j49 %j42};
// &AVDD @WIRE(mode="straight") {#MRXN:3 %j50 %j48};
// &QP @WIRE(mode="straight") {#MLPP:1 %j51 #MLNP:1};
// &QN @WIRE(mode="straight") {#MLPN:1 %j52 #MLNN:1};
// &QP @WIRE(mode="straight") {#MRQP:1 %j53 %j51};
// &QN @WIRE(mode="straight") {#MRQN:1 %j54 %j52};
// &XP @WIRE(mode="straight") {#MLNP:3 %j55 #MSIP:1};
// &XN @WIRE(mode="straight") {#MLNN:3 %j56 #MSIN:1};
// &XP @WIRE(mode="straight") {#MRXP:1 %j55};
// &XN @WIRE(mode="straight") {#MRXN:1 %j56};
// &QP @WIRE(mode="straight") {%j51 %j57 %j58 %j59};
// &QP @WIRE(mode="straight") {#MLNN:2 %j60 %j59 %j61 #MLPN:2};
// &QN @WIRE(mode="straight") {%j52 %j62 %j63 %j64};
// &QN @WIRE(mode="straight") {#MLNP:2 %j65 %j64 %j66 #MLPP:2};
// &CKL @WIRE(mode="straight") {#MRQP:2 %j67};
// &CKL @WIRE(mode="straight") {#MRQN:2 %j68};
// &CKL @WIRE(mode="straight") {#MRXP:2 %j69};
// &CKL @WIRE(mode="straight") {#MRXN:2 %j70};
// &DN @WIRE(mode="straight") {#MSIP:2 %j71};
// &DP @WIRE(mode="straight") {#MSIN:2 %j72};
// &ST @WIRE(mode="straight") {#MSIP:3 %j73 %j74 %j75 %j76 #MSIN:3};
// &ST @WIRE(mode="straight") {%j74 #MST1:1};
// &VSS @WIRE(mode="straight") {#MST1:3 %j77};
// &ST @WIRE(mode="straight") {%j75 #MST2:1};
// &VSS @WIRE(mode="straight") {#MST2:3 %j78};
// &VSS @WIRE(mode="straight") {%j77 %j79 %j78};
// &VSS @WIRE(mode="straight") {%j79 %v5:p};
// &CKL @WIRE(mode="straight") {#MST1:2 %j80};
// &CKL @WIRE(mode="straight") {#MST2:2 %j81};
// &QP @WIRE(mode="straight") {%j82 %outp:1};
// &OUTP @WIRE(mode="straight") {%outp:2 %j83};
// &QN @WIRE(mode="straight") {%j84 %outn:1};
// &OUTN @WIRE(mode="straight") {%outn:2 %j85};
// &AVDD @WIRE(mode="straight") {#MOPP:3 %v6:p};
// &VSS @WIRE(mode="straight") {#MOPN:3 %v7:p};
// &QP @WIRE(mode="straight") {#MOPP:2 %j86 %j87 %j88 #MOPN:2};
// &QP @WIRE(mode="straight") {%j87 %j89};
// &OUTP @WIRE(mode="straight") {#MOPP:1 %j90 #MOPN:1};
// &OUTP @WIRE(mode="straight") {%j90 %j91};
// &AVDD @WIRE(mode="straight") {#MONP:3 %v8:p};
// &VSS @WIRE(mode="straight") {#MONN:3 %v9:p};
// &QN @WIRE(mode="straight") {#MONP:2 %j92 %j93 %j94 #MONN:2};
// &QN @WIRE(mode="straight") {%j93 %j95};
// &OUTN @WIRE(mode="straight") {#MONP:1 %j96 #MONN:1};
// &OUTN @WIRE(mode="straight") {%j96 %j97};
// &CLKC @WIRE(mode="straight") {%j98 %j99 %b0:1};
// &CLKC @WIRE(mode="straight") {%j99 %j100 %j101 %j102 %nand:1};
// &CKB @WIRE(mode="straight") {%b0:2 %j107 %b1:1};
// &CKF @WIRE(mode="straight") {%b1:2 %d3:1};
// &D3 @WIRE(mode="straight") {%d3:2 %d4:1};
// &CKD @WIRE(mode="straight") {%d4:2 %j103 %j104 %nand:2};
// &CKLB @WIRE(mode="straight") {%nand:3 %lb:1};
// &CKL @WIRE(mode="straight") {%lb:2 %j105 %j106 %nor:2};
// &CKB @WIRE(mode="straight") {%j107 %j108 %j109 %j110 %nor:1};
// &CKE @WIRE(mode="straight") {%nor:3 %j111};
// &AVDD @WIRE(mode="straight") {#MB0P:3 %v10:p};
// &VSS @WIRE(mode="straight") {#MB0N:3 %v11:p};
// &CLKC @WIRE(mode="straight") {#MB0P:2 %j112 %j113 %j114 #MB0N:2};
// &CLKC @WIRE(mode="straight") {%j113 %j115};
// &CKB @WIRE(mode="straight") {#MB0P:1 %j116 #MB0N:1};
// &CKB @WIRE(mode="straight") {%j116 %j117};
// &AVDD @WIRE(mode="straight") {#MB1P:3 %v12:p};
// &VSS @WIRE(mode="straight") {#MB1N:3 %v13:p};
// &CKB @WIRE(mode="straight") {#MB1P:2 %j118 %j119 %j120 #MB1N:2};
// &CKB @WIRE(mode="straight") {%j119 %j121};
// &CKF @WIRE(mode="straight") {#MB1P:1 %j122 #MB1N:1};
// &CKF @WIRE(mode="straight") {%j122 %j123};
// &AVDD @WIRE(mode="straight") {#MD3P:3 %v14:p};
// &VSS @WIRE(mode="straight") {#MD3N:3 %v15:p};
// &CKF @WIRE(mode="straight") {#MD3P:2 %j124 %j125 %j126 #MD3N:2};
// &CKF @WIRE(mode="straight") {%j125 %j127};
// &D3 @WIRE(mode="straight") {#MD3P:1 %j128 #MD3N:1};
// &D3 @WIRE(mode="straight") {%j128 %j129};
// &AVDD @WIRE(mode="straight") {#MD4P:3 %v16:p};
// &VSS @WIRE(mode="straight") {#MD4N:3 %v17:p};
// &D3 @WIRE(mode="straight") {#MD4P:2 %j130 %j131 %j132 #MD4N:2};
// &D3 @WIRE(mode="straight") {%j131 %j133};
// &CKD @WIRE(mode="straight") {#MD4P:1 %j134 #MD4N:1};
// &CKD @WIRE(mode="straight") {%j134 %j135};
// &AVDD @WIRE(mode="straight") {#MLBP:3 %v18:p};
// &VSS @WIRE(mode="straight") {#MLBN:3 %v19:p};
// &CKLB @WIRE(mode="straight") {#MLBP:2 %j136 %j137 %j138 #MLBN:2};
// &CKLB @WIRE(mode="straight") {%j137 %j139};
// &CKL @WIRE(mode="straight") {#MLBP:1 %j140 #MLBN:1};
// &CKL @WIRE(mode="straight") {%j140 %j141};
// &AVDD @WIRE(mode="straight") {#MPG1:3 %j142 %j143 %j144 #MPG2:3};
// &AVDD @WIRE(mode="straight") {%j143 %v20:p};
// &CKLB @WIRE(mode="straight") {#MPG1:1 %j145 %j146 %j147 #MPG2:1};
// &CKLB @WIRE(mode="straight") {%j146 #MNG1:1};
// &CKLB @WIRE(mode="straight") {%j147 %j148};
// &NG @WIRE(mode="straight") {#MNG1:3 #MNG2:1};
// &VSS @WIRE(mode="straight") {#MNG2:3 %v21:p};
// &CLKC @WIRE(mode="straight") {#MPG1:2 %j149};
// &CKD @WIRE(mode="straight") {#MPG2:2 %j150};
// &CKD @WIRE(mode="straight") {#MNG1:2 %j151};
// &CLKC @WIRE(mode="straight") {#MNG2:2 %j152};
// &AVDD @WIRE(mode="straight") {#MHEP1:3 %v22:p};
// &HP @WIRE(mode="straight") {#MHEP1:1 #MHEP2:3};
// &CKE @WIRE(mode="straight") {#MHEP2:1 %j153 %j154 #MHEN1:1};
// &CKE @WIRE(mode="straight") {%j153 %j155 #MHEN2:1};
// &CKE @WIRE(mode="straight") {%j155 %j156};
// &VSS @WIRE(mode="straight") {#MHEN1:3 %j157 %j158 %j159 #MHEN2:3};
// &VSS @WIRE(mode="straight") {%j158 %v23:p};
// &CKB @WIRE(mode="straight") {#MHEP1:2 %j160};
// &CKL @WIRE(mode="straight") {#MHEP2:2 %j161};
// &CKB @WIRE(mode="straight") {#MHEN1:2 %j162};
// &CKL @WIRE(mode="straight") {#MHEN2:2 %j163};
// $JUNCTION @ATTACH %j1;
// $JUNCTION @ATTACH %j3;
// $JUNCTION @ATTACH %j4;
// $JUNCTION @ATTACH %j10;
// $JUNCTION @ATTACH %j11;
// $JUNCTION @ATTACH %j15;
// $JUNCTION @ATTACH %j18;
// $JUNCTION @ATTACH %j20;
// $JUNCTION @ATTACH %j21;
// $JUNCTION @ATTACH %j22;
// $JUNCTION @ATTACH %j23;
// $JUNCTION @ATTACH %j24;
// $JUNCTION @ATTACH %j25;
// $JUNCTION @ATTACH %j30;
// $JUNCTION @ATTACH %j31;
// $JUNCTION @ATTACH %j32;
// $JUNCTION @ATTACH %j33;
// $JUNCTION @ATTACH %j34;
// $JUNCTION @ATTACH %j35;
// $JUNCTION @ATTACH %j36;
// $JUNCTION @ATTACH %j43;
// $JUNCTION @ATTACH %j44;
// $JUNCTION @ATTACH %j45;
// $JUNCTION @ATTACH %j46;
// $JUNCTION @ATTACH %j47;
// $JUNCTION @ATTACH %j51;
// $JUNCTION @ATTACH %j52;
// $JUNCTION @ATTACH %j55;
// $JUNCTION @ATTACH %j56;
// $JUNCTION @ATTACH %j59;
// $JUNCTION @ATTACH %j64;
// $JUNCTION @ATTACH %j74;
// $JUNCTION @ATTACH %j75;
// $JUNCTION @ATTACH %j79;
// $JUNCTION @ATTACH %j87;
// $JUNCTION @ATTACH %j90;
// $JUNCTION @ATTACH %j93;
// $JUNCTION @ATTACH %j96;
// $JUNCTION @ATTACH %j99;
// $JUNCTION @ATTACH %j107;
// $JUNCTION @ATTACH %j113;
// $JUNCTION @ATTACH %j116;
// $JUNCTION @ATTACH %j119;
// $JUNCTION @ATTACH %j122;
// $JUNCTION @ATTACH %j125;
// $JUNCTION @ATTACH %j128;
// $JUNCTION @ATTACH %j131;
// $JUNCTION @ATTACH %j134;
// $JUNCTION @ATTACH %j137;
// $JUNCTION @ATTACH %j140;
// $JUNCTION @ATTACH %j143;
// $JUNCTION @ATTACH %j146;
// $JUNCTION @ATTACH %j147;
// $JUNCTION @ATTACH %j153;
// $JUNCTION @ATTACH %j155;
// $JUNCTION @ATTACH %j158;
// }
ends adc_comp
