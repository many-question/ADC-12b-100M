// Split-stage comparator A6: physical integrator, independent latch and physical clock.
// @RNL(type="header") {
// @VERSION("0.3");
// @USE-PACKAGE(name="adc28", version="0.1", path="../../../rnl/adc28.rnl")
// }
simulator lang=spectre
subckt adc_comp (INP INN CLKC OUTP OUTN AVDD VSS)
// All geometry comes from successful device callbacks. No ideal timing or bias elements.
MINP (DP INP FT VSS) nch_ulvt_mac l=3e-08 w=5.6e-05 nf=56 m=1 ad=2.8e-12 as=2.85e-12 pd=6.16e-05 ps=6.37e-05 nrd=0.009138 nrs=0.009138 sa=1.36619e-06 sb=1.36619e-06 sd=1e-07
MINN (DN INN FT VSS) nch_ulvt_mac l=3e-08 w=5.6e-05 nf=56 m=1 ad=2.8e-12 as=2.85e-12 pd=6.16e-05 ps=6.37e-05 nrd=0.009138 nrs=0.009138 sa=1.36619e-06 sb=1.36619e-06 sd=1e-07
MFT1 (FT CKE VSS VSS) nch_ulvt_mac l=3e-08 w=3e-06 nf=3 m=1 ad=1.75e-13 as=1.75e-13 pd=4.35e-06 ps=4.35e-06 nrd=0.136842 nrs=0.136842 sa=1.47042e-07 sb=1.47042e-07 sd=1e-07
MFT2 (FT CKE VSS VSS) nch_ulvt_mac l=3e-08 w=3e-06 nf=3 m=1 ad=1.75e-13 as=1.75e-13 pd=4.35e-06 ps=4.35e-06 nrd=0.136842 nrs=0.136842 sa=1.47042e-07 sb=1.47042e-07 sd=1e-07
MRDP (DP CKF AVDD AVDD) pch_ulvt_mac l=3e-08 w=1.6e-05 nf=16 m=1 ad=8e-13 as=8.5e-13 pd=1.76e-05 ps=1.97e-05 nrd=0.012674 nrs=0.012674 sa=5.01551e-07 sb=5.01551e-07 sd=1e-07
MRDN (DN CKF AVDD AVDD) pch_ulvt_mac l=3e-08 w=1.6e-05 nf=16 m=1 ad=8e-13 as=8.5e-13 pd=1.76e-05 ps=1.97e-05 nrd=0.012674 nrs=0.012674 sa=5.01551e-07 sb=5.01551e-07 sd=1e-07
CDP1 (DP VSS) cfmom_2t nr=52 lr=1e-06 w=5e-08 s=5e-08 stm=1 spm=3 multi=1
CDP2 (DP VSS) cfmom_2t nr=52 lr=1e-06 w=5e-08 s=5e-08 stm=1 spm=3 multi=1
CDP3 (DP VSS) cfmom_2t nr=52 lr=1e-06 w=5e-08 s=5e-08 stm=1 spm=3 multi=1
CDP4 (DP VSS) cfmom_2t nr=52 lr=1e-06 w=5e-08 s=5e-08 stm=1 spm=3 multi=1
CDP5 (DP VSS) cfmom_2t nr=52 lr=1e-06 w=5e-08 s=5e-08 stm=1 spm=3 multi=1
CDN1 (DN VSS) cfmom_2t nr=52 lr=1e-06 w=5e-08 s=5e-08 stm=1 spm=3 multi=1
CDN2 (DN VSS) cfmom_2t nr=52 lr=1e-06 w=5e-08 s=5e-08 stm=1 spm=3 multi=1
CDN3 (DN VSS) cfmom_2t nr=52 lr=1e-06 w=5e-08 s=5e-08 stm=1 spm=3 multi=1
CDN4 (DN VSS) cfmom_2t nr=52 lr=1e-06 w=5e-08 s=5e-08 stm=1 spm=3 multi=1
CDN5 (DN VSS) cfmom_2t nr=52 lr=1e-06 w=5e-08 s=5e-08 stm=1 spm=3 multi=1
MSIP (XP DN ST VSS) nch_ulvt_mac l=3e-08 w=6e-06 nf=6 m=1 ad=3e-13 as=3.5e-13 pd=6.6e-06 ps=8.7e-06 nrd=0.076404 nrs=0.076404 sa=2.39369e-07 sb=2.39369e-07 sd=1e-07
MSIN (XN DP ST VSS) nch_ulvt_mac l=3e-08 w=6e-06 nf=6 m=1 ad=3e-13 as=3.5e-13 pd=6.6e-06 ps=8.7e-06 nrd=0.076404 nrs=0.076404 sa=2.39369e-07 sb=2.39369e-07 sd=1e-07
MST1 (ST CKL VSS VSS) nch_ulvt_mac l=3e-08 w=3e-06 nf=3 m=1 ad=1.75e-13 as=1.75e-13 pd=4.35e-06 ps=4.35e-06 nrd=0.136842 nrs=0.136842 sa=1.47042e-07 sb=1.47042e-07 sd=1e-07
MST2 (ST CKL VSS VSS) nch_ulvt_mac l=3e-08 w=3e-06 nf=3 m=1 ad=1.75e-13 as=1.75e-13 pd=4.35e-06 ps=4.35e-06 nrd=0.136842 nrs=0.136842 sa=1.47042e-07 sb=1.47042e-07 sd=1e-07
MLNP (QP QN XP VSS) nch_ulvt_mac l=3e-08 w=1.2e-05 nf=12 m=1 ad=6e-13 as=6.5e-13 pd=1.32e-05 ps=1.53e-05 nrd=0.040569 nrs=0.040569 sa=4.01767e-07 sb=4.01767e-07 sd=1e-07
MLNN (QN QP XN VSS) nch_ulvt_mac l=3e-08 w=1.2e-05 nf=12 m=1 ad=6e-13 as=6.5e-13 pd=1.32e-05 ps=1.53e-05 nrd=0.040569 nrs=0.040569 sa=4.01767e-07 sb=4.01767e-07 sd=1e-07
MLPP (QP QN AVDD AVDD) pch_ulvt_mac l=3e-08 w=8e-06 nf=8 m=1 ad=4e-13 as=4.5e-13 pd=8.8e-06 ps=1.09e-05 nrd=0.024976 nrs=0.024976 sa=2.95835e-07 sb=2.95835e-07 sd=1e-07
MLPN (QN QP AVDD AVDD) pch_ulvt_mac l=3e-08 w=8e-06 nf=8 m=1 ad=4e-13 as=4.5e-13 pd=8.8e-06 ps=1.09e-05 nrd=0.024976 nrs=0.024976 sa=2.95835e-07 sb=2.95835e-07 sd=1e-07
MRXP (XP CKL AVDD AVDD) pch_ulvt_mac l=3e-08 w=4e-06 nf=4 m=1 ad=2e-13 as=2.5e-13 pd=4.4e-06 ps=6.5e-06 nrd=0.048530 nrs=0.048530 sa=1.79203e-07 sb=1.79203e-07 sd=1e-07
MRXN (XN CKL AVDD AVDD) pch_ulvt_mac l=3e-08 w=4e-06 nf=4 m=1 ad=2e-13 as=2.5e-13 pd=4.4e-06 ps=6.5e-06 nrd=0.048530 nrs=0.048530 sa=1.79203e-07 sb=1.79203e-07 sd=1e-07
MRQP (QP CKL AVDD AVDD) pch_ulvt_mac l=3e-08 w=1.6e-05 nf=16 m=1 ad=8e-13 as=8.5e-13 pd=1.76e-05 ps=1.97e-05 nrd=0.012674 nrs=0.012674 sa=5.01551e-07 sb=5.01551e-07 sd=1e-07
MRQN (QN CKL AVDD AVDD) pch_ulvt_mac l=3e-08 w=1.6e-05 nf=16 m=1 ad=8e-13 as=8.5e-13 pd=1.76e-05 ps=1.97e-05 nrd=0.012674 nrs=0.012674 sa=5.01551e-07 sb=5.01551e-07 sd=1e-07
MOPP (OUTP QP AVDD AVDD) pch_ulvt_mac l=3e-08 w=4e-06 nf=4 m=1 ad=2e-13 as=2.5e-13 pd=4.4e-06 ps=6.5e-06 nrd=0.048530 nrs=0.048530 sa=1.79203e-07 sb=1.79203e-07 sd=1e-07
MOPN (OUTP QP VSS VSS) nch_ulvt_mac l=3e-08 w=3e-06 nf=3 m=1 ad=1.75e-13 as=1.75e-13 pd=4.35e-06 ps=4.35e-06 nrd=0.136842 nrs=0.136842 sa=1.47042e-07 sb=1.47042e-07 sd=1e-07
MONP (OUTN QN AVDD AVDD) pch_ulvt_mac l=3e-08 w=4e-06 nf=4 m=1 ad=2e-13 as=2.5e-13 pd=4.4e-06 ps=6.5e-06 nrd=0.048530 nrs=0.048530 sa=1.79203e-07 sb=1.79203e-07 sd=1e-07
MONN (OUTN QN VSS VSS) nch_ulvt_mac l=3e-08 w=3e-06 nf=3 m=1 ad=1.75e-13 as=1.75e-13 pd=4.35e-06 ps=4.35e-06 nrd=0.136842 nrs=0.136842 sa=1.47042e-07 sb=1.47042e-07 sd=1e-07
MB0P (CKB CLKC AVDD AVDD) pch_ulvt_mac l=3e-08 w=4e-06 nf=4 m=1 ad=2e-13 as=2.5e-13 pd=4.4e-06 ps=6.5e-06 nrd=0.048530 nrs=0.048530 sa=1.79203e-07 sb=1.79203e-07 sd=1e-07
MB0N (CKB CLKC VSS VSS) nch_ulvt_mac l=3e-08 w=2e-06 nf=2 m=1 ad=1e-13 as=1.5e-13 pd=2.2e-06 ps=4.3e-06 nrd=0.185844 nrs=0.185844 sa=1.12742e-07 sb=1.12742e-07 sd=1e-07
MB1P (CKF CKB AVDD AVDD) pch_ulvt_mac l=3e-08 w=8e-06 nf=8 m=1 ad=4e-13 as=4.5e-13 pd=8.8e-06 ps=1.09e-05 nrd=0.024976 nrs=0.024976 sa=2.95835e-07 sb=2.95835e-07 sd=1e-07
MB1N (CKF CKB VSS VSS) nch_ulvt_mac l=3e-08 w=4e-06 nf=4 m=1 ad=2e-13 as=2.5e-13 pd=4.4e-06 ps=6.5e-06 nrd=0.108289 nrs=0.108289 sa=1.79203e-07 sb=1.79203e-07 sd=1e-07
MD3P (D3 CKF AVDD AVDD) pch_ulvt_mac l=3e-08 w=4e-06 nf=4 m=1 ad=2e-13 as=2.5e-13 pd=4.4e-06 ps=6.5e-06 nrd=0.048530 nrs=0.048530 sa=1.79203e-07 sb=1.79203e-07 sd=1e-07
MD3N (D3 CKF VSS VSS) nch_ulvt_mac l=3e-08 w=2e-06 nf=2 m=1 ad=1e-13 as=1.5e-13 pd=2.2e-06 ps=4.3e-06 nrd=0.185844 nrs=0.185844 sa=1.12742e-07 sb=1.12742e-07 sd=1e-07
MD4P (CKD D3 AVDD AVDD) pch_ulvt_mac l=3e-08 w=8e-06 nf=8 m=1 ad=4e-13 as=4.5e-13 pd=8.8e-06 ps=1.09e-05 nrd=0.024976 nrs=0.024976 sa=2.95835e-07 sb=2.95835e-07 sd=1e-07
MD4N (CKD D3 VSS VSS) nch_ulvt_mac l=3e-08 w=4e-06 nf=4 m=1 ad=2e-13 as=2.5e-13 pd=4.4e-06 ps=6.5e-06 nrd=0.108289 nrs=0.108289 sa=1.79203e-07 sb=1.79203e-07 sd=1e-07
MNG1 (CKLB CKD NG VSS) nch_ulvt_mac l=3e-08 w=4e-06 nf=4 m=1 ad=2e-13 as=2.5e-13 pd=4.4e-06 ps=6.5e-06 nrd=0.108289 nrs=0.108289 sa=1.79203e-07 sb=1.79203e-07 sd=1e-07
MNG2 (NG CLKC VSS VSS) nch_ulvt_mac l=3e-08 w=4e-06 nf=4 m=1 ad=2e-13 as=2.5e-13 pd=4.4e-06 ps=6.5e-06 nrd=0.108289 nrs=0.108289 sa=1.79203e-07 sb=1.79203e-07 sd=1e-07
MPG1 (CKLB CLKC AVDD AVDD) pch_ulvt_mac l=3e-08 w=4e-06 nf=4 m=1 ad=2e-13 as=2.5e-13 pd=4.4e-06 ps=6.5e-06 nrd=0.048530 nrs=0.048530 sa=1.79203e-07 sb=1.79203e-07 sd=1e-07
MPG2 (CKLB CKD AVDD AVDD) pch_ulvt_mac l=3e-08 w=4e-06 nf=4 m=1 ad=2e-13 as=2.5e-13 pd=4.4e-06 ps=6.5e-06 nrd=0.048530 nrs=0.048530 sa=1.79203e-07 sb=1.79203e-07 sd=1e-07
MLBP (CKL CKLB AVDD AVDD) pch_ulvt_mac l=3e-08 w=1.6e-05 nf=16 m=1 ad=8e-13 as=8.5e-13 pd=1.76e-05 ps=1.97e-05 nrd=0.012674 nrs=0.012674 sa=5.01551e-07 sb=5.01551e-07 sd=1e-07
MLBN (CKL CKLB VSS VSS) nch_ulvt_mac l=3e-08 w=8e-06 nf=8 m=1 ad=4e-13 as=4.5e-13 pd=8.8e-06 ps=1.09e-05 nrd=0.059025 nrs=0.059025 sa=2.95835e-07 sb=2.95835e-07 sd=1e-07
MHEP1 (HP CKB AVDD AVDD) pch_ulvt_mac l=3e-08 w=8e-06 nf=8 m=1 ad=4e-13 as=4.5e-13 pd=8.8e-06 ps=1.09e-05 nrd=0.024976 nrs=0.024976 sa=2.95835e-07 sb=2.95835e-07 sd=1e-07
MHEP2 (CKE CKL HP AVDD) pch_ulvt_mac l=3e-08 w=8e-06 nf=8 m=1 ad=4e-13 as=4.5e-13 pd=8.8e-06 ps=1.09e-05 nrd=0.024976 nrs=0.024976 sa=2.95835e-07 sb=2.95835e-07 sd=1e-07
MHEN1 (CKE CKB VSS VSS) nch_ulvt_mac l=3e-08 w=4e-06 nf=4 m=1 ad=2e-13 as=2.5e-13 pd=4.4e-06 ps=6.5e-06 nrd=0.108289 nrs=0.108289 sa=1.79203e-07 sb=1.79203e-07 sd=1e-07
MHEN2 (CKE CKL VSS VSS) nch_ulvt_mac l=3e-08 w=4e-06 nf=4 m=1 ad=2e-13 as=2.5e-13 pd=4.4e-06 ps=6.5e-06 nrd=0.108289 nrs=0.108289 sa=1.79203e-07 sb=1.79203e-07 sd=1e-07
// @RNL(author="a6-gallery-layout") {
// # @SELECT-INSTANCE => @TEXT("",key="model");
// # @SELECT-TERMINAL => @REMOVE-FROM $GROUND_FILL_SET;
// # @SELECT-TERMINAL => @REMOVE-FROM $SUPPLY_FILL_SET;
// # @SELECT-NET(port=true) => @REMOVE-FROM $PORT_FILL_SET;
// $LOGIC2 = @DEFINE(roles=[["a","net"],["y","net"]]) {};
// $LOGIC3 = @DEFINE(roles=[["a","net"],["b","net"],["y","net"]]) {};
// $A6_COMPARATOR = @DEFINE-SYMBOL(box=[-8,-7,7,7]) {
//  (-8,2) @PIN(terminal="INP",direction="left"); (-8,-2) @PIN(terminal="INN",direction="left");
//  (-4,-7) @PIN(terminal="CLKC",direction="down");
//  (7,1) @PIN(terminal="OUTP",direction="right"); (7,-1) @PIN(terminal="OUTN",direction="right");
//  (-1,7) @PIN(terminal="AVDD",direction="up"); (-1,-7) @PIN(terminal="VSS",direction="down");
//  @LINE(linewidth=.18) {(-6,-5) (-6,5) (4,2) (4,-2) (-6,-5)};
//  @LINE {(-8,2) (-6,2)}; @LINE {(-8,-2) (-6,-2)};
//  @LINE {(4,1) (7,1)}; @LINE {(4,-1) (7,-1)};
//  @LINE {(-4,-7) (-4,-4.4)}; @LINE {(-5,-4.7) (-4,-3.7) (-3,-4.1)};
//  @LINE {(-1,7) (-1,3.5)}; @LINE {(-1,-3.5) (-1,-7)};
//  (-5.3,1.7) @TEXT("+",size=1.2); (-5.3,-2.3) @TEXT("-",size=1.2);
//  (2,.9) @TEXT("+",size=.9); (2,-2.1) @TEXT("-",size=.9);
//  (-2,0) @TEXT("A6",size=1.1,bold=true,halign="middle");
//  ? @TEXT("${name}",key="name",size=1.1,halign="end") => @PLACE(-7,6)
// }; # @SET-SYMBOL $A6_COMPARATOR;
// $paper = @DEFINE-STYLE(font="Arial",textcolor="#1d2734",linecolor="#1d2734",linewidth=.12) {};
// $device = @DEFINE-STYLE(font="Arial",textcolor="#304c61",linecolor="#17643e",linewidth=.14) {};
// # @SELECT-INSTANCE => @SET-STYLE $device; # @SELECT-USAGE => @SET-STYLE $paper;
// # @SELECT-LABEL => @SET-STYLE $paper; # @SELECT-ANNOTATION => @SET-STYLE $paper; # @SELECT-WIRE => @SET-STYLE $paper;
// (-4,72) @TEXT("A6  /  two-stage dynamic comparator",size=2.1,bold=true,halign="start");
// (-4,68) @TEXT("W in um  |  L = 30 nm  |  NMOS bulk: VSS  /  PMOS bulk: AVDD",size=1.2,bold=false,halign="start");
// (-4,63) @TEXT("01  Integrator",size=1.7,bold=true,halign="start");
// (74,63) @TEXT("02  Regenerative latch",size=1.7,bold=true,halign="start");
// (141,63) @TEXT("03  Outputs",size=1.7,bold=true,halign="start");
// #MRDP @SET-SYMBOL $PMOS; #MRDP @PLACE(18,48) => @ORIENT("R0");
// #MRDP @TEXT("MRDP",key="name",size=1.2,dx=1,dy=1.5,halign="start");
// #MRDP @TEXT("W16",key="dims",size=1.1,dx=1,dy=-1.6,halign="start");
// #MRDN @SET-SYMBOL $PMOS; #MRDN @PLACE(42,48) => @ORIENT("MY");
// #MRDN @TEXT("MRDN",key="name",size=1.2,dx=-1,dy=1.5,halign="end");
// #MRDN @TEXT("W16",key="dims",size=1.1,dx=-1,dy=-1.6,halign="end");
// #MINP @SET-SYMBOL $NMOS; #MINP @PLACE(18,36) => @ORIENT("R0");
// #MINP @TEXT("MINP",key="name",size=1.2,dx=1,dy=1.5,halign="start");
// #MINP @TEXT("W56",key="dims",size=1.1,dx=1,dy=-1.6,halign="start");
// #MINN @SET-SYMBOL $NMOS; #MINN @PLACE(42,36) => @ORIENT("MY");
// #MINN @TEXT("MINN",key="name",size=1.2,dx=-1,dy=1.5,halign="end");
// #MINN @TEXT("W56",key="dims",size=1.1,dx=-1,dy=-1.6,halign="end");
// #MFT1 @SET-SYMBOL $NMOS; #MFT1 @PLACE(25,24) => @ORIENT("R0");
// #MFT1 @TEXT("MFT1",key="name",size=1.2,dx=1,dy=1.5,halign="start");
// #MFT1 @TEXT("W3",key="dims",size=1.1,dx=1,dy=-1.6,halign="start");
// #MFT2 @SET-SYMBOL $NMOS; #MFT2 @PLACE(35,24) => @ORIENT("MY");
// #MFT2 @TEXT("MFT2",key="name",size=1.2,dx=-1,dy=1.5,halign="end");
// #MFT2 @TEXT("W3",key="dims",size=1.1,dx=-1,dy=-1.6,halign="end");
// %v0 = $SUPPLY @ATTACH &AVDD => @PLACE(30,57);
// (19,43) @TEXT("DP",size=1.2,bold=true,halign="start");
// (41,43) @TEXT("DN",size=1.2,bold=true,halign="end");
// (11.3,48.35) @TEXT("CKF",size=1.2,bold=true,halign="end");
// (48.7,48.35) @TEXT("CKF",size=1.2,bold=true,halign="start");
// (11.3,36.35) @TEXT("INP",size=1.2,bold=true,halign="end");
// (48.7,36.35) @TEXT("INN",size=1.2,bold=true,halign="start");
// (18.3,24.35) @TEXT("CKE",size=1.2,bold=true,halign="end");
// (41.7,24.35) @TEXT("CKE",size=1.2,bold=true,halign="start");
// %v1 = $GROUND @ATTACH &VSS => @PLACE(30,17);
// (30,31) @TEXT("FT",size=1.2,bold=true,halign="middle");
// #CDP1 @SET-SYMBOL $CAPACITOR; #CDP1 @PLACE(0,9);
// #CDP1 @TEXT("CDP1",key="name",size=.95,dx=1.1,dy=-1.7,halign="start");
// #CDP1 @TEXT("",key="value");
// #CDP2 @SET-SYMBOL $CAPACITOR; #CDP2 @PLACE(5,9);
// #CDP2 @TEXT("CDP2",key="name",size=.95,dx=1.1,dy=-1.7,halign="start");
// #CDP2 @TEXT("",key="value");
// #CDP3 @SET-SYMBOL $CAPACITOR; #CDP3 @PLACE(10,9);
// #CDP3 @TEXT("CDP3",key="name",size=.95,dx=1.1,dy=-1.7,halign="start");
// #CDP3 @TEXT("",key="value");
// #CDP4 @SET-SYMBOL $CAPACITOR; #CDP4 @PLACE(15,9);
// #CDP4 @TEXT("CDP4",key="name",size=.95,dx=1.1,dy=-1.7,halign="start");
// #CDP4 @TEXT("",key="value");
// #CDP5 @SET-SYMBOL $CAPACITOR; #CDP5 @PLACE(20,9);
// #CDP5 @TEXT("CDP5",key="name",size=.95,dx=1.1,dy=-1.7,halign="start");
// #CDP5 @TEXT("",key="value");
// %v2 = $GROUND @ATTACH &VSS => @PLACE(10,1);
// (10,-4) @TEXT("5 x MOM / nr52 / lr1 um",size=1,bold=false,halign="middle");
// #CDN1 @SET-SYMBOL $CAPACITOR; #CDN1 @PLACE(40,9);
// #CDN1 @TEXT("CDN1",key="name",size=.95,dx=1.1,dy=-1.7,halign="start");
// #CDN1 @TEXT("",key="value");
// #CDN2 @SET-SYMBOL $CAPACITOR; #CDN2 @PLACE(45,9);
// #CDN2 @TEXT("CDN2",key="name",size=.95,dx=1.1,dy=-1.7,halign="start");
// #CDN2 @TEXT("",key="value");
// #CDN3 @SET-SYMBOL $CAPACITOR; #CDN3 @PLACE(50,9);
// #CDN3 @TEXT("CDN3",key="name",size=.95,dx=1.1,dy=-1.7,halign="start");
// #CDN3 @TEXT("",key="value");
// #CDN4 @SET-SYMBOL $CAPACITOR; #CDN4 @PLACE(55,9);
// #CDN4 @TEXT("CDN4",key="name",size=.95,dx=1.1,dy=-1.7,halign="start");
// #CDN4 @TEXT("",key="value");
// #CDN5 @SET-SYMBOL $CAPACITOR; #CDN5 @PLACE(60,9);
// #CDN5 @TEXT("CDN5",key="name",size=.95,dx=1.1,dy=-1.7,halign="start");
// #CDN5 @TEXT("",key="value");
// %v3 = $GROUND @ATTACH &VSS => @PLACE(50,1);
// (50,-4) @TEXT("5 x MOM / nr52 / lr1 um",size=1,bold=false,halign="middle");
// #MLPP @SET-SYMBOL $PMOS; #MLPP @PLACE(90,48) => @ORIENT("MY");
// #MLPP @TEXT("MLPP",key="name",size=1.2,dx=-1,dy=1.5,halign="end");
// #MLPP @TEXT("W8",key="dims",size=1.1,dx=-1,dy=-1.6,halign="end");
// #MLPN @SET-SYMBOL $PMOS; #MLPN @PLACE(114,48) => @ORIENT("R0");
// #MLPN @TEXT("MLPN",key="name",size=1.2,dx=1,dy=1.5,halign="start");
// #MLPN @TEXT("W8",key="dims",size=1.1,dx=1,dy=-1.6,halign="start");
// #MLNP @SET-SYMBOL $NMOS; #MLNP @PLACE(90,36) => @ORIENT("MY");
// #MLNP @TEXT("MLNP",key="name",size=1.2,dx=-1,dy=1.5,halign="end");
// #MLNP @TEXT("W12",key="dims",size=1.1,dx=-1,dy=-1.6,halign="end");
// #MLNN @SET-SYMBOL $NMOS; #MLNN @PLACE(114,36) => @ORIENT("R0");
// #MLNN @TEXT("MLNN",key="name",size=1.2,dx=1,dy=1.5,halign="start");
// #MLNN @TEXT("W12",key="dims",size=1.1,dx=1,dy=-1.6,halign="start");
// #MSIP @SET-SYMBOL $NMOS; #MSIP @PLACE(90,24) => @ORIENT("R0");
// #MSIP @TEXT("MSIP",key="name",size=1.2,dx=1,dy=1.5,halign="start");
// #MSIP @TEXT("W6",key="dims",size=1.1,dx=1,dy=-1.6,halign="start");
// #MSIN @SET-SYMBOL $NMOS; #MSIN @PLACE(114,24) => @ORIENT("MY");
// #MSIN @TEXT("MSIN",key="name",size=1.2,dx=-1,dy=1.5,halign="end");
// #MSIN @TEXT("W6",key="dims",size=1.1,dx=-1,dy=-1.6,halign="end");
// #MRQP @SET-SYMBOL $PMOS; #MRQP @PLACE(78,48) => @ORIENT("R0");
// #MRQP @TEXT("MRQP",key="name",size=1.2,dx=1,dy=1.5,halign="start");
// #MRQP @TEXT("W16",key="dims",size=1.1,dx=1,dy=-1.6,halign="start");
// #MRQN @SET-SYMBOL $PMOS; #MRQN @PLACE(126,48) => @ORIENT("MY");
// #MRQN @TEXT("MRQN",key="name",size=1.2,dx=-1,dy=1.5,halign="end");
// #MRQN @TEXT("W16",key="dims",size=1.1,dx=-1,dy=-1.6,halign="end");
// #MRXP @SET-SYMBOL $PMOS; #MRXP @PLACE(78,30) => @ORIENT("R0");
// #MRXP @TEXT("MRXP",key="name",size=1.2,dx=1,dy=1.5,halign="start");
// #MRXP @TEXT("W4",key="dims",size=1.1,dx=1,dy=-1.6,halign="start");
// #MRXN @SET-SYMBOL $PMOS; #MRXN @PLACE(126,30) => @ORIENT("MY");
// #MRXN @TEXT("MRXN",key="name",size=1.2,dx=-1,dy=1.5,halign="end");
// #MRXN @TEXT("W4",key="dims",size=1.1,dx=-1,dy=-1.6,halign="end");
// #MST1 @SET-SYMBOL $NMOS; #MST1 @PLACE(97,12) => @ORIENT("R0");
// #MST1 @TEXT("MST1",key="name",size=1.2,dx=1,dy=1.5,halign="start");
// #MST1 @TEXT("W3",key="dims",size=1.1,dx=1,dy=-1.6,halign="start");
// #MST2 @SET-SYMBOL $NMOS; #MST2 @PLACE(107,12) => @ORIENT("MY");
// #MST2 @TEXT("MST2",key="name",size=1.2,dx=-1,dy=1.5,halign="end");
// #MST2 @TEXT("W3",key="dims",size=1.1,dx=-1,dy=-1.6,halign="end");
// %v4 = $SUPPLY @ATTACH &AVDD => @PLACE(102,57);
// (84,43) @TEXT("QP",size=1.2,bold=true,halign="middle");
// (120,43) @TEXT("QN",size=1.2,bold=true,halign="middle");
// (91,29) @TEXT("XP",size=1.1,bold=false,halign="start");
// (113,29) @TEXT("XN",size=1.1,bold=false,halign="end");
// (72.3,48.35) @TEXT("CKL",size=1.2,bold=true,halign="end");
// (131.7,48.35) @TEXT("CKL",size=1.2,bold=true,halign="start");
// (72.3,30.35) @TEXT("CKL",size=1.2,bold=true,halign="end");
// (131.7,30.35) @TEXT("CKL",size=1.2,bold=true,halign="start");
// (83.3,24.35) @TEXT("DN",size=1.2,bold=true,halign="end");
// (120.7,24.35) @TEXT("DP",size=1.2,bold=true,halign="start");
// (102,19) @TEXT("ST",size=1.2,bold=true,halign="middle");
// %v5 = $GROUND @ATTACH &VSS => @PLACE(102,4);
// (90.3,12.35) @TEXT("CKL",size=1.2,bold=true,halign="end");
// (113.7,12.35) @TEXT("CKL",size=1.2,bold=true,halign="start");
// (145,58) @TEXT("",size=1.3,bold=true,halign="start");
// #MOPP @SET-SYMBOL $PMOS; #MOPP @PLACE(152,51) => @ORIENT("R0");
// #MOPP @TEXT("MOPP",key="name",size=1.2,dx=1,dy=1.5,halign="start");
// #MOPP @TEXT("W4",key="dims",size=1.1,dx=1,dy=-1.6,halign="start");
// #MOPN @SET-SYMBOL $NMOS; #MOPN @PLACE(152,41) => @ORIENT("R0");
// #MOPN @TEXT("MOPN",key="name",size=1.2,dx=1,dy=1.5,halign="start");
// #MOPN @TEXT("W3",key="dims",size=1.1,dx=1,dy=-1.6,halign="start");
// %v6 = $SUPPLY @ATTACH &AVDD => @PLACE(152,55);
// %v7 = $GROUND @ATTACH &VSS => @PLACE(152,37);
// (142.5,46.5) @TEXT("QP",size=1.2,bold=true,halign="end");
// (159.5,46.4) @TEXT("OUTP",size=1.2,bold=true,halign="start");
// (145,32) @TEXT("",size=1.3,bold=true,halign="start");
// #MONP @SET-SYMBOL $PMOS; #MONP @PLACE(152,25) => @ORIENT("R0");
// #MONP @TEXT("MONP",key="name",size=1.2,dx=1,dy=1.5,halign="start");
// #MONP @TEXT("W4",key="dims",size=1.1,dx=1,dy=-1.6,halign="start");
// #MONN @SET-SYMBOL $NMOS; #MONN @PLACE(152,15) => @ORIENT("R0");
// #MONN @TEXT("MONN",key="name",size=1.2,dx=1,dy=1.5,halign="start");
// #MONN @TEXT("W3",key="dims",size=1.1,dx=1,dy=-1.6,halign="start");
// %v8 = $SUPPLY @ATTACH &AVDD => @PLACE(152,29);
// %v9 = $GROUND @ATTACH &VSS => @PLACE(152,11);
// (142.5,20.5) @TEXT("QN",size=1.2,bold=true,halign="end");
// (159.5,20.4) @TEXT("OUTN",size=1.2,bold=true,halign="start");
// (148,-4) @TEXT("Reset to 0",size=1.1,bold=false,halign="start");
// (-4,-13) @TEXT("Clock function",size=1.7,bold=true,halign="start");
// %b0 = &CLKC &CKB @AS $LOGIC2 => @SET-SYMBOL $INVERTER => @PLACE(10,-24);
// %b0 @TEXT("MB0",key="name",size=1.1,dx=0,dy=3.6,halign="middle");
// %b1 = &CKB &CKF @AS $LOGIC2 => @SET-SYMBOL $INVERTER => @PLACE(30,-24);
// %b1 @TEXT("MB1",key="name",size=1.1,dx=0,dy=3.6,halign="middle");
// %d3 = &CKF &D3 @AS $LOGIC2 => @SET-SYMBOL $INVERTER => @PLACE(50,-24);
// %d3 @TEXT("MD3",key="name",size=1.1,dx=0,dy=3.6,halign="middle");
// %d4 = &D3 &CKD @AS $LOGIC2 => @SET-SYMBOL $INVERTER => @PLACE(70,-24);
// %d4 @TEXT("MD4",key="name",size=1.1,dx=0,dy=3.6,halign="middle");
// %nand = &CLKC &CKD &CKLB @AS $LOGIC3 => @SET-SYMBOL $NAND_2INPUT => @PLACE(98,-24);
// %nand @TEXT("NAND2",key="name",size=1.1,dx=0,dy=3.6,halign="middle");
// %lb = &CKLB &CKL @AS $LOGIC2 => @SET-SYMBOL $INVERTER => @PLACE(124,-24);
// %lb @TEXT("MLB",key="name",size=1.1,dx=0,dy=3.6,halign="middle");
// %nor = &CKB &CKL &CKE @AS $LOGIC3 => @SET-SYMBOL $NOR_2INPUT => @PLACE(150,-24);
// %nor @TEXT("NOR2",key="name",size=1.1,dx=0,dy=3.6,halign="middle");
// (-4,-23) @TEXT("CLKC",size=1.2,bold=true,halign="start");
// (19,-22.5) @TEXT("CKB",size=1.1,bold=true,halign="middle");
// (39,-22.5) @TEXT("CKF",size=1.1,bold=true,halign="middle");
// (59,-22.5) @TEXT("D3",size=1.1,bold=true,halign="middle");
// (80,-22.5) @TEXT("CKD",size=1.1,bold=true,halign="middle");
// (111,-22.5) @TEXT("CKLB",size=1.1,bold=true,halign="middle");
// (134,-22.5) @TEXT("CKL",size=1.1,bold=true,halign="middle");
// (160,-23.5) @TEXT("CKE",size=1.2,bold=true,halign="start");
// (-4,-36) @TEXT("CKF: precharge  /  CKL = CLKC AND CKD  /  CKE = NOR(CKB, CKL)",size=1.2,bold=false,halign="start");
// (-4,-44) @TEXT("Clock implementation",size=1.7,bold=true,halign="start");
// (7,-50) @TEXT("MB0",size=1.3,bold=true,halign="start");
// #MB0P @SET-SYMBOL $PMOS; #MB0P @PLACE(14,-57) => @ORIENT("R0");
// #MB0P @TEXT("MB0P",key="name",size=1.2,dx=1,dy=1.5,halign="start");
// #MB0P @TEXT("W4",key="dims",size=1.1,dx=1,dy=-1.6,halign="start");
// #MB0N @SET-SYMBOL $NMOS; #MB0N @PLACE(14,-67) => @ORIENT("R0");
// #MB0N @TEXT("MB0N",key="name",size=1.2,dx=1,dy=1.5,halign="start");
// #MB0N @TEXT("W2",key="dims",size=1.1,dx=1,dy=-1.6,halign="start");
// %v10 = $SUPPLY @ATTACH &AVDD => @PLACE(14,-53);
// %v11 = $GROUND @ATTACH &VSS => @PLACE(14,-71);
// (4.5,-61.5) @TEXT("CLKC",size=1.2,bold=true,halign="end");
// (21.5,-61.6) @TEXT("CKB",size=1.2,bold=true,halign="start");
// (47,-50) @TEXT("MB1",size=1.3,bold=true,halign="start");
// #MB1P @SET-SYMBOL $PMOS; #MB1P @PLACE(54,-57) => @ORIENT("R0");
// #MB1P @TEXT("MB1P",key="name",size=1.2,dx=1,dy=1.5,halign="start");
// #MB1P @TEXT("W8",key="dims",size=1.1,dx=1,dy=-1.6,halign="start");
// #MB1N @SET-SYMBOL $NMOS; #MB1N @PLACE(54,-67) => @ORIENT("R0");
// #MB1N @TEXT("MB1N",key="name",size=1.2,dx=1,dy=1.5,halign="start");
// #MB1N @TEXT("W4",key="dims",size=1.1,dx=1,dy=-1.6,halign="start");
// %v12 = $SUPPLY @ATTACH &AVDD => @PLACE(54,-53);
// %v13 = $GROUND @ATTACH &VSS => @PLACE(54,-71);
// (44.5,-61.5) @TEXT("CKB",size=1.2,bold=true,halign="end");
// (61.5,-61.6) @TEXT("CKF",size=1.2,bold=true,halign="start");
// (87,-50) @TEXT("MD3",size=1.3,bold=true,halign="start");
// #MD3P @SET-SYMBOL $PMOS; #MD3P @PLACE(94,-57) => @ORIENT("R0");
// #MD3P @TEXT("MD3P",key="name",size=1.2,dx=1,dy=1.5,halign="start");
// #MD3P @TEXT("W4",key="dims",size=1.1,dx=1,dy=-1.6,halign="start");
// #MD3N @SET-SYMBOL $NMOS; #MD3N @PLACE(94,-67) => @ORIENT("R0");
// #MD3N @TEXT("MD3N",key="name",size=1.2,dx=1,dy=1.5,halign="start");
// #MD3N @TEXT("W2",key="dims",size=1.1,dx=1,dy=-1.6,halign="start");
// %v14 = $SUPPLY @ATTACH &AVDD => @PLACE(94,-53);
// %v15 = $GROUND @ATTACH &VSS => @PLACE(94,-71);
// (84.5,-61.5) @TEXT("CKF",size=1.2,bold=true,halign="end");
// (101.5,-61.6) @TEXT("D3",size=1.2,bold=true,halign="start");
// (127,-50) @TEXT("MD4",size=1.3,bold=true,halign="start");
// #MD4P @SET-SYMBOL $PMOS; #MD4P @PLACE(134,-57) => @ORIENT("R0");
// #MD4P @TEXT("MD4P",key="name",size=1.2,dx=1,dy=1.5,halign="start");
// #MD4P @TEXT("W8",key="dims",size=1.1,dx=1,dy=-1.6,halign="start");
// #MD4N @SET-SYMBOL $NMOS; #MD4N @PLACE(134,-67) => @ORIENT("R0");
// #MD4N @TEXT("MD4N",key="name",size=1.2,dx=1,dy=1.5,halign="start");
// #MD4N @TEXT("W4",key="dims",size=1.1,dx=1,dy=-1.6,halign="start");
// %v16 = $SUPPLY @ATTACH &AVDD => @PLACE(134,-53);
// %v17 = $GROUND @ATTACH &VSS => @PLACE(134,-71);
// (124.5,-61.5) @TEXT("D3",size=1.2,bold=true,halign="end");
// (141.5,-61.6) @TEXT("CKD",size=1.2,bold=true,halign="start");
// (1,-82) @TEXT("NAND2",size=1.3,bold=true,halign="start");
// #MPG1 @SET-SYMBOL $PMOS; #MPG1 @PLACE(14,-90) => @ORIENT("R0");
// #MPG1 @TEXT("MPG1",key="name",size=1.2,dx=1,dy=1.5,halign="start");
// #MPG1 @TEXT("W4",key="dims",size=1.1,dx=1,dy=-1.6,halign="start");
// #MPG2 @SET-SYMBOL $PMOS; #MPG2 @PLACE(30,-90) => @ORIENT("MY");
// #MPG2 @TEXT("MPG2",key="name",size=1.2,dx=-1,dy=1.5,halign="end");
// #MPG2 @TEXT("W4",key="dims",size=1.1,dx=-1,dy=-1.6,halign="end");
// #MNG1 @SET-SYMBOL $NMOS; #MNG1 @PLACE(22,-102) => @ORIENT("R0");
// #MNG1 @TEXT("MNG1",key="name",size=1.2,dx=1,dy=1.5,halign="start");
// #MNG1 @TEXT("W4",key="dims",size=1.1,dx=1,dy=-1.6,halign="start");
// #MNG2 @SET-SYMBOL $NMOS; #MNG2 @PLACE(22,-112) => @ORIENT("R0");
// #MNG2 @TEXT("MNG2",key="name",size=1.2,dx=1,dy=1.5,halign="start");
// #MNG2 @TEXT("W4",key="dims",size=1.1,dx=1,dy=-1.6,halign="start");
// %v18 = $SUPPLY @ATTACH &AVDD => @PLACE(22,-82);
// (39,-95.5) @TEXT("CKLB",size=1.2,bold=true,halign="start");
// (23,-107) @TEXT("NG",size=1.1,bold=false,halign="start");
// %v19 = $GROUND @ATTACH &VSS => @PLACE(22,-118);
// (8.3,-89.65) @TEXT("CLKC",size=1.2,bold=true,halign="end");
// (35.7,-89.65) @TEXT("CKD",size=1.2,bold=true,halign="start");
// (16.3,-101.65) @TEXT("CKD",size=1.2,bold=true,halign="end");
// (16.3,-111.65) @TEXT("CLKC",size=1.2,bold=true,halign="end");
// (69,-89) @TEXT("",size=1.3,bold=true,halign="start");
// #MLBP @SET-SYMBOL $PMOS; #MLBP @PLACE(76,-96) => @ORIENT("R0");
// #MLBP @TEXT("MLBP",key="name",size=1.2,dx=1,dy=1.5,halign="start");
// #MLBP @TEXT("W16",key="dims",size=1.1,dx=1,dy=-1.6,halign="start");
// #MLBN @SET-SYMBOL $NMOS; #MLBN @PLACE(76,-106) => @ORIENT("R0");
// #MLBN @TEXT("MLBN",key="name",size=1.2,dx=1,dy=1.5,halign="start");
// #MLBN @TEXT("W8",key="dims",size=1.1,dx=1,dy=-1.6,halign="start");
// %v20 = $SUPPLY @ATTACH &AVDD => @PLACE(76,-92);
// %v21 = $GROUND @ATTACH &VSS => @PLACE(76,-110);
// (66.5,-100.5) @TEXT("CKLB",size=1.2,bold=true,halign="end");
// (83.5,-100.6) @TEXT("CKL",size=1.2,bold=true,halign="start");
// (62,-82) @TEXT("MLB / latch driver",size=1.3,bold=true,halign="start");
// (111,-82) @TEXT("NOR2 / front enable",size=1.3,bold=true,halign="start");
// #MHEP1 @SET-SYMBOL $PMOS; #MHEP1 @PLACE(134,-90) => @ORIENT("R0");
// #MHEP1 @TEXT("MHEP1",key="name",size=1.2,dx=1,dy=1.5,halign="start");
// #MHEP1 @TEXT("W8",key="dims",size=1.1,dx=1,dy=-1.6,halign="start");
// #MHEP2 @SET-SYMBOL $PMOS; #MHEP2 @PLACE(134,-100) => @ORIENT("R0");
// #MHEP2 @TEXT("MHEP2",key="name",size=1.2,dx=1,dy=1.5,halign="start");
// #MHEP2 @TEXT("W8",key="dims",size=1.1,dx=1,dy=-1.6,halign="start");
// #MHEN1 @SET-SYMBOL $NMOS; #MHEN1 @PLACE(126,-114) => @ORIENT("R0");
// #MHEN1 @TEXT("MHEN1",key="name",size=1.2,dx=1,dy=1.5,halign="start");
// #MHEN1 @TEXT("W4",key="dims",size=1.1,dx=1,dy=-1.6,halign="start");
// #MHEN2 @SET-SYMBOL $NMOS; #MHEN2 @PLACE(142,-114) => @ORIENT("MY");
// #MHEN2 @TEXT("MHEN2",key="name",size=1.2,dx=-1,dy=1.5,halign="end");
// #MHEN2 @TEXT("W4",key="dims",size=1.1,dx=-1,dy=-1.6,halign="end");
// %v22 = $SUPPLY @ATTACH &AVDD => @PLACE(134,-85);
// (135,-95) @TEXT("HP",size=1.1,bold=false,halign="start");
// (154,-106.5) @TEXT("CKE",size=1.2,bold=true,halign="start");
// %v23 = $GROUND @ATTACH &VSS => @PLACE(134,-123);
// (127.3,-89.65) @TEXT("CKB",size=1.2,bold=true,halign="end");
// (127.3,-99.65) @TEXT("CKL",size=1.2,bold=true,halign="end");
// (119.3,-113.65) @TEXT("CKB",size=1.2,bold=true,halign="end");
// (148.7,-113.65) @TEXT("CKL",size=1.2,bold=true,halign="start");
// {#MINP #MINN} @AS $MATCHED;
// {#MSIP #MSIN} @AS $MATCHED;
// {#MRDP #MRDN} @AS $MATCHED;
// {#MFT1 #MFT2} @AS $MATCHED;
// {#MST1 #MST2} @AS $MATCHED;
// {#MLNP #MLNN} @AS $MATCHED;
// {#MLPP #MLPN} @AS $MATCHED;
// {#MRXP #MRXN} @AS $MATCHED;
// {#MRQP #MRQN} @AS $MATCHED;
// #MINP(in_p) #MINN(in_n) @AS $DIFFERENTIAL_PAIR; #MSIP(in_p) #MSIN(in_n) @AS $DIFFERENTIAL_PAIR;
// {#MINP #MINN #MFT1 #MFT2 #MRDP #MRDN #CDP1 #CDP2 #CDP3 #CDP4 #CDP5 #CDN1 #CDN2 #CDN3 #CDN4 #CDN5} @GROUP;
// {#MSIP #MSIN #MST1 #MST2 #MLNP #MLNN #MLPP #MLPN #MRXP #MRXN #MRQP #MRQN} @GROUP;
// {#MB0P #MB0N #MB1P #MB1N #MD3P #MD3N #MD4P #MD4N #MNG1 #MNG2 #MPG1 #MPG2 #MLBP #MLBN #MHEP1 #MHEP2 #MHEN1 #MHEN2} @GROUP;
// %j0 = (18,55);
// %j1 = (30,55);
// %j2 = (42,55);
// %j3 = (18,42);
// %j4 = (42,42);
// %j5 = (12,48);
// %j6 = (48,48);
// %j7 = (12,36);
// %j8 = (48,36);
// %j9 = (19,24);
// %j10 = (41,24);
// %j11 = (18,30);
// %j12 = (25,30);
// %j13 = (35,30);
// %j14 = (42,30);
// %j15 = (25,19);
// %j16 = (35,19);
// %j17 = (30,19);
// %j18 = (0,14);
// %j19 = (0,3);
// %j20 = (5,14);
// %j21 = (5,3);
// %j22 = (10,14);
// %j23 = (10,3);
// %j24 = (15,14);
// %j25 = (15,3);
// %j26 = (20,14);
// %j27 = (20,3);
// %j28 = (40,14);
// %j29 = (40,3);
// %j30 = (45,14);
// %j31 = (45,3);
// %j32 = (50,14);
// %j33 = (50,3);
// %j34 = (55,14);
// %j35 = (55,3);
// %j36 = (60,14);
// %j37 = (60,3);
// %j38 = (-4,42);
// %j39 = (-4,14);
// %j40 = (64,42);
// %j41 = (64,14);
// %j42 = (67,55);
// %j43 = (78,55);
// %j44 = (90,55);
// %j45 = (102,55);
// %j46 = (114,55);
// %j47 = (126,55);
// %j48 = (137,55);
// %j49 = (67,32);
// %j50 = (137,32);
// %j51 = (90,42);
// %j52 = (114,42);
// %j53 = (78,42);
// %j54 = (126,42);
// %j55 = (94,42);
// %j56 = (94,45);
// %j57 = (108,45);
// %j58 = (108,36);
// %j59 = (108,48);
// %j60 = (110,42);
// %j61 = (110,39);
// %j62 = (96,39);
// %j63 = (96,36);
// %j64 = (96,48);
// %j65 = (90,28);
// %j66 = (114,28);
// %j67 = (73,48);
// %j68 = (131,48);
// %j69 = (73,30);
// %j70 = (131,30);
// %j71 = (84,24);
// %j72 = (120,24);
// %j73 = (90,18);
// %j74 = (97,18);
// %j75 = (107,18);
// %j76 = (114,18);
// %j77 = (97,7);
// %j78 = (107,7);
// %j79 = (102,7);
// %j80 = (91,12);
// %j81 = (113,12);
// %j82 = (147,51);
// %j83 = (147,46);
// %j84 = (147,41);
// %j85 = (143,46);
// %j86 = (152,46);
// %j87 = (159,46);
// %j88 = (147,25);
// %j89 = (147,20);
// %j90 = (147,15);
// %j91 = (143,20);
// %j92 = (152,20);
// %j93 = (159,20);
// %j94 = (-4,-24);
// %j95 = (2,-24);
// %j96 = (2,-16);
// %j97 = (89,-16);
// %j98 = (89,-23);
// %j99 = (84,-24);
// %j100 = (84,-25);
// %j101 = (140,-24);
// %j102 = (140,-25);
// %j103 = (20,-24);
// %j104 = (20,-31);
// %j105 = (143,-31);
// %j106 = (143,-23);
// %j107 = (159,-24);
// %j108 = (9,-57);
// %j109 = (9,-62);
// %j110 = (9,-67);
// %j111 = (5,-62);
// %j112 = (14,-62);
// %j113 = (21,-62);
// %j114 = (49,-57);
// %j115 = (49,-62);
// %j116 = (49,-67);
// %j117 = (45,-62);
// %j118 = (54,-62);
// %j119 = (61,-62);
// %j120 = (89,-57);
// %j121 = (89,-62);
// %j122 = (89,-67);
// %j123 = (85,-62);
// %j124 = (94,-62);
// %j125 = (101,-62);
// %j126 = (129,-57);
// %j127 = (129,-62);
// %j128 = (129,-67);
// %j129 = (125,-62);
// %j130 = (134,-62);
// %j131 = (141,-62);
// %j132 = (14,-85);
// %j133 = (22,-85);
// %j134 = (30,-85);
// %j135 = (14,-96);
// %j136 = (22,-96);
// %j137 = (30,-96);
// %j138 = (38,-96);
// %j139 = (9,-90);
// %j140 = (35,-90);
// %j141 = (17,-102);
// %j142 = (17,-112);
// %j143 = (71,-96);
// %j144 = (71,-101);
// %j145 = (71,-106);
// %j146 = (67,-101);
// %j147 = (76,-101);
// %j148 = (83,-101);
// %j149 = (134,-107);
// %j150 = (126,-107);
// %j151 = (142,-107);
// %j152 = (153,-107);
// %j153 = (126,-120);
// %j154 = (134,-120);
// %j155 = (142,-120);
// %j156 = (128,-90);
// %j157 = (128,-100);
// %j158 = (120,-114);
// %j159 = (148,-114);
// &AVDD @WIRE(mode="straight") {#MRDP:3 %j0 %j1 %j2 #MRDN:3};
// &AVDD @WIRE(mode="straight") {%j1 %v0:p};
// &DP @WIRE(mode="straight") {#MRDP:1 %j3 #MINP:1};
// &DN @WIRE(mode="straight") {#MRDN:1 %j4 #MINN:1};
// &CKF @WIRE(mode="straight") {#MRDP:2 %j5};
// &CKF @WIRE(mode="straight") {#MRDN:2 %j6};
// &INP @WIRE(mode="straight") {#MINP:2 %j7};
// &INN @WIRE(mode="straight") {#MINN:2 %j8};
// &CKE @WIRE(mode="straight") {#MFT1:2 %j9};
// &CKE @WIRE(mode="straight") {#MFT2:2 %j10};
// &FT @WIRE(mode="straight") {#MINP:3 %j11 %j12 %j13 %j14 #MINN:3};
// &FT @WIRE(mode="straight") {%j12 #MFT1:1};
// &VSS @WIRE(mode="straight") {#MFT1:3 %j15};
// &FT @WIRE(mode="straight") {%j13 #MFT2:1};
// &VSS @WIRE(mode="straight") {#MFT2:3 %j16};
// &VSS @WIRE(mode="straight") {%j15 %j17 %j16};
// &VSS @WIRE(mode="straight") {%j17 %v1:p};
// &DP @WIRE(mode="straight") {%j18 #CDP1:1};
// &VSS @WIRE(mode="straight") {#CDP1:2 %j19};
// &DP @WIRE(mode="straight") {%j20 #CDP2:1};
// &VSS @WIRE(mode="straight") {#CDP2:2 %j21};
// &DP @WIRE(mode="straight") {%j22 #CDP3:1};
// &VSS @WIRE(mode="straight") {#CDP3:2 %j23};
// &DP @WIRE(mode="straight") {%j24 #CDP4:1};
// &VSS @WIRE(mode="straight") {#CDP4:2 %j25};
// &DP @WIRE(mode="straight") {%j26 #CDP5:1};
// &VSS @WIRE(mode="straight") {#CDP5:2 %j27};
// &DP @WIRE(mode="straight") {%j18 %j20 %j22 %j24 %j26};
// &VSS @WIRE(mode="straight") {%j19 %j21 %j23 %j25 %j27};
// &VSS @WIRE(mode="straight") {%j23 %v2:p};
// &DN @WIRE(mode="straight") {%j28 #CDN1:1};
// &VSS @WIRE(mode="straight") {#CDN1:2 %j29};
// &DN @WIRE(mode="straight") {%j30 #CDN2:1};
// &VSS @WIRE(mode="straight") {#CDN2:2 %j31};
// &DN @WIRE(mode="straight") {%j32 #CDN3:1};
// &VSS @WIRE(mode="straight") {#CDN3:2 %j33};
// &DN @WIRE(mode="straight") {%j34 #CDN4:1};
// &VSS @WIRE(mode="straight") {#CDN4:2 %j35};
// &DN @WIRE(mode="straight") {%j36 #CDN5:1};
// &VSS @WIRE(mode="straight") {#CDN5:2 %j37};
// &DN @WIRE(mode="straight") {%j28 %j30 %j32 %j34 %j36};
// &VSS @WIRE(mode="straight") {%j29 %j31 %j33 %j35 %j37};
// &VSS @WIRE(mode="straight") {%j33 %v3:p};
// &DP @WIRE(mode="straight") {%j3 %j38 %j39 %j18};
// &DN @WIRE(mode="straight") {%j4 %j40 %j41 %j36};
// &AVDD @WIRE(mode="straight") {%j42 %j43 %j44 %j45 %j46 %j47 %j48};
// &AVDD @WIRE(mode="straight") {%j45 %v4:p};
// &AVDD @WIRE(mode="straight") {#MRQP:3 %j43};
// &AVDD @WIRE(mode="straight") {#MLPP:3 %j44};
// &AVDD @WIRE(mode="straight") {#MLPN:3 %j46};
// &AVDD @WIRE(mode="straight") {#MRQN:3 %j47};
// &AVDD @WIRE(mode="straight") {#MRXP:3 %j49 %j42};
// &AVDD @WIRE(mode="straight") {#MRXN:3 %j50 %j48};
// &QP @WIRE(mode="straight") {#MLPP:1 %j51 #MLNP:1};
// &QN @WIRE(mode="straight") {#MLPN:1 %j52 #MLNN:1};
// &QP @WIRE(mode="straight") {#MRQP:1 %j53 %j51};
// &QN @WIRE(mode="straight") {#MRQN:1 %j54 %j52};
// &QP @WIRE(mode="straight") {%j51 %j55 %j56 %j57};
// &QP @WIRE(mode="straight") {#MLNN:2 %j58 %j57 %j59 #MLPN:2};
// &QN @WIRE(mode="straight") {%j52 %j60 %j61 %j62};
// &QN @WIRE(mode="straight") {#MLNP:2 %j63 %j62 %j64 #MLPP:2};
// &XP @WIRE(mode="straight") {#MLNP:3 %j65 #MSIP:1};
// &XN @WIRE(mode="straight") {#MLNN:3 %j66 #MSIN:1};
// &XP @WIRE(mode="straight") {#MRXP:1 %j65};
// &XN @WIRE(mode="straight") {#MRXN:1 %j66};
// &CKL @WIRE(mode="straight") {#MRQP:2 %j67};
// &CKL @WIRE(mode="straight") {#MRQN:2 %j68};
// &CKL @WIRE(mode="straight") {#MRXP:2 %j69};
// &CKL @WIRE(mode="straight") {#MRXN:2 %j70};
// &DN @WIRE(mode="straight") {#MSIP:2 %j71};
// &DP @WIRE(mode="straight") {#MSIN:2 %j72};
// &ST @WIRE(mode="straight") {#MSIP:3 %j73 %j74 %j75 %j76 #MSIN:3};
// &ST @WIRE(mode="straight") {%j74 #MST1:1};
// &VSS @WIRE(mode="straight") {#MST1:3 %j77};
// &ST @WIRE(mode="straight") {%j75 #MST2:1};
// &VSS @WIRE(mode="straight") {#MST2:3 %j78};
// &VSS @WIRE(mode="straight") {%j77 %j79 %j78};
// &VSS @WIRE(mode="straight") {%j79 %v5:p};
// &CKL @WIRE(mode="straight") {#MST1:2 %j80};
// &CKL @WIRE(mode="straight") {#MST2:2 %j81};
// &AVDD @WIRE(mode="straight") {#MOPP:3 %v6:p};
// &VSS @WIRE(mode="straight") {#MOPN:3 %v7:p};
// &QP @WIRE(mode="straight") {#MOPP:2 %j82 %j83 %j84 #MOPN:2};
// &QP @WIRE(mode="straight") {%j83 %j85};
// &OUTP @WIRE(mode="straight") {#MOPP:1 %j86 #MOPN:1};
// &OUTP @WIRE(mode="straight") {%j86 %j87};
// &AVDD @WIRE(mode="straight") {#MONP:3 %v8:p};
// &VSS @WIRE(mode="straight") {#MONN:3 %v9:p};
// &QN @WIRE(mode="straight") {#MONP:2 %j88 %j89 %j90 #MONN:2};
// &QN @WIRE(mode="straight") {%j89 %j91};
// &OUTN @WIRE(mode="straight") {#MONP:1 %j92 #MONN:1};
// &OUTN @WIRE(mode="straight") {%j92 %j93};
// &CLKC @WIRE(mode="straight") {%j94 %j95 %b0:1};
// &CLKC @WIRE(mode="straight") {%j95 %j96 %j97 %j98 %nand:1};
// &CKB @WIRE(mode="straight") {%b0:2 %j103 %b1:1};
// &CKF @WIRE(mode="straight") {%b1:2 %d3:1};
// &D3 @WIRE(mode="straight") {%d3:2 %d4:1};
// &CKD @WIRE(mode="straight") {%d4:2 %j99 %j100 %nand:2};
// &CKLB @WIRE(mode="straight") {%nand:3 %lb:1};
// &CKL @WIRE(mode="straight") {%lb:2 %j101 %j102 %nor:2};
// &CKB @WIRE(mode="straight") {%j103 %j104 %j105 %j106 %nor:1};
// &CKE @WIRE(mode="straight") {%nor:3 %j107};
// &AVDD @WIRE(mode="straight") {#MB0P:3 %v10:p};
// &VSS @WIRE(mode="straight") {#MB0N:3 %v11:p};
// &CLKC @WIRE(mode="straight") {#MB0P:2 %j108 %j109 %j110 #MB0N:2};
// &CLKC @WIRE(mode="straight") {%j109 %j111};
// &CKB @WIRE(mode="straight") {#MB0P:1 %j112 #MB0N:1};
// &CKB @WIRE(mode="straight") {%j112 %j113};
// &AVDD @WIRE(mode="straight") {#MB1P:3 %v12:p};
// &VSS @WIRE(mode="straight") {#MB1N:3 %v13:p};
// &CKB @WIRE(mode="straight") {#MB1P:2 %j114 %j115 %j116 #MB1N:2};
// &CKB @WIRE(mode="straight") {%j115 %j117};
// &CKF @WIRE(mode="straight") {#MB1P:1 %j118 #MB1N:1};
// &CKF @WIRE(mode="straight") {%j118 %j119};
// &AVDD @WIRE(mode="straight") {#MD3P:3 %v14:p};
// &VSS @WIRE(mode="straight") {#MD3N:3 %v15:p};
// &CKF @WIRE(mode="straight") {#MD3P:2 %j120 %j121 %j122 #MD3N:2};
// &CKF @WIRE(mode="straight") {%j121 %j123};
// &D3 @WIRE(mode="straight") {#MD3P:1 %j124 #MD3N:1};
// &D3 @WIRE(mode="straight") {%j124 %j125};
// &AVDD @WIRE(mode="straight") {#MD4P:3 %v16:p};
// &VSS @WIRE(mode="straight") {#MD4N:3 %v17:p};
// &D3 @WIRE(mode="straight") {#MD4P:2 %j126 %j127 %j128 #MD4N:2};
// &D3 @WIRE(mode="straight") {%j127 %j129};
// &CKD @WIRE(mode="straight") {#MD4P:1 %j130 #MD4N:1};
// &CKD @WIRE(mode="straight") {%j130 %j131};
// &AVDD @WIRE(mode="straight") {#MPG1:3 %j132 %j133 %j134 #MPG2:3};
// &AVDD @WIRE(mode="straight") {%j133 %v18:p};
// &CKLB @WIRE(mode="straight") {#MPG1:1 %j135 %j136 %j137 #MPG2:1};
// &CKLB @WIRE(mode="straight") {%j136 #MNG1:1};
// &CKLB @WIRE(mode="straight") {%j137 %j138};
// &NG @WIRE(mode="straight") {#MNG1:3 #MNG2:1};
// &VSS @WIRE(mode="straight") {#MNG2:3 %v19:p};
// &CLKC @WIRE(mode="straight") {#MPG1:2 %j139};
// &CKD @WIRE(mode="straight") {#MPG2:2 %j140};
// &CKD @WIRE(mode="straight") {#MNG1:2 %j141};
// &CLKC @WIRE(mode="straight") {#MNG2:2 %j142};
// &AVDD @WIRE(mode="straight") {#MLBP:3 %v20:p};
// &VSS @WIRE(mode="straight") {#MLBN:3 %v21:p};
// &CKLB @WIRE(mode="straight") {#MLBP:2 %j143 %j144 %j145 #MLBN:2};
// &CKLB @WIRE(mode="straight") {%j144 %j146};
// &CKL @WIRE(mode="straight") {#MLBP:1 %j147 #MLBN:1};
// &CKL @WIRE(mode="straight") {%j147 %j148};
// &AVDD @WIRE(mode="straight") {#MHEP1:3 %v22:p};
// &HP @WIRE(mode="straight") {#MHEP1:1 #MHEP2:3};
// &CKE @WIRE(mode="straight") {#MHEP2:1 %j149 %j150 #MHEN1:1};
// &CKE @WIRE(mode="straight") {%j149 %j151 #MHEN2:1};
// &CKE @WIRE(mode="straight") {%j151 %j152};
// &VSS @WIRE(mode="straight") {#MHEN1:3 %j153 %j154 %j155 #MHEN2:3};
// &VSS @WIRE(mode="straight") {%j154 %v23:p};
// &CKB @WIRE(mode="straight") {#MHEP1:2 %j156};
// &CKL @WIRE(mode="straight") {#MHEP2:2 %j157};
// &CKB @WIRE(mode="straight") {#MHEN1:2 %j158};
// &CKL @WIRE(mode="straight") {#MHEN2:2 %j159};
// $JUNCTION @ATTACH %j1;
// $JUNCTION @ATTACH %j3;
// $JUNCTION @ATTACH %j4;
// $JUNCTION @ATTACH %j12;
// $JUNCTION @ATTACH %j13;
// $JUNCTION @ATTACH %j17;
// $JUNCTION @ATTACH %j18;
// $JUNCTION @ATTACH %j20;
// $JUNCTION @ATTACH %j21;
// $JUNCTION @ATTACH %j22;
// $JUNCTION @ATTACH %j23;
// $JUNCTION @ATTACH %j24;
// $JUNCTION @ATTACH %j25;
// $JUNCTION @ATTACH %j30;
// $JUNCTION @ATTACH %j31;
// $JUNCTION @ATTACH %j32;
// $JUNCTION @ATTACH %j33;
// $JUNCTION @ATTACH %j34;
// $JUNCTION @ATTACH %j35;
// $JUNCTION @ATTACH %j36;
// $JUNCTION @ATTACH %j43;
// $JUNCTION @ATTACH %j44;
// $JUNCTION @ATTACH %j45;
// $JUNCTION @ATTACH %j46;
// $JUNCTION @ATTACH %j47;
// $JUNCTION @ATTACH %j51;
// $JUNCTION @ATTACH %j52;
// $JUNCTION @ATTACH %j57;
// $JUNCTION @ATTACH %j62;
// $JUNCTION @ATTACH %j65;
// $JUNCTION @ATTACH %j66;
// $JUNCTION @ATTACH %j74;
// $JUNCTION @ATTACH %j75;
// $JUNCTION @ATTACH %j79;
// $JUNCTION @ATTACH %j83;
// $JUNCTION @ATTACH %j86;
// $JUNCTION @ATTACH %j89;
// $JUNCTION @ATTACH %j92;
// $JUNCTION @ATTACH %j95;
// $JUNCTION @ATTACH %j103;
// $JUNCTION @ATTACH %j109;
// $JUNCTION @ATTACH %j112;
// $JUNCTION @ATTACH %j115;
// $JUNCTION @ATTACH %j118;
// $JUNCTION @ATTACH %j121;
// $JUNCTION @ATTACH %j124;
// $JUNCTION @ATTACH %j127;
// $JUNCTION @ATTACH %j130;
// $JUNCTION @ATTACH %j133;
// $JUNCTION @ATTACH %j136;
// $JUNCTION @ATTACH %j137;
// $JUNCTION @ATTACH %j144;
// $JUNCTION @ATTACH %j147;
// $JUNCTION @ATTACH %j149;
// $JUNCTION @ATTACH %j151;
// $JUNCTION @ATTACH %j154;
// }
ends adc_comp
