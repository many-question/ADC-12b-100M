// Split-stage comparator A2: physical integrator, independent latch and physical clock.
// @RNL(type="header") {
// @VERSION("0.3");
// @USE-PACKAGE(name="adc28", version="0.1", path="../../../rnl/adc28.rnl")
// }
simulator lang=spectre
subckt adc_comp (INP INN CLKC OUTP OUTN AVDD VSS)
// All geometry comes from successful device callbacks. No ideal timing or bias elements.
MINP (DP INP FT VSS) nch_ulvt_mac l=3e-08 w=5.6e-05 nf=56 m=1 ad=2.8e-12 as=2.85e-12 pd=6.16e-05 ps=6.37e-05 nrd=0.009138 nrs=0.009138 sa=1.36619e-06 sb=1.36619e-06 sd=1e-07
MINN (DN INN FT VSS) nch_ulvt_mac l=3e-08 w=5.6e-05 nf=56 m=1 ad=2.8e-12 as=2.85e-12 pd=6.16e-05 ps=6.37e-05 nrd=0.009138 nrs=0.009138 sa=1.36619e-06 sb=1.36619e-06 sd=1e-07
MFT1 (FT CKE VSS VSS) nch_ulvt_mac l=3e-08 w=3e-06 nf=3 m=1 ad=1.75e-13 as=1.75e-13 pd=4.35e-06 ps=4.35e-06 nrd=0.136842 nrs=0.136842 sa=1.47042e-07 sb=1.47042e-07 sd=1e-07
MFT2 (FT CKE VSS VSS) nch_ulvt_mac l=3e-08 w=3e-06 nf=3 m=1 ad=1.75e-13 as=1.75e-13 pd=4.35e-06 ps=4.35e-06 nrd=0.136842 nrs=0.136842 sa=1.47042e-07 sb=1.47042e-07 sd=1e-07
MRDP (DP CKF AVDD AVDD) pch_ulvt_mac l=3e-08 w=1.6e-05 nf=16 m=1 ad=8e-13 as=8.5e-13 pd=1.76e-05 ps=1.97e-05 nrd=0.012674 nrs=0.012674 sa=5.01551e-07 sb=5.01551e-07 sd=1e-07
MRDN (DN CKF AVDD AVDD) pch_ulvt_mac l=3e-08 w=1.6e-05 nf=16 m=1 ad=8e-13 as=8.5e-13 pd=1.76e-05 ps=1.97e-05 nrd=0.012674 nrs=0.012674 sa=5.01551e-07 sb=5.01551e-07 sd=1e-07
CDP1 (DP VSS) cfmom_2t nr=52 lr=1e-06 w=5e-08 s=5e-08 stm=1 spm=3 multi=1
CDP2 (DP VSS) cfmom_2t nr=52 lr=1e-06 w=5e-08 s=5e-08 stm=1 spm=3 multi=1
CDP3 (DP VSS) cfmom_2t nr=52 lr=1e-06 w=5e-08 s=5e-08 stm=1 spm=3 multi=1
CDP4 (DP VSS) cfmom_2t nr=52 lr=1e-06 w=5e-08 s=5e-08 stm=1 spm=3 multi=1
CDP5 (DP VSS) cfmom_2t nr=52 lr=1e-06 w=5e-08 s=5e-08 stm=1 spm=3 multi=1
CDN1 (DN VSS) cfmom_2t nr=52 lr=1e-06 w=5e-08 s=5e-08 stm=1 spm=3 multi=1
CDN2 (DN VSS) cfmom_2t nr=52 lr=1e-06 w=5e-08 s=5e-08 stm=1 spm=3 multi=1
CDN3 (DN VSS) cfmom_2t nr=52 lr=1e-06 w=5e-08 s=5e-08 stm=1 spm=3 multi=1
CDN4 (DN VSS) cfmom_2t nr=52 lr=1e-06 w=5e-08 s=5e-08 stm=1 spm=3 multi=1
CDN5 (DN VSS) cfmom_2t nr=52 lr=1e-06 w=5e-08 s=5e-08 stm=1 spm=3 multi=1
MSIP (XP DN ST VSS) nch_ulvt_mac l=3e-08 w=4e-06 nf=4 m=1 ad=2e-13 as=2.5e-13 pd=4.4e-06 ps=6.5e-06 nrd=0.108289 nrs=0.108289 sa=1.79203e-07 sb=1.79203e-07 sd=1e-07
MSIN (XN DP ST VSS) nch_ulvt_mac l=3e-08 w=4e-06 nf=4 m=1 ad=2e-13 as=2.5e-13 pd=4.4e-06 ps=6.5e-06 nrd=0.108289 nrs=0.108289 sa=1.79203e-07 sb=1.79203e-07 sd=1e-07
MST1 (ST CKL VSS VSS) nch_ulvt_mac l=3e-08 w=3e-06 nf=3 m=1 ad=1.75e-13 as=1.75e-13 pd=4.35e-06 ps=4.35e-06 nrd=0.136842 nrs=0.136842 sa=1.47042e-07 sb=1.47042e-07 sd=1e-07
MST2 (ST CKL VSS VSS) nch_ulvt_mac l=3e-08 w=3e-06 nf=3 m=1 ad=1.75e-13 as=1.75e-13 pd=4.35e-06 ps=4.35e-06 nrd=0.136842 nrs=0.136842 sa=1.47042e-07 sb=1.47042e-07 sd=1e-07
MLNP (QP QN XP VSS) nch_ulvt_mac l=3e-08 w=1.2e-05 nf=12 m=1 ad=6e-13 as=6.5e-13 pd=1.32e-05 ps=1.53e-05 nrd=0.040569 nrs=0.040569 sa=4.01767e-07 sb=4.01767e-07 sd=1e-07
MLNN (QN QP XN VSS) nch_ulvt_mac l=3e-08 w=1.2e-05 nf=12 m=1 ad=6e-13 as=6.5e-13 pd=1.32e-05 ps=1.53e-05 nrd=0.040569 nrs=0.040569 sa=4.01767e-07 sb=4.01767e-07 sd=1e-07
MLPP (QP QN AVDD AVDD) pch_ulvt_mac l=3e-08 w=8e-06 nf=8 m=1 ad=4e-13 as=4.5e-13 pd=8.8e-06 ps=1.09e-05 nrd=0.024976 nrs=0.024976 sa=2.95835e-07 sb=2.95835e-07 sd=1e-07
MLPN (QN QP AVDD AVDD) pch_ulvt_mac l=3e-08 w=8e-06 nf=8 m=1 ad=4e-13 as=4.5e-13 pd=8.8e-06 ps=1.09e-05 nrd=0.024976 nrs=0.024976 sa=2.95835e-07 sb=2.95835e-07 sd=1e-07
MRXP (XP CKL AVDD AVDD) pch_ulvt_mac l=3e-08 w=4e-06 nf=4 m=1 ad=2e-13 as=2.5e-13 pd=4.4e-06 ps=6.5e-06 nrd=0.048530 nrs=0.048530 sa=1.79203e-07 sb=1.79203e-07 sd=1e-07
MRXN (XN CKL AVDD AVDD) pch_ulvt_mac l=3e-08 w=4e-06 nf=4 m=1 ad=2e-13 as=2.5e-13 pd=4.4e-06 ps=6.5e-06 nrd=0.048530 nrs=0.048530 sa=1.79203e-07 sb=1.79203e-07 sd=1e-07
MRQP (QP CKL AVDD AVDD) pch_ulvt_mac l=3e-08 w=1.6e-05 nf=16 m=1 ad=8e-13 as=8.5e-13 pd=1.76e-05 ps=1.97e-05 nrd=0.012674 nrs=0.012674 sa=5.01551e-07 sb=5.01551e-07 sd=1e-07
MRQN (QN CKL AVDD AVDD) pch_ulvt_mac l=3e-08 w=1.6e-05 nf=16 m=1 ad=8e-13 as=8.5e-13 pd=1.76e-05 ps=1.97e-05 nrd=0.012674 nrs=0.012674 sa=5.01551e-07 sb=5.01551e-07 sd=1e-07
MOPP (OUTP QP AVDD AVDD) pch_ulvt_mac l=3e-08 w=4e-06 nf=4 m=1 ad=2e-13 as=2.5e-13 pd=4.4e-06 ps=6.5e-06 nrd=0.048530 nrs=0.048530 sa=1.79203e-07 sb=1.79203e-07 sd=1e-07
MOPN (OUTP QP VSS VSS) nch_ulvt_mac l=3e-08 w=2e-06 nf=2 m=1 ad=1e-13 as=1.5e-13 pd=2.2e-06 ps=4.3e-06 nrd=0.185844 nrs=0.185844 sa=1.12742e-07 sb=1.12742e-07 sd=1e-07
MONP (OUTN QN AVDD AVDD) pch_ulvt_mac l=3e-08 w=4e-06 nf=4 m=1 ad=2e-13 as=2.5e-13 pd=4.4e-06 ps=6.5e-06 nrd=0.048530 nrs=0.048530 sa=1.79203e-07 sb=1.79203e-07 sd=1e-07
MONN (OUTN QN VSS VSS) nch_ulvt_mac l=3e-08 w=2e-06 nf=2 m=1 ad=1e-13 as=1.5e-13 pd=2.2e-06 ps=4.3e-06 nrd=0.185844 nrs=0.185844 sa=1.12742e-07 sb=1.12742e-07 sd=1e-07
MB0P (CKB CLKC AVDD AVDD) pch_ulvt_mac l=3e-08 w=4e-06 nf=4 m=1 ad=2e-13 as=2.5e-13 pd=4.4e-06 ps=6.5e-06 nrd=0.048530 nrs=0.048530 sa=1.79203e-07 sb=1.79203e-07 sd=1e-07
MB0N (CKB CLKC VSS VSS) nch_ulvt_mac l=3e-08 w=2e-06 nf=2 m=1 ad=1e-13 as=1.5e-13 pd=2.2e-06 ps=4.3e-06 nrd=0.185844 nrs=0.185844 sa=1.12742e-07 sb=1.12742e-07 sd=1e-07
MB1P (CKF CKB AVDD AVDD) pch_ulvt_mac l=3e-08 w=8e-06 nf=8 m=1 ad=4e-13 as=4.5e-13 pd=8.8e-06 ps=1.09e-05 nrd=0.024976 nrs=0.024976 sa=2.95835e-07 sb=2.95835e-07 sd=1e-07
MB1N (CKF CKB VSS VSS) nch_ulvt_mac l=3e-08 w=4e-06 nf=4 m=1 ad=2e-13 as=2.5e-13 pd=4.4e-06 ps=6.5e-06 nrd=0.108289 nrs=0.108289 sa=1.79203e-07 sb=1.79203e-07 sd=1e-07
MD1P (D1 CKF AVDD AVDD) pch_ulvt_mac l=3e-08 w=4e-06 nf=4 m=1 ad=2e-13 as=2.5e-13 pd=4.4e-06 ps=6.5e-06 nrd=0.048530 nrs=0.048530 sa=1.79203e-07 sb=1.79203e-07 sd=1e-07
MD1N (D1 CKF VSS VSS) nch_ulvt_mac l=3e-08 w=2e-06 nf=2 m=1 ad=1e-13 as=1.5e-13 pd=2.2e-06 ps=4.3e-06 nrd=0.185844 nrs=0.185844 sa=1.12742e-07 sb=1.12742e-07 sd=1e-07
MD2P (D2 D1 AVDD AVDD) pch_ulvt_mac l=3e-08 w=4e-06 nf=4 m=1 ad=2e-13 as=2.5e-13 pd=4.4e-06 ps=6.5e-06 nrd=0.048530 nrs=0.048530 sa=1.79203e-07 sb=1.79203e-07 sd=1e-07
MD2N (D2 D1 VSS VSS) nch_ulvt_mac l=3e-08 w=2e-06 nf=2 m=1 ad=1e-13 as=1.5e-13 pd=2.2e-06 ps=4.3e-06 nrd=0.185844 nrs=0.185844 sa=1.12742e-07 sb=1.12742e-07 sd=1e-07
MD3P (D3 D2 AVDD AVDD) pch_ulvt_mac l=3e-08 w=4e-06 nf=4 m=1 ad=2e-13 as=2.5e-13 pd=4.4e-06 ps=6.5e-06 nrd=0.048530 nrs=0.048530 sa=1.79203e-07 sb=1.79203e-07 sd=1e-07
MD3N (D3 D2 VSS VSS) nch_ulvt_mac l=3e-08 w=2e-06 nf=2 m=1 ad=1e-13 as=1.5e-13 pd=2.2e-06 ps=4.3e-06 nrd=0.185844 nrs=0.185844 sa=1.12742e-07 sb=1.12742e-07 sd=1e-07
MD4P (CKD D3 AVDD AVDD) pch_ulvt_mac l=3e-08 w=8e-06 nf=8 m=1 ad=4e-13 as=4.5e-13 pd=8.8e-06 ps=1.09e-05 nrd=0.024976 nrs=0.024976 sa=2.95835e-07 sb=2.95835e-07 sd=1e-07
MD4N (CKD D3 VSS VSS) nch_ulvt_mac l=3e-08 w=4e-06 nf=4 m=1 ad=2e-13 as=2.5e-13 pd=4.4e-06 ps=6.5e-06 nrd=0.108289 nrs=0.108289 sa=1.79203e-07 sb=1.79203e-07 sd=1e-07
MNG1 (CKLB CLKC NG VSS) nch_ulvt_mac l=3e-08 w=4e-06 nf=4 m=1 ad=2e-13 as=2.5e-13 pd=4.4e-06 ps=6.5e-06 nrd=0.108289 nrs=0.108289 sa=1.79203e-07 sb=1.79203e-07 sd=1e-07
MNG2 (NG CKD VSS VSS) nch_ulvt_mac l=3e-08 w=4e-06 nf=4 m=1 ad=2e-13 as=2.5e-13 pd=4.4e-06 ps=6.5e-06 nrd=0.108289 nrs=0.108289 sa=1.79203e-07 sb=1.79203e-07 sd=1e-07
MPG1 (CKLB CLKC AVDD AVDD) pch_ulvt_mac l=3e-08 w=4e-06 nf=4 m=1 ad=2e-13 as=2.5e-13 pd=4.4e-06 ps=6.5e-06 nrd=0.048530 nrs=0.048530 sa=1.79203e-07 sb=1.79203e-07 sd=1e-07
MPG2 (CKLB CKD AVDD AVDD) pch_ulvt_mac l=3e-08 w=4e-06 nf=4 m=1 ad=2e-13 as=2.5e-13 pd=4.4e-06 ps=6.5e-06 nrd=0.048530 nrs=0.048530 sa=1.79203e-07 sb=1.79203e-07 sd=1e-07
MLBP (CKL CKLB AVDD AVDD) pch_ulvt_mac l=3e-08 w=1.6e-05 nf=16 m=1 ad=8e-13 as=8.5e-13 pd=1.76e-05 ps=1.97e-05 nrd=0.012674 nrs=0.012674 sa=5.01551e-07 sb=5.01551e-07 sd=1e-07
MLBN (CKL CKLB VSS VSS) nch_ulvt_mac l=3e-08 w=8e-06 nf=8 m=1 ad=4e-13 as=4.5e-13 pd=8.8e-06 ps=1.09e-05 nrd=0.059025 nrs=0.059025 sa=2.95835e-07 sb=2.95835e-07 sd=1e-07
MHEP1 (HP CKB AVDD AVDD) pch_ulvt_mac l=3e-08 w=8e-06 nf=8 m=1 ad=4e-13 as=4.5e-13 pd=8.8e-06 ps=1.09e-05 nrd=0.024976 nrs=0.024976 sa=2.95835e-07 sb=2.95835e-07 sd=1e-07
MHEP2 (CKE CKL HP AVDD) pch_ulvt_mac l=3e-08 w=8e-06 nf=8 m=1 ad=4e-13 as=4.5e-13 pd=8.8e-06 ps=1.09e-05 nrd=0.024976 nrs=0.024976 sa=2.95835e-07 sb=2.95835e-07 sd=1e-07
MHEN1 (CKE CKB VSS VSS) nch_ulvt_mac l=3e-08 w=4e-06 nf=4 m=1 ad=2e-13 as=2.5e-13 pd=4.4e-06 ps=6.5e-06 nrd=0.108289 nrs=0.108289 sa=1.79203e-07 sb=1.79203e-07 sd=1e-07
MHEN2 (CKE CKL VSS VSS) nch_ulvt_mac l=3e-08 w=4e-06 nf=4 m=1 ad=2e-13 as=2.5e-13 pd=4.4e-06 ps=6.5e-06 nrd=0.108289 nrs=0.108289 sa=1.79203e-07 sb=1.79203e-07 sd=1e-07
// @RNL(author="splitstage-a2") {
// # @SELECT-INSTANCE => @TEXT("",key="model");
// # @SELECT-TERMINAL => @REMOVE-FROM $GROUND_FILL_SET;
// # @SELECT-TERMINAL => @REMOVE-FROM $SUPPLY_FILL_SET;
// # @SELECT-NET(port=true) => @REMOVE-FROM $PORT_FILL_SET;
// (0,151) @TEXT("A2 front integrator | W56 pair, 2 x W3 tail, 5 x C52 per node",size=1.5,bold=true);
// (160,151) @TEXT("Independent latch | gate-only DN / DP coupling | physical RTZ buffers",size=1.5,bold=true);
// (0,39) @TEXT("Clock: CKL = CLKC AND CKD; CKE = NOR(CKB, CKL) stops front tail; reset stays CKF",size=1.4,bold=true);
// (0,-23) @TEXT("Every physical device and pin is shown. Wires terminate at exact net labels; equal labels are electrically connected.",size=1.1);
// #MINP @PLACE(0,100) => @ORIENT("R0");
// #MINP @TEXT("MINP",key="name",size=.85,dx=2.2,dy=2.5,halign="start");
// #MINP @TEXT("56um/30nm nf56",key="dims",size=.7,dx=2.2,dy=.3,halign="start");
// %p_MINP_1 = (0,106);
// &DP @WIRE(mode="horizontal-vertical") {#MINP:1 %p_MINP_1};
// (0,107) @TEXT("DP",size=.75,bold=true,halign="middle");
// %p_MINP_2 = (-7,100);
// &INP @WIRE(mode="horizontal-vertical") {#MINP:2 %p_MINP_2};
// (-7.3,100) @TEXT("INP",size=.75,bold=true,halign="end");
// %p_MINP_3 = (0,94);
// &FT @WIRE(mode="horizontal-vertical") {#MINP:3 %p_MINP_3};
// (0,93) @TEXT("FT",size=.75,bold=true,halign="middle");
// %p_MINP_4 = (6,95);
// &VSS @WIRE(mode="horizontal-vertical") {#MINP:4 %p_MINP_4};
// (6.3,95) @TEXT("VSS",size=.75,bold=true,halign="start");
// #MINN @PLACE(32,100) => @ORIENT("R0");
// #MINN @TEXT("MINN",key="name",size=.85,dx=2.2,dy=2.5,halign="start");
// #MINN @TEXT("56um/30nm nf56",key="dims",size=.7,dx=2.2,dy=.3,halign="start");
// %p_MINN_1 = (32,106);
// &DN @WIRE(mode="horizontal-vertical") {#MINN:1 %p_MINN_1};
// (32,107) @TEXT("DN",size=.75,bold=true,halign="middle");
// %p_MINN_2 = (25,100);
// &INN @WIRE(mode="horizontal-vertical") {#MINN:2 %p_MINN_2};
// (24.7,100) @TEXT("INN",size=.75,bold=true,halign="end");
// %p_MINN_3 = (32,94);
// &FT @WIRE(mode="horizontal-vertical") {#MINN:3 %p_MINN_3};
// (32,93) @TEXT("FT",size=.75,bold=true,halign="middle");
// %p_MINN_4 = (38,95);
// &VSS @WIRE(mode="horizontal-vertical") {#MINN:4 %p_MINN_4};
// (38.3,95) @TEXT("VSS",size=.75,bold=true,halign="start");
// #MFT1 @PLACE(0,72) => @ORIENT("R0");
// #MFT1 @TEXT("MFT1",key="name",size=.85,dx=2.2,dy=2.5,halign="start");
// #MFT1 @TEXT("3um/30nm nf3",key="dims",size=.7,dx=2.2,dy=.3,halign="start");
// %p_MFT1_1 = (0,78);
// &FT @WIRE(mode="horizontal-vertical") {#MFT1:1 %p_MFT1_1};
// (0,79) @TEXT("FT",size=.75,bold=true,halign="middle");
// %p_MFT1_2 = (-7,72);
// &CKE @WIRE(mode="horizontal-vertical") {#MFT1:2 %p_MFT1_2};
// (-7.3,72) @TEXT("CKE",size=.75,bold=true,halign="end");
// %p_MFT1_3 = (0,66);
// &VSS @WIRE(mode="horizontal-vertical") {#MFT1:3 %p_MFT1_3};
// (0,65) @TEXT("VSS",size=.75,bold=true,halign="middle");
// %p_MFT1_4 = (6,67);
// &VSS @WIRE(mode="horizontal-vertical") {#MFT1:4 %p_MFT1_4};
// (6.3,67) @TEXT("VSS",size=.75,bold=true,halign="start");
// #MFT2 @PLACE(32,72) => @ORIENT("R0");
// #MFT2 @TEXT("MFT2",key="name",size=.85,dx=2.2,dy=2.5,halign="start");
// #MFT2 @TEXT("3um/30nm nf3",key="dims",size=.7,dx=2.2,dy=.3,halign="start");
// %p_MFT2_1 = (32,78);
// &FT @WIRE(mode="horizontal-vertical") {#MFT2:1 %p_MFT2_1};
// (32,79) @TEXT("FT",size=.75,bold=true,halign="middle");
// %p_MFT2_2 = (25,72);
// &CKE @WIRE(mode="horizontal-vertical") {#MFT2:2 %p_MFT2_2};
// (24.7,72) @TEXT("CKE",size=.75,bold=true,halign="end");
// %p_MFT2_3 = (32,66);
// &VSS @WIRE(mode="horizontal-vertical") {#MFT2:3 %p_MFT2_3};
// (32,65) @TEXT("VSS",size=.75,bold=true,halign="middle");
// %p_MFT2_4 = (38,67);
// &VSS @WIRE(mode="horizontal-vertical") {#MFT2:4 %p_MFT2_4};
// (38.3,67) @TEXT("VSS",size=.75,bold=true,halign="start");
// #MRDP @PLACE(0,128) => @ORIENT("R0");
// #MRDP @TEXT("MRDP",key="name",size=.85,dx=2.2,dy=2.5,halign="start");
// #MRDP @TEXT("16um/30nm nf16",key="dims",size=.7,dx=2.2,dy=.3,halign="start");
// %p_MRDP_1 = (0,122);
// &DP @WIRE(mode="horizontal-vertical") {#MRDP:1 %p_MRDP_1};
// (0,121) @TEXT("DP",size=.75,bold=true,halign="middle");
// %p_MRDP_2 = (-7,128);
// &CKF @WIRE(mode="horizontal-vertical") {#MRDP:2 %p_MRDP_2};
// (-7.3,128) @TEXT("CKF",size=.75,bold=true,halign="end");
// %p_MRDP_3 = (0,134);
// &AVDD @WIRE(mode="horizontal-vertical") {#MRDP:3 %p_MRDP_3};
// (0,135) @TEXT("AVDD",size=.75,bold=true,halign="middle");
// %p_MRDP_4 = (6,123);
// &AVDD @WIRE(mode="horizontal-vertical") {#MRDP:4 %p_MRDP_4};
// (6.3,123) @TEXT("AVDD",size=.75,bold=true,halign="start");
// #MRDN @PLACE(32,128) => @ORIENT("R0");
// #MRDN @TEXT("MRDN",key="name",size=.85,dx=2.2,dy=2.5,halign="start");
// #MRDN @TEXT("16um/30nm nf16",key="dims",size=.7,dx=2.2,dy=.3,halign="start");
// %p_MRDN_1 = (32,122);
// &DN @WIRE(mode="horizontal-vertical") {#MRDN:1 %p_MRDN_1};
// (32,121) @TEXT("DN",size=.75,bold=true,halign="middle");
// %p_MRDN_2 = (25,128);
// &CKF @WIRE(mode="horizontal-vertical") {#MRDN:2 %p_MRDN_2};
// (24.7,128) @TEXT("CKF",size=.75,bold=true,halign="end");
// %p_MRDN_3 = (32,134);
// &AVDD @WIRE(mode="horizontal-vertical") {#MRDN:3 %p_MRDN_3};
// (32,135) @TEXT("AVDD",size=.75,bold=true,halign="middle");
// %p_MRDN_4 = (38,123);
// &AVDD @WIRE(mode="horizontal-vertical") {#MRDN:4 %p_MRDN_4};
// (38.3,123) @TEXT("AVDD",size=.75,bold=true,halign="start");
// #CDP1 @PLACE(64,128) => @ORIENT("R0");
// #CDP1 @TEXT("CDP1",key="name",size=.85,dx=2.2,dy=2.5,halign="start");
// #CDP1 @TEXT("52 fingers / 1um",key="dims",size=.7,dx=2.2,dy=.3,halign="start");
// %p_CDP1_1 = (64,134);
// &DP @WIRE(mode="horizontal-vertical") {#CDP1:1 %p_CDP1_1};
// (64,135) @TEXT("DP",size=.75,bold=true,halign="middle");
// %p_CDP1_2 = (64,122);
// &VSS @WIRE(mode="horizontal-vertical") {#CDP1:2 %p_CDP1_2};
// (64,121) @TEXT("VSS",size=.75,bold=true,halign="middle");
// #CDP2 @PLACE(84,128) => @ORIENT("R0");
// #CDP2 @TEXT("CDP2",key="name",size=.85,dx=2.2,dy=2.5,halign="start");
// #CDP2 @TEXT("52 fingers / 1um",key="dims",size=.7,dx=2.2,dy=.3,halign="start");
// %p_CDP2_1 = (84,134);
// &DP @WIRE(mode="horizontal-vertical") {#CDP2:1 %p_CDP2_1};
// (84,135) @TEXT("DP",size=.75,bold=true,halign="middle");
// %p_CDP2_2 = (84,122);
// &VSS @WIRE(mode="horizontal-vertical") {#CDP2:2 %p_CDP2_2};
// (84,121) @TEXT("VSS",size=.75,bold=true,halign="middle");
// #CDP3 @PLACE(104,128) => @ORIENT("R0");
// #CDP3 @TEXT("CDP3",key="name",size=.85,dx=2.2,dy=2.5,halign="start");
// #CDP3 @TEXT("52 fingers / 1um",key="dims",size=.7,dx=2.2,dy=.3,halign="start");
// %p_CDP3_1 = (104,134);
// &DP @WIRE(mode="horizontal-vertical") {#CDP3:1 %p_CDP3_1};
// (104,135) @TEXT("DP",size=.75,bold=true,halign="middle");
// %p_CDP3_2 = (104,122);
// &VSS @WIRE(mode="horizontal-vertical") {#CDP3:2 %p_CDP3_2};
// (104,121) @TEXT("VSS",size=.75,bold=true,halign="middle");
// #CDP4 @PLACE(124,128) => @ORIENT("R0");
// #CDP4 @TEXT("CDP4",key="name",size=.85,dx=2.2,dy=2.5,halign="start");
// #CDP4 @TEXT("52 fingers / 1um",key="dims",size=.7,dx=2.2,dy=.3,halign="start");
// %p_CDP4_1 = (124,134);
// &DP @WIRE(mode="horizontal-vertical") {#CDP4:1 %p_CDP4_1};
// (124,135) @TEXT("DP",size=.75,bold=true,halign="middle");
// %p_CDP4_2 = (124,122);
// &VSS @WIRE(mode="horizontal-vertical") {#CDP4:2 %p_CDP4_2};
// (124,121) @TEXT("VSS",size=.75,bold=true,halign="middle");
// #CDP5 @PLACE(144,128) => @ORIENT("R0");
// #CDP5 @TEXT("CDP5",key="name",size=.85,dx=2.2,dy=2.5,halign="start");
// #CDP5 @TEXT("52 fingers / 1um",key="dims",size=.7,dx=2.2,dy=.3,halign="start");
// %p_CDP5_1 = (144,134);
// &DP @WIRE(mode="horizontal-vertical") {#CDP5:1 %p_CDP5_1};
// (144,135) @TEXT("DP",size=.75,bold=true,halign="middle");
// %p_CDP5_2 = (144,122);
// &VSS @WIRE(mode="horizontal-vertical") {#CDP5:2 %p_CDP5_2};
// (144,121) @TEXT("VSS",size=.75,bold=true,halign="middle");
// #CDN1 @PLACE(64,100) => @ORIENT("R0");
// #CDN1 @TEXT("CDN1",key="name",size=.85,dx=2.2,dy=2.5,halign="start");
// #CDN1 @TEXT("52 fingers / 1um",key="dims",size=.7,dx=2.2,dy=.3,halign="start");
// %p_CDN1_1 = (64,106);
// &DN @WIRE(mode="horizontal-vertical") {#CDN1:1 %p_CDN1_1};
// (64,107) @TEXT("DN",size=.75,bold=true,halign="middle");
// %p_CDN1_2 = (64,94);
// &VSS @WIRE(mode="horizontal-vertical") {#CDN1:2 %p_CDN1_2};
// (64,93) @TEXT("VSS",size=.75,bold=true,halign="middle");
// #CDN2 @PLACE(84,100) => @ORIENT("R0");
// #CDN2 @TEXT("CDN2",key="name",size=.85,dx=2.2,dy=2.5,halign="start");
// #CDN2 @TEXT("52 fingers / 1um",key="dims",size=.7,dx=2.2,dy=.3,halign="start");
// %p_CDN2_1 = (84,106);
// &DN @WIRE(mode="horizontal-vertical") {#CDN2:1 %p_CDN2_1};
// (84,107) @TEXT("DN",size=.75,bold=true,halign="middle");
// %p_CDN2_2 = (84,94);
// &VSS @WIRE(mode="horizontal-vertical") {#CDN2:2 %p_CDN2_2};
// (84,93) @TEXT("VSS",size=.75,bold=true,halign="middle");
// #CDN3 @PLACE(104,100) => @ORIENT("R0");
// #CDN3 @TEXT("CDN3",key="name",size=.85,dx=2.2,dy=2.5,halign="start");
// #CDN3 @TEXT("52 fingers / 1um",key="dims",size=.7,dx=2.2,dy=.3,halign="start");
// %p_CDN3_1 = (104,106);
// &DN @WIRE(mode="horizontal-vertical") {#CDN3:1 %p_CDN3_1};
// (104,107) @TEXT("DN",size=.75,bold=true,halign="middle");
// %p_CDN3_2 = (104,94);
// &VSS @WIRE(mode="horizontal-vertical") {#CDN3:2 %p_CDN3_2};
// (104,93) @TEXT("VSS",size=.75,bold=true,halign="middle");
// #CDN4 @PLACE(124,100) => @ORIENT("R0");
// #CDN4 @TEXT("CDN4",key="name",size=.85,dx=2.2,dy=2.5,halign="start");
// #CDN4 @TEXT("52 fingers / 1um",key="dims",size=.7,dx=2.2,dy=.3,halign="start");
// %p_CDN4_1 = (124,106);
// &DN @WIRE(mode="horizontal-vertical") {#CDN4:1 %p_CDN4_1};
// (124,107) @TEXT("DN",size=.75,bold=true,halign="middle");
// %p_CDN4_2 = (124,94);
// &VSS @WIRE(mode="horizontal-vertical") {#CDN4:2 %p_CDN4_2};
// (124,93) @TEXT("VSS",size=.75,bold=true,halign="middle");
// #CDN5 @PLACE(144,100) => @ORIENT("R0");
// #CDN5 @TEXT("CDN5",key="name",size=.85,dx=2.2,dy=2.5,halign="start");
// #CDN5 @TEXT("52 fingers / 1um",key="dims",size=.7,dx=2.2,dy=.3,halign="start");
// %p_CDN5_1 = (144,106);
// &DN @WIRE(mode="horizontal-vertical") {#CDN5:1 %p_CDN5_1};
// (144,107) @TEXT("DN",size=.75,bold=true,halign="middle");
// %p_CDN5_2 = (144,94);
// &VSS @WIRE(mode="horizontal-vertical") {#CDN5:2 %p_CDN5_2};
// (144,93) @TEXT("VSS",size=.75,bold=true,halign="middle");
// #MSIP @PLACE(192,72) => @ORIENT("R0");
// #MSIP @TEXT("MSIP",key="name",size=.85,dx=2.2,dy=2.5,halign="start");
// #MSIP @TEXT("4um/30nm nf4",key="dims",size=.7,dx=2.2,dy=.3,halign="start");
// %p_MSIP_1 = (192,78);
// &XP @WIRE(mode="horizontal-vertical") {#MSIP:1 %p_MSIP_1};
// (192,79) @TEXT("XP",size=.75,bold=true,halign="middle");
// %p_MSIP_2 = (185,72);
// &DN @WIRE(mode="horizontal-vertical") {#MSIP:2 %p_MSIP_2};
// (184.7,72) @TEXT("DN",size=.75,bold=true,halign="end");
// %p_MSIP_3 = (192,66);
// &ST @WIRE(mode="horizontal-vertical") {#MSIP:3 %p_MSIP_3};
// (192,65) @TEXT("ST",size=.75,bold=true,halign="middle");
// %p_MSIP_4 = (198,67);
// &VSS @WIRE(mode="horizontal-vertical") {#MSIP:4 %p_MSIP_4};
// (198.3,67) @TEXT("VSS",size=.75,bold=true,halign="start");
// #MSIN @PLACE(224,72) => @ORIENT("R0");
// #MSIN @TEXT("MSIN",key="name",size=.85,dx=2.2,dy=2.5,halign="start");
// #MSIN @TEXT("4um/30nm nf4",key="dims",size=.7,dx=2.2,dy=.3,halign="start");
// %p_MSIN_1 = (224,78);
// &XN @WIRE(mode="horizontal-vertical") {#MSIN:1 %p_MSIN_1};
// (224,79) @TEXT("XN",size=.75,bold=true,halign="middle");
// %p_MSIN_2 = (217,72);
// &DP @WIRE(mode="horizontal-vertical") {#MSIN:2 %p_MSIN_2};
// (216.7,72) @TEXT("DP",size=.75,bold=true,halign="end");
// %p_MSIN_3 = (224,66);
// &ST @WIRE(mode="horizontal-vertical") {#MSIN:3 %p_MSIN_3};
// (224,65) @TEXT("ST",size=.75,bold=true,halign="middle");
// %p_MSIN_4 = (230,67);
// &VSS @WIRE(mode="horizontal-vertical") {#MSIN:4 %p_MSIN_4};
// (230.3,67) @TEXT("VSS",size=.75,bold=true,halign="start");
// #MST1 @PLACE(192,44) => @ORIENT("R0");
// #MST1 @TEXT("MST1",key="name",size=.85,dx=2.2,dy=2.5,halign="start");
// #MST1 @TEXT("3um/30nm nf3",key="dims",size=.7,dx=2.2,dy=.3,halign="start");
// %p_MST1_1 = (192,50);
// &ST @WIRE(mode="horizontal-vertical") {#MST1:1 %p_MST1_1};
// (192,51) @TEXT("ST",size=.75,bold=true,halign="middle");
// %p_MST1_2 = (185,44);
// &CKL @WIRE(mode="horizontal-vertical") {#MST1:2 %p_MST1_2};
// (184.7,44) @TEXT("CKL",size=.75,bold=true,halign="end");
// %p_MST1_3 = (192,38);
// &VSS @WIRE(mode="horizontal-vertical") {#MST1:3 %p_MST1_3};
// (192,37) @TEXT("VSS",size=.75,bold=true,halign="middle");
// %p_MST1_4 = (198,39);
// &VSS @WIRE(mode="horizontal-vertical") {#MST1:4 %p_MST1_4};
// (198.3,39) @TEXT("VSS",size=.75,bold=true,halign="start");
// #MST2 @PLACE(224,44) => @ORIENT("R0");
// #MST2 @TEXT("MST2",key="name",size=.85,dx=2.2,dy=2.5,halign="start");
// #MST2 @TEXT("3um/30nm nf3",key="dims",size=.7,dx=2.2,dy=.3,halign="start");
// %p_MST2_1 = (224,50);
// &ST @WIRE(mode="horizontal-vertical") {#MST2:1 %p_MST2_1};
// (224,51) @TEXT("ST",size=.75,bold=true,halign="middle");
// %p_MST2_2 = (217,44);
// &CKL @WIRE(mode="horizontal-vertical") {#MST2:2 %p_MST2_2};
// (216.7,44) @TEXT("CKL",size=.75,bold=true,halign="end");
// %p_MST2_3 = (224,38);
// &VSS @WIRE(mode="horizontal-vertical") {#MST2:3 %p_MST2_3};
// (224,37) @TEXT("VSS",size=.75,bold=true,halign="middle");
// %p_MST2_4 = (230,39);
// &VSS @WIRE(mode="horizontal-vertical") {#MST2:4 %p_MST2_4};
// (230.3,39) @TEXT("VSS",size=.75,bold=true,halign="start");
// #MLNP @PLACE(192,100) => @ORIENT("R0");
// #MLNP @TEXT("MLNP",key="name",size=.85,dx=2.2,dy=2.5,halign="start");
// #MLNP @TEXT("12um/30nm nf12",key="dims",size=.7,dx=2.2,dy=.3,halign="start");
// %p_MLNP_1 = (192,106);
// &QP @WIRE(mode="horizontal-vertical") {#MLNP:1 %p_MLNP_1};
// (192,107) @TEXT("QP",size=.75,bold=true,halign="middle");
// %p_MLNP_2 = (185,100);
// &QN @WIRE(mode="horizontal-vertical") {#MLNP:2 %p_MLNP_2};
// (184.7,100) @TEXT("QN",size=.75,bold=true,halign="end");
// %p_MLNP_3 = (192,94);
// &XP @WIRE(mode="horizontal-vertical") {#MLNP:3 %p_MLNP_3};
// (192,93) @TEXT("XP",size=.75,bold=true,halign="middle");
// %p_MLNP_4 = (198,95);
// &VSS @WIRE(mode="horizontal-vertical") {#MLNP:4 %p_MLNP_4};
// (198.3,95) @TEXT("VSS",size=.75,bold=true,halign="start");
// #MLNN @PLACE(224,100) => @ORIENT("R0");
// #MLNN @TEXT("MLNN",key="name",size=.85,dx=2.2,dy=2.5,halign="start");
// #MLNN @TEXT("12um/30nm nf12",key="dims",size=.7,dx=2.2,dy=.3,halign="start");
// %p_MLNN_1 = (224,106);
// &QN @WIRE(mode="horizontal-vertical") {#MLNN:1 %p_MLNN_1};
// (224,107) @TEXT("QN",size=.75,bold=true,halign="middle");
// %p_MLNN_2 = (217,100);
// &QP @WIRE(mode="horizontal-vertical") {#MLNN:2 %p_MLNN_2};
// (216.7,100) @TEXT("QP",size=.75,bold=true,halign="end");
// %p_MLNN_3 = (224,94);
// &XN @WIRE(mode="horizontal-vertical") {#MLNN:3 %p_MLNN_3};
// (224,93) @TEXT("XN",size=.75,bold=true,halign="middle");
// %p_MLNN_4 = (230,95);
// &VSS @WIRE(mode="horizontal-vertical") {#MLNN:4 %p_MLNN_4};
// (230.3,95) @TEXT("VSS",size=.75,bold=true,halign="start");
// #MLPP @PLACE(192,128) => @ORIENT("R0");
// #MLPP @TEXT("MLPP",key="name",size=.85,dx=2.2,dy=2.5,halign="start");
// #MLPP @TEXT("8um/30nm nf8",key="dims",size=.7,dx=2.2,dy=.3,halign="start");
// %p_MLPP_1 = (192,122);
// &QP @WIRE(mode="horizontal-vertical") {#MLPP:1 %p_MLPP_1};
// (192,121) @TEXT("QP",size=.75,bold=true,halign="middle");
// %p_MLPP_2 = (185,128);
// &QN @WIRE(mode="horizontal-vertical") {#MLPP:2 %p_MLPP_2};
// (184.7,128) @TEXT("QN",size=.75,bold=true,halign="end");
// %p_MLPP_3 = (192,134);
// &AVDD @WIRE(mode="horizontal-vertical") {#MLPP:3 %p_MLPP_3};
// (192,135) @TEXT("AVDD",size=.75,bold=true,halign="middle");
// %p_MLPP_4 = (198,123);
// &AVDD @WIRE(mode="horizontal-vertical") {#MLPP:4 %p_MLPP_4};
// (198.3,123) @TEXT("AVDD",size=.75,bold=true,halign="start");
// #MLPN @PLACE(224,128) => @ORIENT("R0");
// #MLPN @TEXT("MLPN",key="name",size=.85,dx=2.2,dy=2.5,halign="start");
// #MLPN @TEXT("8um/30nm nf8",key="dims",size=.7,dx=2.2,dy=.3,halign="start");
// %p_MLPN_1 = (224,122);
// &QN @WIRE(mode="horizontal-vertical") {#MLPN:1 %p_MLPN_1};
// (224,121) @TEXT("QN",size=.75,bold=true,halign="middle");
// %p_MLPN_2 = (217,128);
// &QP @WIRE(mode="horizontal-vertical") {#MLPN:2 %p_MLPN_2};
// (216.7,128) @TEXT("QP",size=.75,bold=true,halign="end");
// %p_MLPN_3 = (224,134);
// &AVDD @WIRE(mode="horizontal-vertical") {#MLPN:3 %p_MLPN_3};
// (224,135) @TEXT("AVDD",size=.75,bold=true,halign="middle");
// %p_MLPN_4 = (230,123);
// &AVDD @WIRE(mode="horizontal-vertical") {#MLPN:4 %p_MLPN_4};
// (230.3,123) @TEXT("AVDD",size=.75,bold=true,halign="start");
// #MRXP @PLACE(160,72) => @ORIENT("R0");
// #MRXP @TEXT("MRXP",key="name",size=.85,dx=2.2,dy=2.5,halign="start");
// #MRXP @TEXT("4um/30nm nf4",key="dims",size=.7,dx=2.2,dy=.3,halign="start");
// %p_MRXP_1 = (160,66);
// &XP @WIRE(mode="horizontal-vertical") {#MRXP:1 %p_MRXP_1};
// (160,65) @TEXT("XP",size=.75,bold=true,halign="middle");
// %p_MRXP_2 = (153,72);
// &CKL @WIRE(mode="horizontal-vertical") {#MRXP:2 %p_MRXP_2};
// (152.7,72) @TEXT("CKL",size=.75,bold=true,halign="end");
// %p_MRXP_3 = (160,78);
// &AVDD @WIRE(mode="horizontal-vertical") {#MRXP:3 %p_MRXP_3};
// (160,79) @TEXT("AVDD",size=.75,bold=true,halign="middle");
// %p_MRXP_4 = (166,67);
// &AVDD @WIRE(mode="horizontal-vertical") {#MRXP:4 %p_MRXP_4};
// (166.3,67) @TEXT("AVDD",size=.75,bold=true,halign="start");
// #MRXN @PLACE(256,72) => @ORIENT("R0");
// #MRXN @TEXT("MRXN",key="name",size=.85,dx=2.2,dy=2.5,halign="start");
// #MRXN @TEXT("4um/30nm nf4",key="dims",size=.7,dx=2.2,dy=.3,halign="start");
// %p_MRXN_1 = (256,66);
// &XN @WIRE(mode="horizontal-vertical") {#MRXN:1 %p_MRXN_1};
// (256,65) @TEXT("XN",size=.75,bold=true,halign="middle");
// %p_MRXN_2 = (249,72);
// &CKL @WIRE(mode="horizontal-vertical") {#MRXN:2 %p_MRXN_2};
// (248.7,72) @TEXT("CKL",size=.75,bold=true,halign="end");
// %p_MRXN_3 = (256,78);
// &AVDD @WIRE(mode="horizontal-vertical") {#MRXN:3 %p_MRXN_3};
// (256,79) @TEXT("AVDD",size=.75,bold=true,halign="middle");
// %p_MRXN_4 = (262,67);
// &AVDD @WIRE(mode="horizontal-vertical") {#MRXN:4 %p_MRXN_4};
// (262.3,67) @TEXT("AVDD",size=.75,bold=true,halign="start");
// #MRQP @PLACE(160,128) => @ORIENT("R0");
// #MRQP @TEXT("MRQP",key="name",size=.85,dx=2.2,dy=2.5,halign="start");
// #MRQP @TEXT("16um/30nm nf16",key="dims",size=.7,dx=2.2,dy=.3,halign="start");
// %p_MRQP_1 = (160,122);
// &QP @WIRE(mode="horizontal-vertical") {#MRQP:1 %p_MRQP_1};
// (160,121) @TEXT("QP",size=.75,bold=true,halign="middle");
// %p_MRQP_2 = (153,128);
// &CKL @WIRE(mode="horizontal-vertical") {#MRQP:2 %p_MRQP_2};
// (152.7,128) @TEXT("CKL",size=.75,bold=true,halign="end");
// %p_MRQP_3 = (160,134);
// &AVDD @WIRE(mode="horizontal-vertical") {#MRQP:3 %p_MRQP_3};
// (160,135) @TEXT("AVDD",size=.75,bold=true,halign="middle");
// %p_MRQP_4 = (166,123);
// &AVDD @WIRE(mode="horizontal-vertical") {#MRQP:4 %p_MRQP_4};
// (166.3,123) @TEXT("AVDD",size=.75,bold=true,halign="start");
// #MRQN @PLACE(256,128) => @ORIENT("R0");
// #MRQN @TEXT("MRQN",key="name",size=.85,dx=2.2,dy=2.5,halign="start");
// #MRQN @TEXT("16um/30nm nf16",key="dims",size=.7,dx=2.2,dy=.3,halign="start");
// %p_MRQN_1 = (256,122);
// &QN @WIRE(mode="horizontal-vertical") {#MRQN:1 %p_MRQN_1};
// (256,121) @TEXT("QN",size=.75,bold=true,halign="middle");
// %p_MRQN_2 = (249,128);
// &CKL @WIRE(mode="horizontal-vertical") {#MRQN:2 %p_MRQN_2};
// (248.7,128) @TEXT("CKL",size=.75,bold=true,halign="end");
// %p_MRQN_3 = (256,134);
// &AVDD @WIRE(mode="horizontal-vertical") {#MRQN:3 %p_MRQN_3};
// (256,135) @TEXT("AVDD",size=.75,bold=true,halign="middle");
// %p_MRQN_4 = (262,123);
// &AVDD @WIRE(mode="horizontal-vertical") {#MRQN:4 %p_MRQN_4};
// (262.3,123) @TEXT("AVDD",size=.75,bold=true,halign="start");
// #MOPP @PLACE(288,124) => @ORIENT("R0");
// #MOPP @TEXT("MOPP",key="name",size=.85,dx=2.2,dy=2.5,halign="start");
// #MOPP @TEXT("4um/30nm nf4",key="dims",size=.7,dx=2.2,dy=.3,halign="start");
// %p_MOPP_1 = (288,118);
// &OUTP @WIRE(mode="horizontal-vertical") {#MOPP:1 %p_MOPP_1};
// (288,117) @TEXT("OUTP",size=.75,bold=true,halign="middle");
// %p_MOPP_2 = (281,124);
// &QP @WIRE(mode="horizontal-vertical") {#MOPP:2 %p_MOPP_2};
// (280.7,124) @TEXT("QP",size=.75,bold=true,halign="end");
// %p_MOPP_3 = (288,130);
// &AVDD @WIRE(mode="horizontal-vertical") {#MOPP:3 %p_MOPP_3};
// (288,131) @TEXT("AVDD",size=.75,bold=true,halign="middle");
// %p_MOPP_4 = (294,119);
// &AVDD @WIRE(mode="horizontal-vertical") {#MOPP:4 %p_MOPP_4};
// (294.3,119) @TEXT("AVDD",size=.75,bold=true,halign="start");
// #MOPN @PLACE(288,100) => @ORIENT("R0");
// #MOPN @TEXT("MOPN",key="name",size=.85,dx=2.2,dy=2.5,halign="start");
// #MOPN @TEXT("2um/30nm nf2",key="dims",size=.7,dx=2.2,dy=.3,halign="start");
// %p_MOPN_1 = (288,106);
// &OUTP @WIRE(mode="horizontal-vertical") {#MOPN:1 %p_MOPN_1};
// (288,107) @TEXT("OUTP",size=.75,bold=true,halign="middle");
// %p_MOPN_2 = (281,100);
// &QP @WIRE(mode="horizontal-vertical") {#MOPN:2 %p_MOPN_2};
// (280.7,100) @TEXT("QP",size=.75,bold=true,halign="end");
// %p_MOPN_3 = (288,94);
// &VSS @WIRE(mode="horizontal-vertical") {#MOPN:3 %p_MOPN_3};
// (288,93) @TEXT("VSS",size=.75,bold=true,halign="middle");
// %p_MOPN_4 = (294,95);
// &VSS @WIRE(mode="horizontal-vertical") {#MOPN:4 %p_MOPN_4};
// (294.3,95) @TEXT("VSS",size=.75,bold=true,halign="start");
// #MONP @PLACE(320,124) => @ORIENT("R0");
// #MONP @TEXT("MONP",key="name",size=.85,dx=2.2,dy=2.5,halign="start");
// #MONP @TEXT("4um/30nm nf4",key="dims",size=.7,dx=2.2,dy=.3,halign="start");
// %p_MONP_1 = (320,118);
// &OUTN @WIRE(mode="horizontal-vertical") {#MONP:1 %p_MONP_1};
// (320,117) @TEXT("OUTN",size=.75,bold=true,halign="middle");
// %p_MONP_2 = (313,124);
// &QN @WIRE(mode="horizontal-vertical") {#MONP:2 %p_MONP_2};
// (312.7,124) @TEXT("QN",size=.75,bold=true,halign="end");
// %p_MONP_3 = (320,130);
// &AVDD @WIRE(mode="horizontal-vertical") {#MONP:3 %p_MONP_3};
// (320,131) @TEXT("AVDD",size=.75,bold=true,halign="middle");
// %p_MONP_4 = (326,119);
// &AVDD @WIRE(mode="horizontal-vertical") {#MONP:4 %p_MONP_4};
// (326.3,119) @TEXT("AVDD",size=.75,bold=true,halign="start");
// #MONN @PLACE(320,100) => @ORIENT("R0");
// #MONN @TEXT("MONN",key="name",size=.85,dx=2.2,dy=2.5,halign="start");
// #MONN @TEXT("2um/30nm nf2",key="dims",size=.7,dx=2.2,dy=.3,halign="start");
// %p_MONN_1 = (320,106);
// &OUTN @WIRE(mode="horizontal-vertical") {#MONN:1 %p_MONN_1};
// (320,107) @TEXT("OUTN",size=.75,bold=true,halign="middle");
// %p_MONN_2 = (313,100);
// &QN @WIRE(mode="horizontal-vertical") {#MONN:2 %p_MONN_2};
// (312.7,100) @TEXT("QN",size=.75,bold=true,halign="end");
// %p_MONN_3 = (320,94);
// &VSS @WIRE(mode="horizontal-vertical") {#MONN:3 %p_MONN_3};
// (320,93) @TEXT("VSS",size=.75,bold=true,halign="middle");
// %p_MONN_4 = (326,95);
// &VSS @WIRE(mode="horizontal-vertical") {#MONN:4 %p_MONN_4};
// (326.3,95) @TEXT("VSS",size=.75,bold=true,halign="start");
// #MB0P @PLACE(0,20) => @ORIENT("R0");
// #MB0P @TEXT("MB0P",key="name",size=.85,dx=2.2,dy=2.5,halign="start");
// #MB0P @TEXT("4um/30nm nf4",key="dims",size=.7,dx=2.2,dy=.3,halign="start");
// %p_MB0P_1 = (0,14);
// &CKB @WIRE(mode="horizontal-vertical") {#MB0P:1 %p_MB0P_1};
// (0,13) @TEXT("CKB",size=.75,bold=true,halign="middle");
// %p_MB0P_2 = (-7,20);
// &CLKC @WIRE(mode="horizontal-vertical") {#MB0P:2 %p_MB0P_2};
// (-7.3,20) @TEXT("CLKC",size=.75,bold=true,halign="end");
// %p_MB0P_3 = (0,26);
// &AVDD @WIRE(mode="horizontal-vertical") {#MB0P:3 %p_MB0P_3};
// (0,27) @TEXT("AVDD",size=.75,bold=true,halign="middle");
// %p_MB0P_4 = (6,15);
// &AVDD @WIRE(mode="horizontal-vertical") {#MB0P:4 %p_MB0P_4};
// (6.3,15) @TEXT("AVDD",size=.75,bold=true,halign="start");
// #MB0N @PLACE(0,-4) => @ORIENT("R0");
// #MB0N @TEXT("MB0N",key="name",size=.85,dx=2.2,dy=2.5,halign="start");
// #MB0N @TEXT("2um/30nm nf2",key="dims",size=.7,dx=2.2,dy=.3,halign="start");
// %p_MB0N_1 = (0,2);
// &CKB @WIRE(mode="horizontal-vertical") {#MB0N:1 %p_MB0N_1};
// (0,3) @TEXT("CKB",size=.75,bold=true,halign="middle");
// %p_MB0N_2 = (-7,-4);
// &CLKC @WIRE(mode="horizontal-vertical") {#MB0N:2 %p_MB0N_2};
// (-7.3,-4) @TEXT("CLKC",size=.75,bold=true,halign="end");
// %p_MB0N_3 = (0,-10);
// &VSS @WIRE(mode="horizontal-vertical") {#MB0N:3 %p_MB0N_3};
// (0,-11) @TEXT("VSS",size=.75,bold=true,halign="middle");
// %p_MB0N_4 = (6,-9);
// &VSS @WIRE(mode="horizontal-vertical") {#MB0N:4 %p_MB0N_4};
// (6.3,-9) @TEXT("VSS",size=.75,bold=true,halign="start");
// #MB1P @PLACE(32,20) => @ORIENT("R0");
// #MB1P @TEXT("MB1P",key="name",size=.85,dx=2.2,dy=2.5,halign="start");
// #MB1P @TEXT("8um/30nm nf8",key="dims",size=.7,dx=2.2,dy=.3,halign="start");
// %p_MB1P_1 = (32,14);
// &CKF @WIRE(mode="horizontal-vertical") {#MB1P:1 %p_MB1P_1};
// (32,13) @TEXT("CKF",size=.75,bold=true,halign="middle");
// %p_MB1P_2 = (25,20);
// &CKB @WIRE(mode="horizontal-vertical") {#MB1P:2 %p_MB1P_2};
// (24.7,20) @TEXT("CKB",size=.75,bold=true,halign="end");
// %p_MB1P_3 = (32,26);
// &AVDD @WIRE(mode="horizontal-vertical") {#MB1P:3 %p_MB1P_3};
// (32,27) @TEXT("AVDD",size=.75,bold=true,halign="middle");
// %p_MB1P_4 = (38,15);
// &AVDD @WIRE(mode="horizontal-vertical") {#MB1P:4 %p_MB1P_4};
// (38.3,15) @TEXT("AVDD",size=.75,bold=true,halign="start");
// #MB1N @PLACE(32,-4) => @ORIENT("R0");
// #MB1N @TEXT("MB1N",key="name",size=.85,dx=2.2,dy=2.5,halign="start");
// #MB1N @TEXT("4um/30nm nf4",key="dims",size=.7,dx=2.2,dy=.3,halign="start");
// %p_MB1N_1 = (32,2);
// &CKF @WIRE(mode="horizontal-vertical") {#MB1N:1 %p_MB1N_1};
// (32,3) @TEXT("CKF",size=.75,bold=true,halign="middle");
// %p_MB1N_2 = (25,-4);
// &CKB @WIRE(mode="horizontal-vertical") {#MB1N:2 %p_MB1N_2};
// (24.7,-4) @TEXT("CKB",size=.75,bold=true,halign="end");
// %p_MB1N_3 = (32,-10);
// &VSS @WIRE(mode="horizontal-vertical") {#MB1N:3 %p_MB1N_3};
// (32,-11) @TEXT("VSS",size=.75,bold=true,halign="middle");
// %p_MB1N_4 = (38,-9);
// &VSS @WIRE(mode="horizontal-vertical") {#MB1N:4 %p_MB1N_4};
// (38.3,-9) @TEXT("VSS",size=.75,bold=true,halign="start");
// #MD1P @PLACE(64,20) => @ORIENT("R0");
// #MD1P @TEXT("MD1P",key="name",size=.85,dx=2.2,dy=2.5,halign="start");
// #MD1P @TEXT("4um/30nm nf4",key="dims",size=.7,dx=2.2,dy=.3,halign="start");
// %p_MD1P_1 = (64,14);
// &D1 @WIRE(mode="horizontal-vertical") {#MD1P:1 %p_MD1P_1};
// (64,13) @TEXT("D1",size=.75,bold=true,halign="middle");
// %p_MD1P_2 = (57,20);
// &CKF @WIRE(mode="horizontal-vertical") {#MD1P:2 %p_MD1P_2};
// (56.7,20) @TEXT("CKF",size=.75,bold=true,halign="end");
// %p_MD1P_3 = (64,26);
// &AVDD @WIRE(mode="horizontal-vertical") {#MD1P:3 %p_MD1P_3};
// (64,27) @TEXT("AVDD",size=.75,bold=true,halign="middle");
// %p_MD1P_4 = (70,15);
// &AVDD @WIRE(mode="horizontal-vertical") {#MD1P:4 %p_MD1P_4};
// (70.3,15) @TEXT("AVDD",size=.75,bold=true,halign="start");
// #MD1N @PLACE(64,-4) => @ORIENT("R0");
// #MD1N @TEXT("MD1N",key="name",size=.85,dx=2.2,dy=2.5,halign="start");
// #MD1N @TEXT("2um/30nm nf2",key="dims",size=.7,dx=2.2,dy=.3,halign="start");
// %p_MD1N_1 = (64,2);
// &D1 @WIRE(mode="horizontal-vertical") {#MD1N:1 %p_MD1N_1};
// (64,3) @TEXT("D1",size=.75,bold=true,halign="middle");
// %p_MD1N_2 = (57,-4);
// &CKF @WIRE(mode="horizontal-vertical") {#MD1N:2 %p_MD1N_2};
// (56.7,-4) @TEXT("CKF",size=.75,bold=true,halign="end");
// %p_MD1N_3 = (64,-10);
// &VSS @WIRE(mode="horizontal-vertical") {#MD1N:3 %p_MD1N_3};
// (64,-11) @TEXT("VSS",size=.75,bold=true,halign="middle");
// %p_MD1N_4 = (70,-9);
// &VSS @WIRE(mode="horizontal-vertical") {#MD1N:4 %p_MD1N_4};
// (70.3,-9) @TEXT("VSS",size=.75,bold=true,halign="start");
// #MD2P @PLACE(96,20) => @ORIENT("R0");
// #MD2P @TEXT("MD2P",key="name",size=.85,dx=2.2,dy=2.5,halign="start");
// #MD2P @TEXT("4um/30nm nf4",key="dims",size=.7,dx=2.2,dy=.3,halign="start");
// %p_MD2P_1 = (96,14);
// &D2 @WIRE(mode="horizontal-vertical") {#MD2P:1 %p_MD2P_1};
// (96,13) @TEXT("D2",size=.75,bold=true,halign="middle");
// %p_MD2P_2 = (89,20);
// &D1 @WIRE(mode="horizontal-vertical") {#MD2P:2 %p_MD2P_2};
// (88.7,20) @TEXT("D1",size=.75,bold=true,halign="end");
// %p_MD2P_3 = (96,26);
// &AVDD @WIRE(mode="horizontal-vertical") {#MD2P:3 %p_MD2P_3};
// (96,27) @TEXT("AVDD",size=.75,bold=true,halign="middle");
// %p_MD2P_4 = (102,15);
// &AVDD @WIRE(mode="horizontal-vertical") {#MD2P:4 %p_MD2P_4};
// (102.3,15) @TEXT("AVDD",size=.75,bold=true,halign="start");
// #MD2N @PLACE(96,-4) => @ORIENT("R0");
// #MD2N @TEXT("MD2N",key="name",size=.85,dx=2.2,dy=2.5,halign="start");
// #MD2N @TEXT("2um/30nm nf2",key="dims",size=.7,dx=2.2,dy=.3,halign="start");
// %p_MD2N_1 = (96,2);
// &D2 @WIRE(mode="horizontal-vertical") {#MD2N:1 %p_MD2N_1};
// (96,3) @TEXT("D2",size=.75,bold=true,halign="middle");
// %p_MD2N_2 = (89,-4);
// &D1 @WIRE(mode="horizontal-vertical") {#MD2N:2 %p_MD2N_2};
// (88.7,-4) @TEXT("D1",size=.75,bold=true,halign="end");
// %p_MD2N_3 = (96,-10);
// &VSS @WIRE(mode="horizontal-vertical") {#MD2N:3 %p_MD2N_3};
// (96,-11) @TEXT("VSS",size=.75,bold=true,halign="middle");
// %p_MD2N_4 = (102,-9);
// &VSS @WIRE(mode="horizontal-vertical") {#MD2N:4 %p_MD2N_4};
// (102.3,-9) @TEXT("VSS",size=.75,bold=true,halign="start");
// #MD3P @PLACE(128,20) => @ORIENT("R0");
// #MD3P @TEXT("MD3P",key="name",size=.85,dx=2.2,dy=2.5,halign="start");
// #MD3P @TEXT("4um/30nm nf4",key="dims",size=.7,dx=2.2,dy=.3,halign="start");
// %p_MD3P_1 = (128,14);
// &D3 @WIRE(mode="horizontal-vertical") {#MD3P:1 %p_MD3P_1};
// (128,13) @TEXT("D3",size=.75,bold=true,halign="middle");
// %p_MD3P_2 = (121,20);
// &D2 @WIRE(mode="horizontal-vertical") {#MD3P:2 %p_MD3P_2};
// (120.7,20) @TEXT("D2",size=.75,bold=true,halign="end");
// %p_MD3P_3 = (128,26);
// &AVDD @WIRE(mode="horizontal-vertical") {#MD3P:3 %p_MD3P_3};
// (128,27) @TEXT("AVDD",size=.75,bold=true,halign="middle");
// %p_MD3P_4 = (134,15);
// &AVDD @WIRE(mode="horizontal-vertical") {#MD3P:4 %p_MD3P_4};
// (134.3,15) @TEXT("AVDD",size=.75,bold=true,halign="start");
// #MD3N @PLACE(128,-4) => @ORIENT("R0");
// #MD3N @TEXT("MD3N",key="name",size=.85,dx=2.2,dy=2.5,halign="start");
// #MD3N @TEXT("2um/30nm nf2",key="dims",size=.7,dx=2.2,dy=.3,halign="start");
// %p_MD3N_1 = (128,2);
// &D3 @WIRE(mode="horizontal-vertical") {#MD3N:1 %p_MD3N_1};
// (128,3) @TEXT("D3",size=.75,bold=true,halign="middle");
// %p_MD3N_2 = (121,-4);
// &D2 @WIRE(mode="horizontal-vertical") {#MD3N:2 %p_MD3N_2};
// (120.7,-4) @TEXT("D2",size=.75,bold=true,halign="end");
// %p_MD3N_3 = (128,-10);
// &VSS @WIRE(mode="horizontal-vertical") {#MD3N:3 %p_MD3N_3};
// (128,-11) @TEXT("VSS",size=.75,bold=true,halign="middle");
// %p_MD3N_4 = (134,-9);
// &VSS @WIRE(mode="horizontal-vertical") {#MD3N:4 %p_MD3N_4};
// (134.3,-9) @TEXT("VSS",size=.75,bold=true,halign="start");
// #MD4P @PLACE(160,20) => @ORIENT("R0");
// #MD4P @TEXT("MD4P",key="name",size=.85,dx=2.2,dy=2.5,halign="start");
// #MD4P @TEXT("8um/30nm nf8",key="dims",size=.7,dx=2.2,dy=.3,halign="start");
// %p_MD4P_1 = (160,14);
// &CKD @WIRE(mode="horizontal-vertical") {#MD4P:1 %p_MD4P_1};
// (160,13) @TEXT("CKD",size=.75,bold=true,halign="middle");
// %p_MD4P_2 = (153,20);
// &D3 @WIRE(mode="horizontal-vertical") {#MD4P:2 %p_MD4P_2};
// (152.7,20) @TEXT("D3",size=.75,bold=true,halign="end");
// %p_MD4P_3 = (160,26);
// &AVDD @WIRE(mode="horizontal-vertical") {#MD4P:3 %p_MD4P_3};
// (160,27) @TEXT("AVDD",size=.75,bold=true,halign="middle");
// %p_MD4P_4 = (166,15);
// &AVDD @WIRE(mode="horizontal-vertical") {#MD4P:4 %p_MD4P_4};
// (166.3,15) @TEXT("AVDD",size=.75,bold=true,halign="start");
// #MD4N @PLACE(160,-4) => @ORIENT("R0");
// #MD4N @TEXT("MD4N",key="name",size=.85,dx=2.2,dy=2.5,halign="start");
// #MD4N @TEXT("4um/30nm nf4",key="dims",size=.7,dx=2.2,dy=.3,halign="start");
// %p_MD4N_1 = (160,2);
// &CKD @WIRE(mode="horizontal-vertical") {#MD4N:1 %p_MD4N_1};
// (160,3) @TEXT("CKD",size=.75,bold=true,halign="middle");
// %p_MD4N_2 = (153,-4);
// &D3 @WIRE(mode="horizontal-vertical") {#MD4N:2 %p_MD4N_2};
// (152.7,-4) @TEXT("D3",size=.75,bold=true,halign="end");
// %p_MD4N_3 = (160,-10);
// &VSS @WIRE(mode="horizontal-vertical") {#MD4N:3 %p_MD4N_3};
// (160,-11) @TEXT("VSS",size=.75,bold=true,halign="middle");
// %p_MD4N_4 = (166,-9);
// &VSS @WIRE(mode="horizontal-vertical") {#MD4N:4 %p_MD4N_4};
// (166.3,-9) @TEXT("VSS",size=.75,bold=true,halign="start");
// #MNG1 @PLACE(224,-4) => @ORIENT("R0");
// #MNG1 @TEXT("MNG1",key="name",size=.85,dx=2.2,dy=2.5,halign="start");
// #MNG1 @TEXT("4um/30nm nf4",key="dims",size=.7,dx=2.2,dy=.3,halign="start");
// %p_MNG1_1 = (224,2);
// &CKLB @WIRE(mode="horizontal-vertical") {#MNG1:1 %p_MNG1_1};
// (224,3) @TEXT("CKLB",size=.75,bold=true,halign="middle");
// %p_MNG1_2 = (217,-4);
// &CLKC @WIRE(mode="horizontal-vertical") {#MNG1:2 %p_MNG1_2};
// (216.7,-4) @TEXT("CLKC",size=.75,bold=true,halign="end");
// %p_MNG1_3 = (224,-10);
// &NG @WIRE(mode="horizontal-vertical") {#MNG1:3 %p_MNG1_3};
// (224,-11) @TEXT("NG",size=.75,bold=true,halign="middle");
// %p_MNG1_4 = (230,-9);
// &VSS @WIRE(mode="horizontal-vertical") {#MNG1:4 %p_MNG1_4};
// (230.3,-9) @TEXT("VSS",size=.75,bold=true,halign="start");
// #MNG2 @PLACE(256,-4) => @ORIENT("R0");
// #MNG2 @TEXT("MNG2",key="name",size=.85,dx=2.2,dy=2.5,halign="start");
// #MNG2 @TEXT("4um/30nm nf4",key="dims",size=.7,dx=2.2,dy=.3,halign="start");
// %p_MNG2_1 = (256,2);
// &NG @WIRE(mode="horizontal-vertical") {#MNG2:1 %p_MNG2_1};
// (256,3) @TEXT("NG",size=.75,bold=true,halign="middle");
// %p_MNG2_2 = (249,-4);
// &CKD @WIRE(mode="horizontal-vertical") {#MNG2:2 %p_MNG2_2};
// (248.7,-4) @TEXT("CKD",size=.75,bold=true,halign="end");
// %p_MNG2_3 = (256,-10);
// &VSS @WIRE(mode="horizontal-vertical") {#MNG2:3 %p_MNG2_3};
// (256,-11) @TEXT("VSS",size=.75,bold=true,halign="middle");
// %p_MNG2_4 = (262,-9);
// &VSS @WIRE(mode="horizontal-vertical") {#MNG2:4 %p_MNG2_4};
// (262.3,-9) @TEXT("VSS",size=.75,bold=true,halign="start");
// #MPG1 @PLACE(224,20) => @ORIENT("R0");
// #MPG1 @TEXT("MPG1",key="name",size=.85,dx=2.2,dy=2.5,halign="start");
// #MPG1 @TEXT("4um/30nm nf4",key="dims",size=.7,dx=2.2,dy=.3,halign="start");
// %p_MPG1_1 = (224,14);
// &CKLB @WIRE(mode="horizontal-vertical") {#MPG1:1 %p_MPG1_1};
// (224,13) @TEXT("CKLB",size=.75,bold=true,halign="middle");
// %p_MPG1_2 = (217,20);
// &CLKC @WIRE(mode="horizontal-vertical") {#MPG1:2 %p_MPG1_2};
// (216.7,20) @TEXT("CLKC",size=.75,bold=true,halign="end");
// %p_MPG1_3 = (224,26);
// &AVDD @WIRE(mode="horizontal-vertical") {#MPG1:3 %p_MPG1_3};
// (224,27) @TEXT("AVDD",size=.75,bold=true,halign="middle");
// %p_MPG1_4 = (230,15);
// &AVDD @WIRE(mode="horizontal-vertical") {#MPG1:4 %p_MPG1_4};
// (230.3,15) @TEXT("AVDD",size=.75,bold=true,halign="start");
// #MPG2 @PLACE(256,20) => @ORIENT("R0");
// #MPG2 @TEXT("MPG2",key="name",size=.85,dx=2.2,dy=2.5,halign="start");
// #MPG2 @TEXT("4um/30nm nf4",key="dims",size=.7,dx=2.2,dy=.3,halign="start");
// %p_MPG2_1 = (256,14);
// &CKLB @WIRE(mode="horizontal-vertical") {#MPG2:1 %p_MPG2_1};
// (256,13) @TEXT("CKLB",size=.75,bold=true,halign="middle");
// %p_MPG2_2 = (249,20);
// &CKD @WIRE(mode="horizontal-vertical") {#MPG2:2 %p_MPG2_2};
// (248.7,20) @TEXT("CKD",size=.75,bold=true,halign="end");
// %p_MPG2_3 = (256,26);
// &AVDD @WIRE(mode="horizontal-vertical") {#MPG2:3 %p_MPG2_3};
// (256,27) @TEXT("AVDD",size=.75,bold=true,halign="middle");
// %p_MPG2_4 = (262,15);
// &AVDD @WIRE(mode="horizontal-vertical") {#MPG2:4 %p_MPG2_4};
// (262.3,15) @TEXT("AVDD",size=.75,bold=true,halign="start");
// #MLBP @PLACE(288,20) => @ORIENT("R0");
// #MLBP @TEXT("MLBP",key="name",size=.85,dx=2.2,dy=2.5,halign="start");
// #MLBP @TEXT("16um/30nm nf16",key="dims",size=.7,dx=2.2,dy=.3,halign="start");
// %p_MLBP_1 = (288,14);
// &CKL @WIRE(mode="horizontal-vertical") {#MLBP:1 %p_MLBP_1};
// (288,13) @TEXT("CKL",size=.75,bold=true,halign="middle");
// %p_MLBP_2 = (281,20);
// &CKLB @WIRE(mode="horizontal-vertical") {#MLBP:2 %p_MLBP_2};
// (280.7,20) @TEXT("CKLB",size=.75,bold=true,halign="end");
// %p_MLBP_3 = (288,26);
// &AVDD @WIRE(mode="horizontal-vertical") {#MLBP:3 %p_MLBP_3};
// (288,27) @TEXT("AVDD",size=.75,bold=true,halign="middle");
// %p_MLBP_4 = (294,15);
// &AVDD @WIRE(mode="horizontal-vertical") {#MLBP:4 %p_MLBP_4};
// (294.3,15) @TEXT("AVDD",size=.75,bold=true,halign="start");
// #MLBN @PLACE(288,-4) => @ORIENT("R0");
// #MLBN @TEXT("MLBN",key="name",size=.85,dx=2.2,dy=2.5,halign="start");
// #MLBN @TEXT("8um/30nm nf8",key="dims",size=.7,dx=2.2,dy=.3,halign="start");
// %p_MLBN_1 = (288,2);
// &CKL @WIRE(mode="horizontal-vertical") {#MLBN:1 %p_MLBN_1};
// (288,3) @TEXT("CKL",size=.75,bold=true,halign="middle");
// %p_MLBN_2 = (281,-4);
// &CKLB @WIRE(mode="horizontal-vertical") {#MLBN:2 %p_MLBN_2};
// (280.7,-4) @TEXT("CKLB",size=.75,bold=true,halign="end");
// %p_MLBN_3 = (288,-10);
// &VSS @WIRE(mode="horizontal-vertical") {#MLBN:3 %p_MLBN_3};
// (288,-11) @TEXT("VSS",size=.75,bold=true,halign="middle");
// %p_MLBN_4 = (294,-9);
// &VSS @WIRE(mode="horizontal-vertical") {#MLBN:4 %p_MLBN_4};
// (294.3,-9) @TEXT("VSS",size=.75,bold=true,halign="start");
// #MHEP1 @PLACE(352,20) => @ORIENT("R0");
// #MHEP1 @TEXT("MHEP1",key="name",size=.85,dx=2.2,dy=2.5,halign="start");
// #MHEP1 @TEXT("8um/30nm nf8",key="dims",size=.7,dx=2.2,dy=.3,halign="start");
// %p_MHEP1_1 = (352,14);
// &HP @WIRE(mode="horizontal-vertical") {#MHEP1:1 %p_MHEP1_1};
// (352,13) @TEXT("HP",size=.75,bold=true,halign="middle");
// %p_MHEP1_2 = (345,20);
// &CKB @WIRE(mode="horizontal-vertical") {#MHEP1:2 %p_MHEP1_2};
// (344.7,20) @TEXT("CKB",size=.75,bold=true,halign="end");
// %p_MHEP1_3 = (352,26);
// &AVDD @WIRE(mode="horizontal-vertical") {#MHEP1:3 %p_MHEP1_3};
// (352,27) @TEXT("AVDD",size=.75,bold=true,halign="middle");
// %p_MHEP1_4 = (358,15);
// &AVDD @WIRE(mode="horizontal-vertical") {#MHEP1:4 %p_MHEP1_4};
// (358.3,15) @TEXT("AVDD",size=.75,bold=true,halign="start");
// #MHEP2 @PLACE(384,20) => @ORIENT("R0");
// #MHEP2 @TEXT("MHEP2",key="name",size=.85,dx=2.2,dy=2.5,halign="start");
// #MHEP2 @TEXT("8um/30nm nf8",key="dims",size=.7,dx=2.2,dy=.3,halign="start");
// %p_MHEP2_1 = (384,14);
// &CKE @WIRE(mode="horizontal-vertical") {#MHEP2:1 %p_MHEP2_1};
// (384,13) @TEXT("CKE",size=.75,bold=true,halign="middle");
// %p_MHEP2_2 = (377,20);
// &CKL @WIRE(mode="horizontal-vertical") {#MHEP2:2 %p_MHEP2_2};
// (376.7,20) @TEXT("CKL",size=.75,bold=true,halign="end");
// %p_MHEP2_3 = (384,26);
// &HP @WIRE(mode="horizontal-vertical") {#MHEP2:3 %p_MHEP2_3};
// (384,27) @TEXT("HP",size=.75,bold=true,halign="middle");
// %p_MHEP2_4 = (390,15);
// &AVDD @WIRE(mode="horizontal-vertical") {#MHEP2:4 %p_MHEP2_4};
// (390.3,15) @TEXT("AVDD",size=.75,bold=true,halign="start");
// #MHEN1 @PLACE(352,-4) => @ORIENT("R0");
// #MHEN1 @TEXT("MHEN1",key="name",size=.85,dx=2.2,dy=2.5,halign="start");
// #MHEN1 @TEXT("4um/30nm nf4",key="dims",size=.7,dx=2.2,dy=.3,halign="start");
// %p_MHEN1_1 = (352,2);
// &CKE @WIRE(mode="horizontal-vertical") {#MHEN1:1 %p_MHEN1_1};
// (352,3) @TEXT("CKE",size=.75,bold=true,halign="middle");
// %p_MHEN1_2 = (345,-4);
// &CKB @WIRE(mode="horizontal-vertical") {#MHEN1:2 %p_MHEN1_2};
// (344.7,-4) @TEXT("CKB",size=.75,bold=true,halign="end");
// %p_MHEN1_3 = (352,-10);
// &VSS @WIRE(mode="horizontal-vertical") {#MHEN1:3 %p_MHEN1_3};
// (352,-11) @TEXT("VSS",size=.75,bold=true,halign="middle");
// %p_MHEN1_4 = (358,-9);
// &VSS @WIRE(mode="horizontal-vertical") {#MHEN1:4 %p_MHEN1_4};
// (358.3,-9) @TEXT("VSS",size=.75,bold=true,halign="start");
// #MHEN2 @PLACE(384,-4) => @ORIENT("R0");
// #MHEN2 @TEXT("MHEN2",key="name",size=.85,dx=2.2,dy=2.5,halign="start");
// #MHEN2 @TEXT("4um/30nm nf4",key="dims",size=.7,dx=2.2,dy=.3,halign="start");
// %p_MHEN2_1 = (384,2);
// &CKE @WIRE(mode="horizontal-vertical") {#MHEN2:1 %p_MHEN2_1};
// (384,3) @TEXT("CKE",size=.75,bold=true,halign="middle");
// %p_MHEN2_2 = (377,-4);
// &CKL @WIRE(mode="horizontal-vertical") {#MHEN2:2 %p_MHEN2_2};
// (376.7,-4) @TEXT("CKL",size=.75,bold=true,halign="end");
// %p_MHEN2_3 = (384,-10);
// &VSS @WIRE(mode="horizontal-vertical") {#MHEN2:3 %p_MHEN2_3};
// (384,-11) @TEXT("VSS",size=.75,bold=true,halign="middle");
// %p_MHEN2_4 = (390,-9);
// &VSS @WIRE(mode="horizontal-vertical") {#MHEN2:4 %p_MHEN2_4};
// (390.3,-9) @TEXT("VSS",size=.75,bold=true,halign="start");
// {#MINP #MINN} @AS $MATCHED;
// {#MSIP #MSIN} @AS $MATCHED;
// {#MRDP #MRDN} @AS $MATCHED;
// {#MFT1 #MFT2} @AS $MATCHED;
// {#MST1 #MST2} @AS $MATCHED;
// {#MLNP #MLNN} @AS $MATCHED;
// {#MLPP #MLPN} @AS $MATCHED;
// {#MRXP #MRXN} @AS $MATCHED;
// {#MRQP #MRQN} @AS $MATCHED;
// #MINP(in_p) #MINN(in_n) @AS $DIFFERENTIAL_PAIR;
// #MSIP(in_p) #MSIN(in_n) @AS $DIFFERENTIAL_PAIR;
// {#MINP #MINN #MFT1 #MFT2 #MRDP #MRDN #CDP1 #CDP2 #CDP3 #CDP4 #CDP5 #CDN1 #CDN2 #CDN3 #CDN4 #CDN5} @GROUP;
// {#MSIP #MSIN #MST1 #MST2 #MLNP #MLNN #MLPP #MLPN #MRXP #MRXN #MRQP #MRQN #MOPP #MOPN #MONP #MONN} @GROUP;
// {#MB0P #MB0N #MB1P #MB1N #MD1P #MD1N #MD2P #MD2N #MD3P #MD3N #MD4P #MD4N #MNG1 #MNG2 #MPG1 #MPG2 #MLBP #MLBN #MHEP1 #MHEP2 #MHEN1 #MHEN2} @GROUP;
// }
ends adc_comp
