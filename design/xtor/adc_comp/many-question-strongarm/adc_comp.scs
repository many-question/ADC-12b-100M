// Strongarm comparator core with return-to-zero output interface.
// @RNL(type="header") {
//   @VERSION("0.3");
//   @USE-PACKAGE(name="adc28", version="0.1", path="../../../rnl/adc28.rnl")
// }
simulator lang=spectre
subckt adc_comp (INP INN CLKC OUTP OUTN AVDD VSS)
// Geometry and terminal parasitics are from successful device callbacks.
// INP > INN asserts OUTP. CLKC low resets both external outputs to zero.
MCKN (CKB CLKC VSS VSS) nch_ulvt_mac l=3e-08 w=2e-06 nf=2 m=1 ad=1e-13 as=1.5e-13 pd=2.2e-06 ps=4.3e-06 nrd=0.185844 nrs=0.185844 sa=1.12742e-07 sb=1.12742e-07 sd=1e-07
MCKP (CKB CLKC AVDD AVDD) pch_ulvt_mac l=3e-08 w=4e-06 nf=4 m=1 ad=2e-13 as=2.5e-13 pd=4.4e-06 ps=6.5e-06 nrd=0.048530 nrs=0.048530 sa=1.79203e-07 sb=1.79203e-07 sd=1e-07
MCK2N (CKE CKB VSS VSS) nch_ulvt_mac l=3e-08 w=4e-06 nf=4 m=1 ad=2e-13 as=2.5e-13 pd=4.4e-06 ps=6.5e-06 nrd=0.108289 nrs=0.108289 sa=1.79203e-07 sb=1.79203e-07 sd=1e-07
MCK2P (CKE CKB AVDD AVDD) pch_ulvt_mac l=3e-08 w=8e-06 nf=8 m=1 ad=4e-13 as=4.5e-13 pd=8.8e-06 ps=1.09e-05 nrd=0.024976 nrs=0.024976 sa=2.95835e-07 sb=2.95835e-07 sd=1e-07
MINP (DP INP TAIL VSS) nch_ulvt_mac l=3e-08 w=4.8e-05 nf=48 m=1 ad=2.4e-12 as=2.45e-12 pd=5.28e-05 ps=5.49e-05 nrd=0.010636 nrs=0.010636 sa=1.20441e-06 sb=1.20441e-06 sd=1e-07
MINN (DN INN TAIL VSS) nch_ulvt_mac l=3e-08 w=4.8e-05 nf=48 m=1 ad=2.4e-12 as=2.45e-12 pd=5.28e-05 ps=5.49e-05 nrd=0.010636 nrs=0.010636 sa=1.20441e-06 sb=1.20441e-06 sd=1e-07
MTAIL (TAIL CKE VSS VSS) nch_ulvt_mac l=3e-08 w=4e-06 nf=4 m=1 ad=2e-13 as=2.5e-13 pd=4.4e-06 ps=6.5e-06 nrd=0.108289 nrs=0.108289 sa=1.79203e-07 sb=1.79203e-07 sd=1e-07
MRDP (DP CKE AVDD AVDD) pch_ulvt_mac l=3e-08 w=4e-06 nf=4 m=1 ad=2e-13 as=2.5e-13 pd=4.4e-06 ps=6.5e-06 nrd=0.048530 nrs=0.048530 sa=1.79203e-07 sb=1.79203e-07 sd=1e-07
MRDN (DN CKE AVDD AVDD) pch_ulvt_mac l=3e-08 w=4e-06 nf=4 m=1 ad=2e-13 as=2.5e-13 pd=4.4e-06 ps=6.5e-06 nrd=0.048530 nrs=0.048530 sa=1.79203e-07 sb=1.79203e-07 sd=1e-07
MLNP (QP QN DP VSS) nch_ulvt_mac l=3e-08 w=2e-06 nf=2 m=1 ad=1e-13 as=1.5e-13 pd=2.2e-06 ps=4.3e-06 nrd=0.185844 nrs=0.185844 sa=1.12742e-07 sb=1.12742e-07 sd=1e-07
MLNN (QN QP DN VSS) nch_ulvt_mac l=3e-08 w=2e-06 nf=2 m=1 ad=1e-13 as=1.5e-13 pd=2.2e-06 ps=4.3e-06 nrd=0.185844 nrs=0.185844 sa=1.12742e-07 sb=1.12742e-07 sd=1e-07
MLPP (QP QN AVDD AVDD) pch_ulvt_mac l=3e-08 w=4e-06 nf=4 m=1 ad=2e-13 as=2.5e-13 pd=4.4e-06 ps=6.5e-06 nrd=0.048530 nrs=0.048530 sa=1.79203e-07 sb=1.79203e-07 sd=1e-07
MLPN (QN QP AVDD AVDD) pch_ulvt_mac l=3e-08 w=4e-06 nf=4 m=1 ad=2e-13 as=2.5e-13 pd=4.4e-06 ps=6.5e-06 nrd=0.048530 nrs=0.048530 sa=1.79203e-07 sb=1.79203e-07 sd=1e-07
MRQP (QP CKE AVDD AVDD) pch_ulvt_mac l=3e-08 w=2e-06 nf=2 m=1 ad=1e-13 as=1.5e-13 pd=2.2e-06 ps=4.3e-06 nrd=0.091833 nrs=0.091833 sa=1.12742e-07 sb=1.12742e-07 sd=1e-07
MRQN (QN CKE AVDD AVDD) pch_ulvt_mac l=3e-08 w=2e-06 nf=2 m=1 ad=1e-13 as=1.5e-13 pd=2.2e-06 ps=4.3e-06 nrd=0.091833 nrs=0.091833 sa=1.12742e-07 sb=1.12742e-07 sd=1e-07
MOPN (OUTP QP VSS VSS) nch_ulvt_mac l=3e-08 w=2e-06 nf=2 m=1 ad=1e-13 as=1.5e-13 pd=2.2e-06 ps=4.3e-06 nrd=0.185844 nrs=0.185844 sa=1.12742e-07 sb=1.12742e-07 sd=1e-07
MOPP (OUTP QP AVDD AVDD) pch_ulvt_mac l=3e-08 w=4e-06 nf=4 m=1 ad=2e-13 as=2.5e-13 pd=4.4e-06 ps=6.5e-06 nrd=0.048530 nrs=0.048530 sa=1.79203e-07 sb=1.79203e-07 sd=1e-07
MONN (OUTN QN VSS VSS) nch_ulvt_mac l=3e-08 w=2e-06 nf=2 m=1 ad=1e-13 as=1.5e-13 pd=2.2e-06 ps=4.3e-06 nrd=0.185844 nrs=0.185844 sa=1.12742e-07 sb=1.12742e-07 sd=1e-07
MONP (OUTN QN AVDD AVDD) pch_ulvt_mac l=3e-08 w=4e-06 nf=4 m=1 ad=2e-13 as=2.5e-13 pd=4.4e-06 ps=6.5e-06 nrd=0.048530 nrs=0.048530 sa=1.79203e-07 sb=1.79203e-07 sd=1e-07
// @RNL(author="schematic-review") {
//  &VSS @ADD-TO $GROUND_NET_SET;
//  &AVDD @ADD-TO $SUPPLY_NET_SET;
//  # @SELECT-INSTANCE => @TEXT("", key="model");
//  # @SELECT-INSTANCE => @TEXT("", key="name");
//  $clock_wire = @DEFINE-STYLE(linecolor="#ab6c15", fillcolor="#ab6c15", textcolor="#ab6c15") {};
//  $p_wire = @DEFINE-STYLE(linecolor="#3f5597", fillcolor="#3f5597", textcolor="#3f5597") {};
//  $n_wire = @DEFINE-STYLE(linecolor="#16817a", fillcolor="#16817a", textcolor="#16817a") {};
//  $dynamic_wire = @DEFINE-STYLE(linecolor="#286e97", fillcolor="#286e97", textcolor="#286e97") {};
//  $power_wire = @DEFINE-STYLE(linecolor="#697887", fillcolor="#697887", textcolor="#697887") {};
//  $signal_wire = @DEFINE-STYLE(linecolor="#263442", fillcolor="#263442", textcolor="#263442") {};
//  @LINE(linecolor="#d3dbe4", linewidth=0.08, linestyle="dashed") {(-68, -36) (68, -36) (68, 84) (-68, 84) (-68, -36)};
//  @LINE(linecolor="#d3dbe4", linewidth=0.08, linestyle="dashed") {(-118, 30) (-74, 30) (-74, 76) (-118, 76) (-118, 30)};
//  @LINE(linecolor="#d3dbe4", linewidth=0.08, linestyle="dashed") {(74, 30) (118, 30) (118, 76) (74, 76) (74, 30)};
//  @LINE(linecolor="#d3dbe4", linewidth=0.08, linestyle="dashed") {(-132, -28) (-74, -28) (-74, 20) (-132, 20) (-132, -28)};
//  (0, 96) @TEXT("StrongARM comparator", size=2, bold=true, halign="middle", textcolor="#273747");
//  (0, 91) @TEXT("28 nm HPC+ | ULVT MOS | device labels: W/L and nf", size=0.9, bold=false, halign="middle", textcolor="#526171");
//  (0, 81) @TEXT("Single-stage regenerative core", size=1.35, bold=true, halign="middle", textcolor="#273747");
//  (-96, 73) @TEXT("OUTP buffer", size=1.35, bold=true, halign="middle", textcolor="#273747");
//  (96, 73) @TEXT("OUTN buffer", size=1.35, bold=true, halign="middle", textcolor="#273747");
//  #MLPP @PLACE(-18, 62) => @ORIENT("MY");
//  #MLPP @TEXT("MLPP", key="name", size=1.15, bold=true, halign="end", textcolor="#273747") => @PLACE(-20.8, 63.2);
//  #MLPP @TEXT("4\mu{}m/30nm  nf4", key="dims", size=1, halign="end", textcolor="#526171") => @PLACE(-20.8, 60.5);
//  #MLPN @PLACE(18, 62) => @ORIENT("R0");
//  #MLPN @TEXT("MLPN", key="name", size=1.15, bold=true, halign="start", textcolor="#273747") => @PLACE(20.8, 63.2);
//  #MLPN @TEXT("4\mu{}m/30nm  nf4", key="dims", size=1, halign="start", textcolor="#526171") => @PLACE(20.8, 60.5);
//  #MLNP @PLACE(-18, 38) => @ORIENT("MY");
//  #MLNP @TEXT("MLNP", key="name", size=1.15, bold=true, halign="end", textcolor="#273747") => @PLACE(-20.8, 39.2);
//  #MLNP @TEXT("2\mu{}m/30nm  nf2", key="dims", size=1, halign="end", textcolor="#526171") => @PLACE(-20.8, 36.5);
//  #MLNN @PLACE(18, 38) => @ORIENT("R0");
//  #MLNN @TEXT("MLNN", key="name", size=1.15, bold=true, halign="start", textcolor="#273747") => @PLACE(20.8, 39.2);
//  #MLNN @TEXT("2\mu{}m/30nm  nf2", key="dims", size=1, halign="start", textcolor="#526171") => @PLACE(20.8, 36.5);
//  #MRQP @PLACE(-38, 62) => @ORIENT("R0");
//  #MRQP @TEXT("MRQP", key="name", size=1.15, bold=true, halign="start", textcolor="#273747") => @PLACE(-35.2, 63.2);
//  #MRQP @TEXT("2\mu{}m/30nm  nf2", key="dims", size=1, halign="start", textcolor="#526171") => @PLACE(-35.2, 60.5);
//  #MRQN @PLACE(38, 62) => @ORIENT("MY");
//  #MRQN @TEXT("MRQN", key="name", size=1.15, bold=true, halign="end", textcolor="#273747") => @PLACE(35.2, 63.2);
//  #MRQN @TEXT("2\mu{}m/30nm  nf2", key="dims", size=1, halign="end", textcolor="#526171") => @PLACE(35.2, 60.5);
//  #MRDP @PLACE(-50, 34) => @ORIENT("R0");
//  #MRDP @TEXT("MRDP", key="name", size=1.15, bold=true, halign="start", textcolor="#273747") => @PLACE(-47.2, 35.2);
//  #MRDP @TEXT("4\mu{}m/30nm  nf4", key="dims", size=1, halign="start", textcolor="#526171") => @PLACE(-47.2, 32.5);
//  #MRDN @PLACE(50, 34) => @ORIENT("MY");
//  #MRDN @TEXT("MRDN", key="name", size=1.15, bold=true, halign="end", textcolor="#273747") => @PLACE(47.2, 35.2);
//  #MRDN @TEXT("4\mu{}m/30nm  nf4", key="dims", size=1, halign="end", textcolor="#526171") => @PLACE(47.2, 32.5);
//  #MINP @PLACE(-18, 8) => @ORIENT("R0");
//  #MINP @TEXT("MINP", key="name", size=1.15, bold=true, halign="start", textcolor="#273747") => @PLACE(-15.2, 9.2);
//  #MINP @TEXT("48\mu{}m/30nm  nf48", key="dims", size=1, halign="start", textcolor="#526171") => @PLACE(-15.2, 6.5);
//  #MINN @PLACE(18, 8) => @ORIENT("MY");
//  #MINN @TEXT("MINN", key="name", size=1.15, bold=true, halign="end", textcolor="#273747") => @PLACE(15.2, 9.2);
//  #MINN @TEXT("48\mu{}m/30nm  nf48", key="dims", size=1, halign="end", textcolor="#526171") => @PLACE(15.2, 6.5);
//  #MTAIL @PLACE(0, -12) => @ORIENT("R0");
//  #MTAIL @TEXT("MTAIL", key="name", size=1.15, bold=true, halign="start", textcolor="#273747") => @PLACE(2.8, -10.8);
//  #MTAIL @TEXT("4\mu{}m/30nm  nf4", key="dims", size=1, halign="start", textcolor="#526171") => @PLACE(2.8, -13.5);
//  %core_vdd_0 = (-58, 74);
//  %core_vdd_1 = (-50, 74);
//  $JUNCTION @ATTACH %core_vdd_1 => @SET-STYLE $power_wire;
//  %core_vdd_2 = (-38, 74);
//  $JUNCTION @ATTACH %core_vdd_2 => @SET-STYLE $power_wire;
//  %core_vdd_3 = (-18, 74);
//  $JUNCTION @ATTACH %core_vdd_3 => @SET-STYLE $power_wire;
//  %core_vdd_4 = (0.0, 74);
//  $JUNCTION @ATTACH %core_vdd_4 => @SET-STYLE $power_wire;
//  %core_vdd_5 = (18, 74);
//  $JUNCTION @ATTACH %core_vdd_5 => @SET-STYLE $power_wire;
//  %core_vdd_6 = (38, 74);
//  $JUNCTION @ATTACH %core_vdd_6 => @SET-STYLE $power_wire;
//  %core_vdd_7 = (50, 74);
//  $JUNCTION @ATTACH %core_vdd_7 => @SET-STYLE $power_wire;
//  %core_vdd_8 = (58, 74);
//  &AVDD @WIRE(mode="straight", linecolor="#697887", linewidth=0.11) {%core_vdd_0 %core_vdd_1 %core_vdd_2 %core_vdd_3 %core_vdd_4 %core_vdd_5 %core_vdd_6 %core_vdd_7 %core_vdd_8};
//  %s_MRDP = (-50, 37);
//  $JUNCTION @ATTACH %s_MRDP => @SET-STYLE $power_wire;
//  &AVDD @WIRE(mode="straight", linecolor="#697887", linewidth=0.11) {#MRDP:s %s_MRDP};
//  &AVDD @WIRE(mode="straight", linecolor="#697887", linewidth=0.11) {#MRDP:b (-48, 34) (-48, 37) %s_MRDP};
//  &AVDD @WIRE(mode="straight", linecolor="#697887", linewidth=0.11) {%s_MRDP %core_vdd_1};
//  %s_MRQP = (-38, 65);
//  $JUNCTION @ATTACH %s_MRQP => @SET-STYLE $power_wire;
//  &AVDD @WIRE(mode="straight", linecolor="#697887", linewidth=0.11) {#MRQP:s %s_MRQP};
//  &AVDD @WIRE(mode="straight", linecolor="#697887", linewidth=0.11) {#MRQP:b (-36, 62) (-36, 65) %s_MRQP};
//  &AVDD @WIRE(mode="straight", linecolor="#697887", linewidth=0.11) {%s_MRQP %core_vdd_2};
//  %s_MLPP = (-18, 65);
//  $JUNCTION @ATTACH %s_MLPP => @SET-STYLE $power_wire;
//  &AVDD @WIRE(mode="straight", linecolor="#697887", linewidth=0.11) {#MLPP:s %s_MLPP};
//  &AVDD @WIRE(mode="straight", linecolor="#697887", linewidth=0.11) {#MLPP:b (-20, 62) (-20, 65) %s_MLPP};
//  &AVDD @WIRE(mode="straight", linecolor="#697887", linewidth=0.11) {%s_MLPP %core_vdd_3};
//  %s_MLPN = (18, 65);
//  $JUNCTION @ATTACH %s_MLPN => @SET-STYLE $power_wire;
//  &AVDD @WIRE(mode="straight", linecolor="#697887", linewidth=0.11) {#MLPN:s %s_MLPN};
//  &AVDD @WIRE(mode="straight", linecolor="#697887", linewidth=0.11) {#MLPN:b (20, 62) (20, 65) %s_MLPN};
//  &AVDD @WIRE(mode="straight", linecolor="#697887", linewidth=0.11) {%s_MLPN %core_vdd_5};
//  %s_MRQN = (38, 65);
//  $JUNCTION @ATTACH %s_MRQN => @SET-STYLE $power_wire;
//  &AVDD @WIRE(mode="straight", linecolor="#697887", linewidth=0.11) {#MRQN:s %s_MRQN};
//  &AVDD @WIRE(mode="straight", linecolor="#697887", linewidth=0.11) {#MRQN:b (36, 62) (36, 65) %s_MRQN};
//  &AVDD @WIRE(mode="straight", linecolor="#697887", linewidth=0.11) {%s_MRQN %core_vdd_6};
//  %s_MRDN = (50, 37);
//  $JUNCTION @ATTACH %s_MRDN => @SET-STYLE $power_wire;
//  &AVDD @WIRE(mode="straight", linecolor="#697887", linewidth=0.11) {#MRDN:s %s_MRDN};
//  &AVDD @WIRE(mode="straight", linecolor="#697887", linewidth=0.11) {#MRDN:b (48, 34) (48, 37) %s_MRDN};
//  &AVDD @WIRE(mode="straight", linecolor="#697887", linewidth=0.11) {%s_MRDN %core_vdd_7};
//  %core_vdd_tag = $SUPPLY @ATTACH &AVDD => @PLACE(0.0, 76.5);
//  %core_vdd_tag => @SET-STYLE $power_wire;
//  &AVDD @WIRE(mode="straight", linecolor="#697887", linewidth=0.11) {%core_vdd_4 %core_vdd_tag:p};
//  %b_MLNP = $GROUND @ATTACH &VSS => @PLACE(-29, 35);
//  %b_MLNP => @SET-STYLE $power_wire;
//  %b_MLNP @TEXT("", key="name");
//  &VSS @WIRE(mode="straight", linecolor="#697887", linewidth=0.11) {#MLNP:b (-29, 38) %b_MLNP:p};
//  %b_MLNN = $GROUND @ATTACH &VSS => @PLACE(29, 35);
//  %b_MLNN => @SET-STYLE $power_wire;
//  %b_MLNN @TEXT("", key="name");
//  &VSS @WIRE(mode="straight", linecolor="#697887", linewidth=0.11) {#MLNN:b (29, 38) %b_MLNN:p};
//  %b_MINP = $GROUND @ATTACH &VSS => @PLACE(-7, 5);
//  %b_MINP => @SET-STYLE $power_wire;
//  %b_MINP @TEXT("", key="name");
//  &VSS @WIRE(mode="straight", linecolor="#697887", linewidth=0.11) {#MINP:b (-7, 8) %b_MINP:p};
//  %b_MINN = $GROUND @ATTACH &VSS => @PLACE(7, 5);
//  %b_MINN => @SET-STYLE $power_wire;
//  %b_MINN @TEXT("", key="name");
//  &VSS @WIRE(mode="straight", linecolor="#697887", linewidth=0.11) {#MINN:b (7, 8) %b_MINN:p};
//  %s_MTAIL = (0, -15);
//  $JUNCTION @ATTACH %s_MTAIL => @SET-STYLE $power_wire;
//  &VSS @WIRE(mode="straight", linecolor="#697887", linewidth=0.11) {#MTAIL:s %s_MTAIL};
//  &VSS @WIRE(mode="straight", linecolor="#697887", linewidth=0.11) {#MTAIL:b (2, -12) (2, -15) %s_MTAIL};
//  %g_MTAIL = $GROUND @ATTACH &VSS => @PLACE(0, -22);
//  %g_MTAIL => @SET-STYLE $power_wire;
//  &VSS @WIRE(mode="straight", linecolor="#697887", linewidth=0.11) {%s_MTAIL %g_MTAIL:p};
//  %qp = (-18, 50);
//  $JUNCTION @ATTACH %qp => @SET-STYLE $p_wire;
//  %qn = (18, 45);
//  $JUNCTION @ATTACH %qn => @SET-STYLE $n_wire;
//  %qp_reset = (-38, 50);
//  $JUNCTION @ATTACH %qp_reset => @SET-STYLE $p_wire;
//  %qn_reset = (38, 45);
//  $JUNCTION @ATTACH %qn_reset => @SET-STYLE $n_wire;
//  &QP @WIRE(mode="straight", linecolor="#3f5597", linewidth=0.16) {#MLPP:d %qp #MLNP:d};
//  &QP @WIRE(mode="straight", linecolor="#3f5597", linewidth=0.16) {%qp %qp_reset #MRQP:d};
//  &QN @WIRE(mode="straight", linecolor="#16817a", linewidth=0.16) {#MLPN:d %qn #MLNN:d};
//  &QN @WIRE(mode="straight", linecolor="#16817a", linewidth=0.16) {%qn %qn_reset #MRQN:d};
//  %feedback_qp = (8, 50);
//  $JUNCTION @ATTACH %feedback_qp => @SET-STYLE $p_wire;
//  %feedback_qn = (-8, 45);
//  $JUNCTION @ATTACH %feedback_qn => @SET-STYLE $n_wire;
//  &QP @WIRE(mode="straight", linecolor="#3f5597", linewidth=0.16) {%qp %feedback_qp};
//  &QP @WIRE(mode="straight", linecolor="#3f5597", linewidth=0.16) {#MLPN:g (8, 62) %feedback_qp (8, 38) #MLNN:g};
//  &QN @WIRE(mode="straight", linecolor="#16817a", linewidth=0.16) {%qn %feedback_qn};
//  &QN @WIRE(mode="straight", linecolor="#16817a", linewidth=0.16) {#MLPP:g (-8, 62) %feedback_qn (-8, 38) #MLNP:g};
//  %dp = (-18, 22);
//  $JUNCTION @ATTACH %dp => @SET-STYLE $dynamic_wire;
//  %dn = (18, 22);
//  $JUNCTION @ATTACH %dn => @SET-STYLE $dynamic_wire;
//  &DP @WIRE(mode="straight", linecolor="#286e97", linewidth=0.16) {#MLNP:s %dp #MINP:d};
//  &DP @WIRE(mode="straight", linecolor="#286e97", linewidth=0.16) {#MRDP:d (-50, 22) %dp};
//  &DN @WIRE(mode="straight", linecolor="#286e97", linewidth=0.16) {#MLNN:s %dn #MINN:d};
//  &DN @WIRE(mode="straight", linecolor="#286e97", linewidth=0.16) {#MRDN:d (50, 22) %dn};
//  %tail = (0, 0);
//  $JUNCTION @ATTACH %tail => @SET-STYLE $signal_wire;
//  &TAIL @WIRE(mode="straight", linecolor="#263442", linewidth=0.16) {#MINP:s (-18, 0) %tail (18, 0) #MINN:s};
//  &TAIL @WIRE(mode="straight", linecolor="#263442", linewidth=0.16) {%tail #MTAIL:d};
//  %port_INP = $IO_PORT @ATTACH &INP => @PLACE(-32, 8) => @ORIENT("R0");
//  %port_INP @TEXT("INP", key="name", size=1, bold=true);
//  %port_INN = $IO_PORT @ATTACH &INN => @PLACE(32, 8) => @ORIENT("MY");
//  %port_INN @TEXT("INN", key="name", size=1, bold=true);
//  &INP @WIRE(mode="straight", linecolor="#263442", linewidth=0.16) {%port_INP:p #MINP:g};
//  &INN @WIRE(mode="straight", linecolor="#263442", linewidth=0.16) {%port_INN:p #MINN:g};
//  #MCKP @PLACE(-114, -1) => @ORIENT("R0");
//  #MCKP @TEXT("MCKP", key="name", size=1.15, bold=true, halign="start", textcolor="#273747") => @PLACE(-111.2, 0.19999999999999996);
//  #MCKP @TEXT("4\mu{}m/30nm  nf4", key="dims", size=1, halign="start", textcolor="#526171") => @PLACE(-111.2, -2.5);
//  #MCKN @PLACE(-114, -15) => @ORIENT("R0");
//  #MCKN @TEXT("MCKN", key="name", size=1.15, bold=true, halign="start", textcolor="#273747") => @PLACE(-111.2, -13.8);
//  #MCKN @TEXT("2\mu{}m/30nm  nf2", key="dims", size=1, halign="start", textcolor="#526171") => @PLACE(-111.2, -16.5);
//  %clk1_in = (-120, -8);
//  $JUNCTION @ATTACH %clk1_in => @SET-STYLE $clock_wire;
//  %clk1_out = (-114, -8);
//  $JUNCTION @ATTACH %clk1_out => @SET-STYLE $clock_wire;
//  &CLKC @WIRE(mode="straight", linecolor="#ab6c15", linewidth=0.16) {#MCKP:g (-120, -1) %clk1_in (-120, -15) #MCKN:g};
//  &CKB @WIRE(mode="straight", linecolor="#ab6c15", linewidth=0.16) {#MCKP:d %clk1_out #MCKN:d};
//  #MCK2P @PLACE(-88, -1) => @ORIENT("R0");
//  #MCK2P @TEXT("MCK2P", key="name", size=1.15, bold=true, halign="start", textcolor="#273747") => @PLACE(-85.2, 0.19999999999999996);
//  #MCK2P @TEXT("8\mu{}m/30nm  nf8", key="dims", size=1, halign="start", textcolor="#526171") => @PLACE(-85.2, -2.5);
//  #MCK2N @PLACE(-88, -15) => @ORIENT("R0");
//  #MCK2N @TEXT("MCK2N", key="name", size=1.15, bold=true, halign="start", textcolor="#273747") => @PLACE(-85.2, -13.8);
//  #MCK2N @TEXT("4\mu{}m/30nm  nf4", key="dims", size=1, halign="start", textcolor="#526171") => @PLACE(-85.2, -16.5);
//  %clk2_in = (-94, -8);
//  $JUNCTION @ATTACH %clk2_in => @SET-STYLE $clock_wire;
//  %clk2_out = (-88, -8);
//  $JUNCTION @ATTACH %clk2_out => @SET-STYLE $clock_wire;
//  &CKB @WIRE(mode="straight", linecolor="#ab6c15", linewidth=0.16) {#MCK2P:g (-94, -1) %clk2_in (-94, -15) #MCK2N:g};
//  &CKE @WIRE(mode="straight", linecolor="#ab6c15", linewidth=0.16) {#MCK2P:d %clk2_out #MCK2N:d};
//  %port_CLKC = $IO_PORT @ATTACH &CLKC => @PLACE(-132, -8) => @ORIENT("R0");
//  %port_CLKC @TEXT("CLKC", key="name", size=1, bold=true);
//  &CLKC @WIRE(mode="straight", linecolor="#ab6c15", linewidth=0.16) {%port_CLKC:p %clk1_in};
//  &CKB @WIRE(mode="straight", linecolor="#ab6c15", linewidth=0.16) {%clk1_out %clk2_in};
//  %clock_vdd_0 = (-114, 8);
//  $JUNCTION @ATTACH %clock_vdd_0 => @SET-STYLE $power_wire;
//  %clock_vdd_1 = (-101.0, 8);
//  $JUNCTION @ATTACH %clock_vdd_1 => @SET-STYLE $power_wire;
//  %clock_vdd_2 = (-88, 8);
//  $JUNCTION @ATTACH %clock_vdd_2 => @SET-STYLE $power_wire;
//  &AVDD @WIRE(mode="straight", linecolor="#697887", linewidth=0.11) {%clock_vdd_0 %clock_vdd_1 %clock_vdd_2};
//  %s_MCKP = (-114, 2);
//  $JUNCTION @ATTACH %s_MCKP => @SET-STYLE $power_wire;
//  &AVDD @WIRE(mode="straight", linecolor="#697887", linewidth=0.11) {#MCKP:s %s_MCKP};
//  &AVDD @WIRE(mode="straight", linecolor="#697887", linewidth=0.11) {#MCKP:b (-112, -1) (-112, 2) %s_MCKP};
//  &AVDD @WIRE(mode="straight", linecolor="#697887", linewidth=0.11) {%s_MCKP %clock_vdd_0};
//  %s_MCK2P = (-88, 2);
//  $JUNCTION @ATTACH %s_MCK2P => @SET-STYLE $power_wire;
//  &AVDD @WIRE(mode="straight", linecolor="#697887", linewidth=0.11) {#MCK2P:s %s_MCK2P};
//  &AVDD @WIRE(mode="straight", linecolor="#697887", linewidth=0.11) {#MCK2P:b (-86, -1) (-86, 2) %s_MCK2P};
//  &AVDD @WIRE(mode="straight", linecolor="#697887", linewidth=0.11) {%s_MCK2P %clock_vdd_2};
//  %clock_vdd_tag = $SUPPLY @ATTACH &AVDD => @PLACE(-101.0, 10.5);
//  %clock_vdd_tag => @SET-STYLE $power_wire;
//  &AVDD @WIRE(mode="straight", linecolor="#697887", linewidth=0.11) {%clock_vdd_1 %clock_vdd_tag:p};
//  %clock_vss_0 = (-114, -24);
//  $JUNCTION @ATTACH %clock_vss_0 => @SET-STYLE $power_wire;
//  %clock_vss_1 = (-101.0, -24);
//  $JUNCTION @ATTACH %clock_vss_1 => @SET-STYLE $power_wire;
//  %clock_vss_2 = (-88, -24);
//  $JUNCTION @ATTACH %clock_vss_2 => @SET-STYLE $power_wire;
//  &VSS @WIRE(mode="straight", linecolor="#697887", linewidth=0.11) {%clock_vss_0 %clock_vss_1 %clock_vss_2};
//  %s_MCKN = (-114, -18);
//  $JUNCTION @ATTACH %s_MCKN => @SET-STYLE $power_wire;
//  &VSS @WIRE(mode="straight", linecolor="#697887", linewidth=0.11) {#MCKN:s %s_MCKN};
//  &VSS @WIRE(mode="straight", linecolor="#697887", linewidth=0.11) {#MCKN:b (-112, -15) (-112, -18) %s_MCKN};
//  &VSS @WIRE(mode="straight", linecolor="#697887", linewidth=0.11) {%s_MCKN %clock_vss_0};
//  %s_MCK2N = (-88, -18);
//  $JUNCTION @ATTACH %s_MCK2N => @SET-STYLE $power_wire;
//  &VSS @WIRE(mode="straight", linecolor="#697887", linewidth=0.11) {#MCK2N:s %s_MCK2N};
//  &VSS @WIRE(mode="straight", linecolor="#697887", linewidth=0.11) {#MCK2N:b (-86, -15) (-86, -18) %s_MCK2N};
//  &VSS @WIRE(mode="straight", linecolor="#697887", linewidth=0.11) {%s_MCK2N %clock_vss_2};
//  %clock_vss_tag = $GROUND @ATTACH &VSS => @PLACE(-101.0, -25.5);
//  %clock_vss_tag => @SET-STYLE $power_wire;
//  &VSS @WIRE(mode="straight", linecolor="#697887", linewidth=0.11) {%clock_vss_1 %clock_vss_tag:p};
//  {#MCKP #MCKN #MCK2P #MCK2N} @GROUP;
//  (-101.0, 16) @TEXT("Clock buffer", size=1.35, bold=true, halign="middle", textcolor="#273747");
//  (-101.0, -9) @TEXT("CKB", size=0.8, bold=false, halign="middle", textcolor="#ab6c15");
//  (-80, -6.4) @TEXT("CKE", size=0.8, bold=false, halign="middle", textcolor="#ab6c15");
//  %cke_left = (-64, -30);
//  $JUNCTION @ATTACH %cke_left => @SET-STYLE $clock_wire;
//  %cke_tail = (-8, -30);
//  $JUNCTION @ATTACH %cke_tail => @SET-STYLE $clock_wire;
//  %cke_right = (64, -30);
//  &CKE @WIRE(mode="straight", linecolor="#ab6c15", linewidth=0.16) {%clk2_out (-72, -8) (-72, -30) %cke_left %cke_tail %cke_right};
//  &CKE @WIRE(mode="straight", linecolor="#ab6c15", linewidth=0.16) {%cke_tail (-8, -12) #MTAIL:g};
//  %cke_p_reset = (-64, 34);
//  $JUNCTION @ATTACH %cke_p_reset => @SET-STYLE $clock_wire;
//  &CKE @WIRE(mode="straight", linecolor="#ab6c15", linewidth=0.16) {%cke_left %cke_p_reset (-64, 62) #MRQP:g};
//  &CKE @WIRE(mode="straight", linecolor="#ab6c15", linewidth=0.16) {%cke_p_reset #MRDP:g};
//  %cke_n_reset = (64, 34);
//  $JUNCTION @ATTACH %cke_n_reset => @SET-STYLE $clock_wire;
//  &CKE @WIRE(mode="straight", linecolor="#ab6c15", linewidth=0.16) {%cke_right %cke_n_reset (64, 62) #MRQN:g};
//  &CKE @WIRE(mode="straight", linecolor="#ab6c15", linewidth=0.16) {%cke_n_reset #MRDN:g};
//  #MOPP @PLACE(-90, 57) => @ORIENT("MY");
//  #MOPP @TEXT("MOPP", key="name", size=1.15, bold=true, halign="end", textcolor="#273747") => @PLACE(-92.8, 58.2);
//  #MOPP @TEXT("4\mu{}m/30nm  nf4", key="dims", size=1, halign="end", textcolor="#526171") => @PLACE(-92.8, 55.5);
//  #MOPN @PLACE(-90, 43) => @ORIENT("MY");
//  #MOPN @TEXT("MOPN", key="name", size=1.15, bold=true, halign="end", textcolor="#273747") => @PLACE(-92.8, 44.2);
//  #MOPN @TEXT("2\mu{}m/30nm  nf2", key="dims", size=1, halign="end", textcolor="#526171") => @PLACE(-92.8, 41.5);
//  %outp_buf_in = (-84, 50);
//  $JUNCTION @ATTACH %outp_buf_in => @SET-STYLE $p_wire;
//  %outp_buf_out = (-90, 50);
//  $JUNCTION @ATTACH %outp_buf_out => @SET-STYLE $p_wire;
//  &QP @WIRE(mode="straight", linecolor="#3f5597", linewidth=0.16) {#MOPP:g (-84, 57) %outp_buf_in (-84, 43) #MOPN:g};
//  &OUTP @WIRE(mode="straight", linecolor="#3f5597", linewidth=0.16) {#MOPP:d %outp_buf_out #MOPN:d};
//  &QP @WIRE(mode="straight", linecolor="#3f5597", linewidth=0.16) {%qp_reset %outp_buf_in};
//  %port_OUTP = $IO_PORT @ATTACH &OUTP => @PLACE(-116, 50) => @ORIENT("R0");
//  %port_OUTP @TEXT("OUTP", key="name", size=1, bold=true);
//  &OUTP @WIRE(mode="straight", linecolor="#3f5597", linewidth=0.16) {%outp_buf_out %port_OUTP:p};
//  %outp_vdd_0 = (-98, 66);
//  %outp_vdd_1 = (-90, 66);
//  $JUNCTION @ATTACH %outp_vdd_1 => @SET-STYLE $power_wire;
//  %outp_vdd_2 = (-82, 66);
//  &AVDD @WIRE(mode="straight", linecolor="#697887", linewidth=0.11) {%outp_vdd_0 %outp_vdd_1 %outp_vdd_2};
//  %s_MOPP = (-90, 60);
//  $JUNCTION @ATTACH %s_MOPP => @SET-STYLE $power_wire;
//  &AVDD @WIRE(mode="straight", linecolor="#697887", linewidth=0.11) {#MOPP:s %s_MOPP};
//  &AVDD @WIRE(mode="straight", linecolor="#697887", linewidth=0.11) {#MOPP:b (-92, 57) (-92, 60) %s_MOPP};
//  &AVDD @WIRE(mode="straight", linecolor="#697887", linewidth=0.11) {%s_MOPP %outp_vdd_1};
//  %outp_vdd_tag = $SUPPLY @ATTACH &AVDD => @PLACE(-90.0, 68.5);
//  %outp_vdd_tag => @SET-STYLE $power_wire;
//  &AVDD @WIRE(mode="straight", linecolor="#697887", linewidth=0.11) {%outp_vdd_1 %outp_vdd_tag:p};
//  %outp_vss_0 = (-98, 34);
//  %outp_vss_1 = (-90, 34);
//  $JUNCTION @ATTACH %outp_vss_1 => @SET-STYLE $power_wire;
//  %outp_vss_2 = (-82, 34);
//  &VSS @WIRE(mode="straight", linecolor="#697887", linewidth=0.11) {%outp_vss_0 %outp_vss_1 %outp_vss_2};
//  %s_MOPN = (-90, 40);
//  $JUNCTION @ATTACH %s_MOPN => @SET-STYLE $power_wire;
//  &VSS @WIRE(mode="straight", linecolor="#697887", linewidth=0.11) {#MOPN:s %s_MOPN};
//  &VSS @WIRE(mode="straight", linecolor="#697887", linewidth=0.11) {#MOPN:b (-92, 43) (-92, 40) %s_MOPN};
//  &VSS @WIRE(mode="straight", linecolor="#697887", linewidth=0.11) {%s_MOPN %outp_vss_1};
//  %outp_vss_tag = $GROUND @ATTACH &VSS => @PLACE(-90.0, 32.5);
//  %outp_vss_tag => @SET-STYLE $power_wire;
//  &VSS @WIRE(mode="straight", linecolor="#697887", linewidth=0.11) {%outp_vss_1 %outp_vss_tag:p};
//  {#MOPP #MOPN} @GROUP;
//  #MONP @PLACE(90, 57) => @ORIENT("R0");
//  #MONP @TEXT("MONP", key="name", size=1.15, bold=true, halign="start", textcolor="#273747") => @PLACE(92.8, 58.2);
//  #MONP @TEXT("4\mu{}m/30nm  nf4", key="dims", size=1, halign="start", textcolor="#526171") => @PLACE(92.8, 55.5);
//  #MONN @PLACE(90, 43) => @ORIENT("R0");
//  #MONN @TEXT("MONN", key="name", size=1.15, bold=true, halign="start", textcolor="#273747") => @PLACE(92.8, 44.2);
//  #MONN @TEXT("2\mu{}m/30nm  nf2", key="dims", size=1, halign="start", textcolor="#526171") => @PLACE(92.8, 41.5);
//  %outn_buf_in = (84, 50);
//  $JUNCTION @ATTACH %outn_buf_in => @SET-STYLE $n_wire;
//  %outn_buf_out = (90, 50);
//  $JUNCTION @ATTACH %outn_buf_out => @SET-STYLE $n_wire;
//  &QN @WIRE(mode="straight", linecolor="#16817a", linewidth=0.16) {#MONP:g (84, 57) %outn_buf_in (84, 43) #MONN:g};
//  &OUTN @WIRE(mode="straight", linecolor="#16817a", linewidth=0.16) {#MONP:d %outn_buf_out #MONN:d};
//  &QN @WIRE(mode="straight", linecolor="#16817a", linewidth=0.16) {%qn_reset (70, 45) (70, 50) %outn_buf_in};
//  %port_OUTN = $IO_PORT @ATTACH &OUTN => @PLACE(116, 50) => @ORIENT("MY");
//  %port_OUTN @TEXT("OUTN", key="name", size=1, bold=true);
//  &OUTN @WIRE(mode="straight", linecolor="#16817a", linewidth=0.16) {%outn_buf_out %port_OUTN:p};
//  %outn_vdd_0 = (82, 66);
//  %outn_vdd_1 = (90, 66);
//  $JUNCTION @ATTACH %outn_vdd_1 => @SET-STYLE $power_wire;
//  %outn_vdd_2 = (98, 66);
//  &AVDD @WIRE(mode="straight", linecolor="#697887", linewidth=0.11) {%outn_vdd_0 %outn_vdd_1 %outn_vdd_2};
//  %s_MONP = (90, 60);
//  $JUNCTION @ATTACH %s_MONP => @SET-STYLE $power_wire;
//  &AVDD @WIRE(mode="straight", linecolor="#697887", linewidth=0.11) {#MONP:s %s_MONP};
//  &AVDD @WIRE(mode="straight", linecolor="#697887", linewidth=0.11) {#MONP:b (92, 57) (92, 60) %s_MONP};
//  &AVDD @WIRE(mode="straight", linecolor="#697887", linewidth=0.11) {%s_MONP %outn_vdd_1};
//  %outn_vdd_tag = $SUPPLY @ATTACH &AVDD => @PLACE(90.0, 68.5);
//  %outn_vdd_tag => @SET-STYLE $power_wire;
//  &AVDD @WIRE(mode="straight", linecolor="#697887", linewidth=0.11) {%outn_vdd_1 %outn_vdd_tag:p};
//  %outn_vss_0 = (82, 34);
//  %outn_vss_1 = (90, 34);
//  $JUNCTION @ATTACH %outn_vss_1 => @SET-STYLE $power_wire;
//  %outn_vss_2 = (98, 34);
//  &VSS @WIRE(mode="straight", linecolor="#697887", linewidth=0.11) {%outn_vss_0 %outn_vss_1 %outn_vss_2};
//  %s_MONN = (90, 40);
//  $JUNCTION @ATTACH %s_MONN => @SET-STYLE $power_wire;
//  &VSS @WIRE(mode="straight", linecolor="#697887", linewidth=0.11) {#MONN:s %s_MONN};
//  &VSS @WIRE(mode="straight", linecolor="#697887", linewidth=0.11) {#MONN:b (92, 43) (92, 40) %s_MONN};
//  &VSS @WIRE(mode="straight", linecolor="#697887", linewidth=0.11) {%s_MONN %outn_vss_1};
//  %outn_vss_tag = $GROUND @ATTACH &VSS => @PLACE(90.0, 32.5);
//  %outn_vss_tag => @SET-STYLE $power_wire;
//  &VSS @WIRE(mode="straight", linecolor="#697887", linewidth=0.11) {%outn_vss_1 %outn_vss_tag:p};
//  {#MONP #MONN} @GROUP;
//  (-28, 52) @TEXT("QP", size=0.9, bold=true, halign="middle", textcolor="#3f5597");
//  (28, 47) @TEXT("QN", size=0.9, bold=true, halign="middle", textcolor="#16817a");
//  (-22, 24) @TEXT("DP", size=0.9, bold=true, halign="middle", textcolor="#286e97");
//  (22, 24) @TEXT("DN", size=0.9, bold=true, halign="middle", textcolor="#286e97");
//  (4, -3) @TEXT("TAIL", size=0.8, bold=false, halign="start", textcolor="#526171");
//  (0, -42) @TEXT("Dots mark connections. Crossings without dots are separate nets.", size=0.85, bold=false, halign="middle", textcolor="#526171");
//  %input_pair = #MINP(in_p) #MINN(in_n) #MTAIL(tail) @AS $DIFFERENTIAL_PAIR;
//  %core_axis = (0, 0);
//  {#MINP #MINN} @AS $MATCHED;
//  #MINP(a) #MINN(b) %core_axis(axis) @AS $MIRRORED;
//  {#MRDP #MRDN} @AS $MATCHED;
//  #MRDP(a) #MRDN(b) %core_axis(axis) @AS $MIRRORED;
//  {#MLNP #MLNN} @AS $MATCHED;
//  #MLNP(a) #MLNN(b) %core_axis(axis) @AS $MIRRORED;
//  {#MLPP #MLPN} @AS $MATCHED;
//  #MLPP(a) #MLPN(b) %core_axis(axis) @AS $MIRRORED;
//  {#MRQP #MRQN} @AS $MATCHED;
//  #MRQP(a) #MRQN(b) %core_axis(axis) @AS $MIRRORED;
//  {#MINP #MINN #MTAIL #MRDP #MRDN #MLNP #MLNN #MLPP #MLPN #MRQP #MRQN} @GROUP;
// }
ends adc_comp
