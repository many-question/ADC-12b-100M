// Strongarm comparator core with return-to-zero output interface.
// @RNL(type="header") {
//   @VERSION("0.3");
//   @USE-PACKAGE(name="adc28", version="0.1", path="../../../rnl/adc28.rnl")
// }
simulator lang=spectre
subckt adc_comp (INP INN CLKC OUTP OUTN AVDD VSS)
// Geometry and terminal parasitics are from successful device callbacks.
// INP > INN asserts OUTP. CLKC low resets both external outputs to zero.
MINP (DP INP TAIL VSS) nch_ulvt_mac l=3e-08 w=5.6e-05 nf=56 m=1 ad=2.8e-12 as=2.85e-12 pd=6.16e-05 ps=6.37e-05 nrd=0.009138 nrs=0.009138 sa=1.36619e-06 sb=1.36619e-06 sd=1e-07
MINN (DN INN TAIL VSS) nch_ulvt_mac l=3e-08 w=5.6e-05 nf=56 m=1 ad=2.8e-12 as=2.85e-12 pd=6.16e-05 ps=6.37e-05 nrd=0.009138 nrs=0.009138 sa=1.36619e-06 sb=1.36619e-06 sd=1e-07
MTAIL (TAIL CLKC VSS VSS) nch_ulvt_mac l=3e-08 w=3e-06 nf=3 m=1 ad=1.75e-13 as=1.75e-13 pd=4.35e-06 ps=4.35e-06 nrd=0.136842 nrs=0.136842 sa=1.47042e-07 sb=1.47042e-07 sd=1e-07
MRDP (DP CLKC DPX AVDD) pch_ulvt_mac l=3e-08 w=4e-06 nf=4 m=1 ad=2e-13 as=2.5e-13 pd=4.4e-06 ps=6.5e-06 nrd=0.048530 nrs=0.048530 sa=1.79203e-07 sb=1.79203e-07 sd=1e-07
MRDN (DN CLKC DNX AVDD) pch_ulvt_mac l=3e-08 w=4e-06 nf=4 m=1 ad=2e-13 as=2.5e-13 pd=4.4e-06 ps=6.5e-06 nrd=0.048530 nrs=0.048530 sa=1.79203e-07 sb=1.79203e-07 sd=1e-07
MLNP (QP QN DP VSS) nch_ulvt_mac l=3e-08 w=1.2e-05 nf=12 m=1 ad=6e-13 as=6.5e-13 pd=1.32e-05 ps=1.53e-05 nrd=0.040569 nrs=0.040569 sa=4.01767e-07 sb=4.01767e-07 sd=1e-07
MLNN (QN QP DN VSS) nch_ulvt_mac l=3e-08 w=1.2e-05 nf=12 m=1 ad=6e-13 as=6.5e-13 pd=1.32e-05 ps=1.53e-05 nrd=0.040569 nrs=0.040569 sa=4.01767e-07 sb=4.01767e-07 sd=1e-07
MLPP (QP QN AVDD AVDD) pch_ulvt_mac l=3e-08 w=8e-06 nf=8 m=1 ad=4e-13 as=4.5e-13 pd=8.8e-06 ps=1.09e-05 nrd=0.024976 nrs=0.024976 sa=2.95835e-07 sb=2.95835e-07 sd=1e-07
MLPN (QN QP AVDD AVDD) pch_ulvt_mac l=3e-08 w=8e-06 nf=8 m=1 ad=4e-13 as=4.5e-13 pd=8.8e-06 ps=1.09e-05 nrd=0.024976 nrs=0.024976 sa=2.95835e-07 sb=2.95835e-07 sd=1e-07
MRQP (QP CLKC AVDD AVDD) pch_ulvt_mac l=3e-08 w=2e-06 nf=2 m=1 ad=1e-13 as=1.5e-13 pd=2.2e-06 ps=4.3e-06 nrd=0.091833 nrs=0.091833 sa=1.12742e-07 sb=1.12742e-07 sd=1e-07
MRQN (QN CLKC AVDD AVDD) pch_ulvt_mac l=3e-08 w=2e-06 nf=2 m=1 ad=1e-13 as=1.5e-13 pd=2.2e-06 ps=4.3e-06 nrd=0.091833 nrs=0.091833 sa=1.12742e-07 sb=1.12742e-07 sd=1e-07
MOPN (OUTP QP VSS VSS) nch_ulvt_mac l=3e-08 w=2e-06 nf=2 m=1 ad=1e-13 as=1.5e-13 pd=2.2e-06 ps=4.3e-06 nrd=0.185844 nrs=0.185844 sa=1.12742e-07 sb=1.12742e-07 sd=1e-07
MOPP (OUTP QP AVDD AVDD) pch_ulvt_mac l=3e-08 w=4e-06 nf=4 m=1 ad=2e-13 as=2.5e-13 pd=4.4e-06 ps=6.5e-06 nrd=0.048530 nrs=0.048530 sa=1.79203e-07 sb=1.79203e-07 sd=1e-07
MONN (OUTN QN VSS VSS) nch_ulvt_mac l=3e-08 w=2e-06 nf=2 m=1 ad=1e-13 as=1.5e-13 pd=2.2e-06 ps=4.3e-06 nrd=0.185844 nrs=0.185844 sa=1.12742e-07 sb=1.12742e-07 sd=1e-07
MONP (OUTN QN AVDD AVDD) pch_ulvt_mac l=3e-08 w=4e-06 nf=4 m=1 ad=2e-13 as=2.5e-13 pd=4.4e-06 ps=6.5e-06 nrd=0.048530 nrs=0.048530 sa=1.79203e-07 sb=1.79203e-07 sd=1e-07
CDP (DP VSS) cfmom_2t nr=48 lr=1e-06 w=5e-08 s=5e-08 stm=1 spm=3 multi=1
CDN (DN VSS) cfmom_2t nr=48 lr=1e-06 w=5e-08 s=5e-08 stm=1 spm=3 multi=1
MPDP (DPX CKD AVDD AVDD) pch_ulvt_mac l=3e-08 w=6e-06 nf=6 m=1 ad=3e-13 as=3.5e-13 pd=6.6e-06 ps=8.7e-06 nrd=0.032979 nrs=0.032979 sa=2.39369e-07 sb=2.39369e-07 sd=1e-07
MPDN (DNX CKD AVDD AVDD) pch_ulvt_mac l=3e-08 w=6e-06 nf=6 m=1 ad=3e-13 as=3.5e-13 pd=6.6e-06 ps=8.7e-06 nrd=0.032979 nrs=0.032979 sa=2.39369e-07 sb=2.39369e-07 sd=1e-07
MPQP (QP CKD AVDD AVDD) pch_ulvt_mac l=3e-08 w=4e-06 nf=4 m=1 ad=2e-13 as=2.5e-13 pd=4.4e-06 ps=6.5e-06 nrd=0.048530 nrs=0.048530 sa=1.79203e-07 sb=1.79203e-07 sd=1e-07
MPQN (QN CKD AVDD AVDD) pch_ulvt_mac l=3e-08 w=4e-06 nf=4 m=1 ad=2e-13 as=2.5e-13 pd=4.4e-06 ps=6.5e-06 nrd=0.048530 nrs=0.048530 sa=1.79203e-07 sb=1.79203e-07 sd=1e-07
MCKN (CKB CLKC VSS VSS) nch_ulvt_mac l=3e-08 w=2e-06 nf=2 m=1 ad=1e-13 as=1.5e-13 pd=2.2e-06 ps=4.3e-06 nrd=0.185844 nrs=0.185844 sa=1.12742e-07 sb=1.12742e-07 sd=1e-07
MCKP (CKB CLKC AVDD AVDD) pch_ulvt_mac l=3e-08 w=2e-06 nf=2 m=1 ad=1e-13 as=1.5e-13 pd=2.2e-06 ps=4.3e-06 nrd=0.091833 nrs=0.091833 sa=1.12742e-07 sb=1.12742e-07 sd=1e-07
MCK2N (CKD CKB VSS VSS) nch_ulvt_mac l=3e-08 w=4e-06 nf=4 m=1 ad=2e-13 as=2.5e-13 pd=4.4e-06 ps=6.5e-06 nrd=0.108289 nrs=0.108289 sa=1.79203e-07 sb=1.79203e-07 sd=1e-07
MCK2P (CKD CKB AVDD AVDD) pch_ulvt_mac l=3e-08 w=8e-06 nf=8 m=1 ad=4e-13 as=4.5e-13 pd=8.8e-06 ps=1.09e-05 nrd=0.024976 nrs=0.024976 sa=2.95835e-07 sb=2.95835e-07 sd=1e-07
CCB (CKB VSS) cfmom_2t nr=16 lr=1e-06 w=5e-08 s=5e-08 stm=1 spm=3 multi=1
CCD (CKD VSS) cfmom_2t nr=16 lr=1e-06 w=5e-08 s=5e-08 stm=1 spm=3 multi=1
// @RNL(author="schematic-review") {
//  &VSS @ADD-TO $GROUND_NET_SET;
//  &AVDD @ADD-TO $SUPPLY_NET_SET;
//  # @SELECT-INSTANCE => @TEXT("", key="model");
//  # @SELECT-INSTANCE => @TEXT("", key="name");
//  $clock_wire = @DEFINE-STYLE(linecolor="#ab6c15", fillcolor="#ab6c15", textcolor="#ab6c15") {};
//  $p_wire = @DEFINE-STYLE(linecolor="#3f5597", fillcolor="#3f5597", textcolor="#3f5597") {};
//  $n_wire = @DEFINE-STYLE(linecolor="#16817a", fillcolor="#16817a", textcolor="#16817a") {};
//  $dynamic_wire = @DEFINE-STYLE(linecolor="#286e97", fillcolor="#286e97", textcolor="#286e97") {};
//  $power_wire = @DEFINE-STYLE(linecolor="#697887", fillcolor="#697887", textcolor="#697887") {};
//  $signal_wire = @DEFINE-STYLE(linecolor="#263442", fillcolor="#263442", textcolor="#263442") {};
//  @LINE(linecolor="#d3dbe4", linewidth=0.08, linestyle="dashed") {(-112, -36) (112, -36) (112, 110) (-112, 110) (-112, -36)};
//  @LINE(linecolor="#d3dbe4", linewidth=0.08, linestyle="dashed") {(-158, 30) (-118, 30) (-118, 76) (-158, 76) (-158, 30)};
//  @LINE(linecolor="#d3dbe4", linewidth=0.08, linestyle="dashed") {(118, 30) (158, 30) (158, 76) (118, 76) (118, 30)};
//  @LINE(linecolor="#d3dbe4", linewidth=0.08, linestyle="dashed") {(-194, -44) (-112, -44) (-112, 20) (-194, 20) (-194, -44)};
//  (0, 123) @TEXT("StrongARM comparator", size=2, bold=true, halign="middle", textcolor="#273747");
//  (0, 117) @TEXT("Single-stage latch with staggered precharge and RTZ outputs", size=1.1, bold=false, halign="middle", textcolor="#526171");
//  (0, 112) @TEXT("28 nm HPC+ | ULVT MOS | device labels: W/L and nf", size=0.9, bold=false, halign="middle", textcolor="#526171");
//  (0, 106) @TEXT("Regenerative core", size=1.35, bold=true, halign="middle", textcolor="#273747");
//  (-90, 103) @TEXT("Series DP", size=1.1, bold=true, halign="middle", textcolor="#273747");
//  (-50, 103) @TEXT("Parallel QP", size=1.1, bold=true, halign="middle", textcolor="#273747");
//  (90, 103) @TEXT("Series DN", size=1.1, bold=true, halign="middle", textcolor="#273747");
//  (50, 103) @TEXT("Parallel QN", size=1.1, bold=true, halign="middle", textcolor="#273747");
//  (-138, 73) @TEXT("RTZ OUTP", size=1.35, bold=true, halign="middle", textcolor="#273747");
//  (138, 73) @TEXT("RTZ OUTN", size=1.35, bold=true, halign="middle", textcolor="#273747");
//  (-150, 14) @TEXT("Clock drive and damping", size=1.35, bold=true, halign="middle", textcolor="#273747");
//  #MLPP @PLACE(-18, 62) => @ORIENT("MY");
//  #MLPP @TEXT("MLPP", key="name", size=1.15, bold=true, halign="end", textcolor="#273747") => @PLACE(-20.8, 63.2);
//  #MLPP @TEXT("8\mu{}m/30nm  nf8", key="dims", size=1, halign="end", textcolor="#526171") => @PLACE(-20.8, 60.5);
//  #MLPN @PLACE(18, 62) => @ORIENT("R0");
//  #MLPN @TEXT("MLPN", key="name", size=1.15, bold=true, halign="start", textcolor="#273747") => @PLACE(20.8, 63.2);
//  #MLPN @TEXT("8\mu{}m/30nm  nf8", key="dims", size=1, halign="start", textcolor="#526171") => @PLACE(20.8, 60.5);
//  #MLNP @PLACE(-18, 38) => @ORIENT("MY");
//  #MLNP @TEXT("MLNP", key="name", size=1.15, bold=true, halign="end", textcolor="#273747") => @PLACE(-20.8, 42.5);
//  #MLNP @TEXT("12\mu{}m/30nm  nf12", key="dims", size=1, halign="end", textcolor="#526171") => @PLACE(-20.8, 40.2);
//  #MLNN @PLACE(18, 38) => @ORIENT("R0");
//  #MLNN @TEXT("MLNN", key="name", size=1.15, bold=true, halign="start", textcolor="#273747") => @PLACE(20.8, 42.5);
//  #MLNN @TEXT("12\mu{}m/30nm  nf12", key="dims", size=1, halign="start", textcolor="#526171") => @PLACE(20.8, 40.2);
//  #MRQP @PLACE(-38, 76) => @ORIENT("MY");
//  #MRQP @TEXT("MRQP", key="name", size=1.15, bold=true, halign="end", textcolor="#273747") => @PLACE(-40.8, 77.2);
//  #MRQP @TEXT("2\mu{}m/30nm  nf2", key="dims", size=1, halign="end", textcolor="#526171") => @PLACE(-40.8, 74.5);
//  #MRQN @PLACE(38, 76) => @ORIENT("R0");
//  #MRQN @TEXT("MRQN", key="name", size=1.15, bold=true, halign="start", textcolor="#273747") => @PLACE(40.8, 77.2);
//  #MRQN @TEXT("2\mu{}m/30nm  nf2", key="dims", size=1, halign="start", textcolor="#526171") => @PLACE(40.8, 74.5);
//  #MPQP @PLACE(-62, 76) => @ORIENT("R0");
//  #MPQP @TEXT("MPQP", key="name", size=1.15, bold=true, halign="start", textcolor="#273747") => @PLACE(-59.2, 77.2);
//  #MPQP @TEXT("4\mu{}m/30nm  nf4", key="dims", size=1, halign="start", textcolor="#526171") => @PLACE(-59.2, 74.5);
//  #MPQN @PLACE(62, 76) => @ORIENT("MY");
//  #MPQN @TEXT("MPQN", key="name", size=1.15, bold=true, halign="end", textcolor="#273747") => @PLACE(59.2, 77.2);
//  #MPQN @TEXT("4\mu{}m/30nm  nf4", key="dims", size=1, halign="end", textcolor="#526171") => @PLACE(59.2, 74.5);
//  #MPDP @PLACE(-90, 76) => @ORIENT("R0");
//  #MPDP @TEXT("MPDP", key="name", size=1.15, bold=true, halign="start", textcolor="#273747") => @PLACE(-87.2, 77.2);
//  #MPDP @TEXT("6\mu{}m/30nm  nf6", key="dims", size=1, halign="start", textcolor="#526171") => @PLACE(-87.2, 74.5);
//  #MPDN @PLACE(90, 76) => @ORIENT("MY");
//  #MPDN @TEXT("MPDN", key="name", size=1.15, bold=true, halign="end", textcolor="#273747") => @PLACE(87.2, 77.2);
//  #MPDN @TEXT("6\mu{}m/30nm  nf6", key="dims", size=1, halign="end", textcolor="#526171") => @PLACE(87.2, 74.5);
//  #MRDP @PLACE(-90, 56) => @ORIENT("R0");
//  #MRDP @TEXT("MRDP", key="name", size=1.15, bold=true, halign="start", textcolor="#273747") => @PLACE(-87.2, 57.2);
//  #MRDP @TEXT("4\mu{}m/30nm  nf4", key="dims", size=1, halign="start", textcolor="#526171") => @PLACE(-87.2, 54.5);
//  #MRDN @PLACE(90, 56) => @ORIENT("MY");
//  #MRDN @TEXT("MRDN", key="name", size=1.15, bold=true, halign="end", textcolor="#273747") => @PLACE(87.2, 57.2);
//  #MRDN @TEXT("4\mu{}m/30nm  nf4", key="dims", size=1, halign="end", textcolor="#526171") => @PLACE(87.2, 54.5);
//  #MINP @PLACE(-18, 8) => @ORIENT("R0");
//  #MINP @TEXT("MINP", key="name", size=1.15, bold=true, halign="start", textcolor="#273747") => @PLACE(-15.2, 12.5);
//  #MINP @TEXT("56\mu{}m/30nm  nf56", key="dims", size=1, halign="start", textcolor="#526171") => @PLACE(-15.2, 10.2);
//  #MINN @PLACE(18, 8) => @ORIENT("MY");
//  #MINN @TEXT("MINN", key="name", size=1.15, bold=true, halign="end", textcolor="#273747") => @PLACE(15.2, 12.5);
//  #MINN @TEXT("56\mu{}m/30nm  nf56", key="dims", size=1, halign="end", textcolor="#526171") => @PLACE(15.2, 10.2);
//  #MTAIL @PLACE(0, -12) => @ORIENT("R0");
//  #MTAIL @TEXT("MTAIL", key="name", size=1.15, bold=true, halign="start", textcolor="#273747") => @PLACE(2.8, -10.8);
//  #MTAIL @TEXT("3\mu{}m/30nm  nf3", key="dims", size=1, halign="start", textcolor="#526171") => @PLACE(2.8, -13.5);
//  %core_vdd_0 = (-98, 96);
//  %core_vdd_1 = (-90, 96);
//  $JUNCTION @ATTACH %core_vdd_1 => @SET-STYLE $power_wire;
//  %core_vdd_2 = (-62, 96);
//  $JUNCTION @ATTACH %core_vdd_2 => @SET-STYLE $power_wire;
//  %core_vdd_3 = (-38, 96);
//  $JUNCTION @ATTACH %core_vdd_3 => @SET-STYLE $power_wire;
//  %core_vdd_4 = (-18, 96);
//  $JUNCTION @ATTACH %core_vdd_4 => @SET-STYLE $power_wire;
//  %core_vdd_5 = (0.0, 96);
//  $JUNCTION @ATTACH %core_vdd_5 => @SET-STYLE $power_wire;
//  %core_vdd_6 = (18, 96);
//  $JUNCTION @ATTACH %core_vdd_6 => @SET-STYLE $power_wire;
//  %core_vdd_7 = (38, 96);
//  $JUNCTION @ATTACH %core_vdd_7 => @SET-STYLE $power_wire;
//  %core_vdd_8 = (62, 96);
//  $JUNCTION @ATTACH %core_vdd_8 => @SET-STYLE $power_wire;
//  %core_vdd_9 = (90, 96);
//  $JUNCTION @ATTACH %core_vdd_9 => @SET-STYLE $power_wire;
//  %core_vdd_10 = (98, 96);
//  &AVDD @WIRE(mode="straight", linecolor="#697887", linewidth=0.11) {%core_vdd_0 %core_vdd_1 %core_vdd_2 %core_vdd_3 %core_vdd_4 %core_vdd_5 %core_vdd_6 %core_vdd_7 %core_vdd_8 %core_vdd_9 %core_vdd_10};
//  %s_MPDP = (-90, 79);
//  $JUNCTION @ATTACH %s_MPDP => @SET-STYLE $power_wire;
//  &AVDD @WIRE(mode="straight", linecolor="#697887", linewidth=0.11) {#MPDP:s %s_MPDP};
//  &AVDD @WIRE(mode="straight", linecolor="#697887", linewidth=0.11) {#MPDP:b (-88, 76) (-88, 79) %s_MPDP};
//  &AVDD @WIRE(mode="straight", linecolor="#697887", linewidth=0.11) {%s_MPDP %core_vdd_1};
//  %s_MPQP = (-62, 79);
//  $JUNCTION @ATTACH %s_MPQP => @SET-STYLE $power_wire;
//  &AVDD @WIRE(mode="straight", linecolor="#697887", linewidth=0.11) {#MPQP:s %s_MPQP};
//  &AVDD @WIRE(mode="straight", linecolor="#697887", linewidth=0.11) {#MPQP:b (-60, 76) (-60, 79) %s_MPQP};
//  &AVDD @WIRE(mode="straight", linecolor="#697887", linewidth=0.11) {%s_MPQP %core_vdd_2};
//  %s_MRQP = (-38, 79);
//  $JUNCTION @ATTACH %s_MRQP => @SET-STYLE $power_wire;
//  &AVDD @WIRE(mode="straight", linecolor="#697887", linewidth=0.11) {#MRQP:s %s_MRQP};
//  &AVDD @WIRE(mode="straight", linecolor="#697887", linewidth=0.11) {#MRQP:b (-40, 76) (-40, 79) %s_MRQP};
//  &AVDD @WIRE(mode="straight", linecolor="#697887", linewidth=0.11) {%s_MRQP %core_vdd_3};
//  %s_MLPP = (-18, 65);
//  $JUNCTION @ATTACH %s_MLPP => @SET-STYLE $power_wire;
//  &AVDD @WIRE(mode="straight", linecolor="#697887", linewidth=0.11) {#MLPP:s %s_MLPP};
//  &AVDD @WIRE(mode="straight", linecolor="#697887", linewidth=0.11) {#MLPP:b (-20, 62) (-20, 65) %s_MLPP};
//  &AVDD @WIRE(mode="straight", linecolor="#697887", linewidth=0.11) {%s_MLPP %core_vdd_4};
//  %s_MLPN = (18, 65);
//  $JUNCTION @ATTACH %s_MLPN => @SET-STYLE $power_wire;
//  &AVDD @WIRE(mode="straight", linecolor="#697887", linewidth=0.11) {#MLPN:s %s_MLPN};
//  &AVDD @WIRE(mode="straight", linecolor="#697887", linewidth=0.11) {#MLPN:b (20, 62) (20, 65) %s_MLPN};
//  &AVDD @WIRE(mode="straight", linecolor="#697887", linewidth=0.11) {%s_MLPN %core_vdd_6};
//  %s_MRQN = (38, 79);
//  $JUNCTION @ATTACH %s_MRQN => @SET-STYLE $power_wire;
//  &AVDD @WIRE(mode="straight", linecolor="#697887", linewidth=0.11) {#MRQN:s %s_MRQN};
//  &AVDD @WIRE(mode="straight", linecolor="#697887", linewidth=0.11) {#MRQN:b (40, 76) (40, 79) %s_MRQN};
//  &AVDD @WIRE(mode="straight", linecolor="#697887", linewidth=0.11) {%s_MRQN %core_vdd_7};
//  %s_MPQN = (62, 79);
//  $JUNCTION @ATTACH %s_MPQN => @SET-STYLE $power_wire;
//  &AVDD @WIRE(mode="straight", linecolor="#697887", linewidth=0.11) {#MPQN:s %s_MPQN};
//  &AVDD @WIRE(mode="straight", linecolor="#697887", linewidth=0.11) {#MPQN:b (60, 76) (60, 79) %s_MPQN};
//  &AVDD @WIRE(mode="straight", linecolor="#697887", linewidth=0.11) {%s_MPQN %core_vdd_8};
//  %s_MPDN = (90, 79);
//  $JUNCTION @ATTACH %s_MPDN => @SET-STYLE $power_wire;
//  &AVDD @WIRE(mode="straight", linecolor="#697887", linewidth=0.11) {#MPDN:s %s_MPDN};
//  &AVDD @WIRE(mode="straight", linecolor="#697887", linewidth=0.11) {#MPDN:b (88, 76) (88, 79) %s_MPDN};
//  &AVDD @WIRE(mode="straight", linecolor="#697887", linewidth=0.11) {%s_MPDN %core_vdd_9};
//  %core_vdd_tag = $SUPPLY @ATTACH &AVDD => @PLACE(0.0, 98.5);
//  %core_vdd_tag => @SET-STYLE $power_wire;
//  &AVDD @WIRE(mode="straight", linecolor="#697887", linewidth=0.11) {%core_vdd_5 %core_vdd_tag:p};
//  %b_MRDP = $SUPPLY @ATTACH &AVDD => @PLACE(-79, 60);
//  %b_MRDP => @SET-STYLE $power_wire;
//  &AVDD @WIRE(mode="straight", linecolor="#697887", linewidth=0.11) {#MRDP:b (-79, 56) %b_MRDP:p};
//  %b_MRDN = $SUPPLY @ATTACH &AVDD => @PLACE(79, 60);
//  %b_MRDN => @SET-STYLE $power_wire;
//  &AVDD @WIRE(mode="straight", linecolor="#697887", linewidth=0.11) {#MRDN:b (79, 56) %b_MRDN:p};
//  %b_MLNP = $GROUND @ATTACH &VSS => @PLACE(-29, 35);
//  %b_MLNP => @SET-STYLE $power_wire;
//  %b_MLNP @TEXT("", key="name");
//  &VSS @WIRE(mode="straight", linecolor="#697887", linewidth=0.11) {#MLNP:b (-29, 38) %b_MLNP:p};
//  %b_MLNN = $GROUND @ATTACH &VSS => @PLACE(29, 35);
//  %b_MLNN => @SET-STYLE $power_wire;
//  %b_MLNN @TEXT("", key="name");
//  &VSS @WIRE(mode="straight", linecolor="#697887", linewidth=0.11) {#MLNN:b (29, 38) %b_MLNN:p};
//  %b_MINP = $GROUND @ATTACH &VSS => @PLACE(-7, 5);
//  %b_MINP => @SET-STYLE $power_wire;
//  %b_MINP @TEXT("", key="name");
//  &VSS @WIRE(mode="straight", linecolor="#697887", linewidth=0.11) {#MINP:b (-7, 8) %b_MINP:p};
//  %b_MINN = $GROUND @ATTACH &VSS => @PLACE(7, 5);
//  %b_MINN => @SET-STYLE $power_wire;
//  %b_MINN @TEXT("", key="name");
//  &VSS @WIRE(mode="straight", linecolor="#697887", linewidth=0.11) {#MINN:b (7, 8) %b_MINN:p};
//  %s_MTAIL = (0, -15);
//  $JUNCTION @ATTACH %s_MTAIL => @SET-STYLE $power_wire;
//  &VSS @WIRE(mode="straight", linecolor="#697887", linewidth=0.11) {#MTAIL:s %s_MTAIL};
//  &VSS @WIRE(mode="straight", linecolor="#697887", linewidth=0.11) {#MTAIL:b (2, -12) (2, -15) %s_MTAIL};
//  %g_MTAIL = $GROUND @ATTACH &VSS => @PLACE(0, -22);
//  %g_MTAIL => @SET-STYLE $power_wire;
//  &VSS @WIRE(mode="straight", linecolor="#697887", linewidth=0.11) {%s_MTAIL %g_MTAIL:p};
//  %dpx = (-90, 68);
//  $JUNCTION @ATTACH %dpx => @SET-STYLE $dynamic_wire;
//  %dnx = (90, 68);
//  $JUNCTION @ATTACH %dnx => @SET-STYLE $dynamic_wire;
//  &DPX @WIRE(mode="straight", linecolor="#286e97", linewidth=0.16) {#MPDP:d %dpx #MRDP:s};
//  &DNX @WIRE(mode="straight", linecolor="#286e97", linewidth=0.16) {#MPDN:d %dnx #MRDN:s};
//  (-95, 70) @TEXT("DPX", size=1, bold=true, halign="middle", textcolor="#286e97");
//  (95, 70) @TEXT("DNX", size=1, bold=true, halign="middle", textcolor="#286e97");
//  %dp = (-18, 22);
//  $JUNCTION @ATTACH %dp => @SET-STYLE $dynamic_wire;
//  %dn = (18, 22);
//  $JUNCTION @ATTACH %dn => @SET-STYLE $dynamic_wire;
//  %dp_cap = (-66, 22);
//  $JUNCTION @ATTACH %dp_cap => @SET-STYLE $dynamic_wire;
//  %dn_cap = (66, 22);
//  $JUNCTION @ATTACH %dn_cap => @SET-STYLE $dynamic_wire;
//  &DP @WIRE(mode="straight", linecolor="#286e97", linewidth=0.16) {#MRDP:d (-90, 22) %dp_cap %dp};
//  &DN @WIRE(mode="straight", linecolor="#286e97", linewidth=0.16) {#MRDN:d (90, 22) %dn_cap %dn};
//  &DP @WIRE(mode="straight", linecolor="#286e97", linewidth=0.16) {#MLNP:s %dp #MINP:d};
//  &DN @WIRE(mode="straight", linecolor="#286e97", linewidth=0.16) {#MLNN:s %dn #MINN:d};
//  #CDP @PLACE(-66, 8) => @ORIENT("R0");
//  #CDP @TEXT("CDP", key="name", size=1.15, bold=true, halign="end", textcolor="#273747") => @PLACE(-69, 9.5);
//  #CDP @TEXT("14.06 fF nominal", key="value", size=0.95, halign="end", textcolor="#526171") => @PLACE(-69, 6.7);
//  #CDP @TEXT("nr=48, lr=1\mu{}m", key="geometry", size=0.9, halign="end", textcolor="#526171") => @PLACE(-69, 3.9000000000000004);
//  &DP @WIRE(mode="straight", linecolor="#286e97", linewidth=0.16) {%dp_cap #CDP:p};
//  %g_CDP = $GROUND @ATTACH &VSS => @PLACE(-66, 0);
//  %g_CDP => @SET-STYLE $power_wire;
//  &VSS @WIRE(mode="straight", linecolor="#697887", linewidth=0.11) {#CDP:n %g_CDP:p};
//  #CDN @PLACE(66, 8) => @ORIENT("MY");
//  #CDN @TEXT("CDN", key="name", size=1.15, bold=true, halign="start", textcolor="#273747") => @PLACE(69, 9.5);
//  #CDN @TEXT("14.06 fF nominal", key="value", size=0.95, halign="start", textcolor="#526171") => @PLACE(69, 6.7);
//  #CDN @TEXT("nr=48, lr=1\mu{}m", key="geometry", size=0.9, halign="start", textcolor="#526171") => @PLACE(69, 3.9000000000000004);
//  &DN @WIRE(mode="straight", linecolor="#286e97", linewidth=0.16) {%dn_cap #CDN:p};
//  %g_CDN = $GROUND @ATTACH &VSS => @PLACE(66, 0);
//  %g_CDN => @SET-STYLE $power_wire;
//  &VSS @WIRE(mode="straight", linecolor="#697887", linewidth=0.11) {#CDN:n %g_CDN:p};
//  (-22, 24) @TEXT("DP", size=1, bold=true, halign="middle", textcolor="#286e97");
//  (22, 24) @TEXT("DN", size=1, bold=true, halign="middle", textcolor="#286e97");
//  %qp = (-18, 50);
//  $JUNCTION @ATTACH %qp => @SET-STYLE $p_wire;
//  %qn = (18, 45);
//  $JUNCTION @ATTACH %qn => @SET-STYLE $n_wire;
//  %qp_direct = (-38, 50);
//  $JUNCTION @ATTACH %qp_direct => @SET-STYLE $p_wire;
//  %qn_direct = (38, 45);
//  $JUNCTION @ATTACH %qn_direct => @SET-STYLE $n_wire;
//  %qp_delayed = (-62, 50);
//  $JUNCTION @ATTACH %qp_delayed => @SET-STYLE $p_wire;
//  %qn_delayed = (62, 45);
//  $JUNCTION @ATTACH %qn_delayed => @SET-STYLE $n_wire;
//  &QP @WIRE(mode="straight", linecolor="#3f5597", linewidth=0.16) {#MLPP:d %qp #MLNP:d};
//  &QN @WIRE(mode="straight", linecolor="#16817a", linewidth=0.16) {#MLPN:d %qn #MLNN:d};
//  &QP @WIRE(mode="straight", linecolor="#3f5597", linewidth=0.16) {%qp %qp_direct %qp_delayed};
//  &QN @WIRE(mode="straight", linecolor="#16817a", linewidth=0.16) {%qn %qn_direct %qn_delayed};
//  &QP @WIRE(mode="straight", linecolor="#3f5597", linewidth=0.16) {#MRQP:d %qp_direct};
//  &QP @WIRE(mode="straight", linecolor="#3f5597", linewidth=0.16) {#MPQP:d %qp_delayed};
//  &QN @WIRE(mode="straight", linecolor="#16817a", linewidth=0.16) {#MRQN:d %qn_direct};
//  &QN @WIRE(mode="straight", linecolor="#16817a", linewidth=0.16) {#MPQN:d %qn_delayed};
//  %feedback_qp = (8, 50);
//  $JUNCTION @ATTACH %feedback_qp => @SET-STYLE $p_wire;
//  %feedback_qn = (-8, 45);
//  $JUNCTION @ATTACH %feedback_qn => @SET-STYLE $n_wire;
//  &QP @WIRE(mode="straight", linecolor="#3f5597", linewidth=0.16) {%qp %feedback_qp};
//  &QP @WIRE(mode="straight", linecolor="#3f5597", linewidth=0.16) {#MLPN:g (8, 62) %feedback_qp (8, 38) #MLNN:g};
//  &QN @WIRE(mode="straight", linecolor="#16817a", linewidth=0.16) {%qn %feedback_qn};
//  &QN @WIRE(mode="straight", linecolor="#16817a", linewidth=0.16) {#MLPP:g (-8, 62) %feedback_qn (-8, 38) #MLNP:g};
//  (-26, 52) @TEXT("QP", size=1, bold=true, halign="middle", textcolor="#3f5597");
//  (26, 47) @TEXT("QN", size=1, bold=true, halign="middle", textcolor="#16817a");
//  %tail = (0, 0);
//  $JUNCTION @ATTACH %tail => @SET-STYLE $signal_wire;
//  &TAIL @WIRE(mode="straight", linecolor="#263442", linewidth=0.16) {#MINP:s (-18, 0) %tail (18, 0) #MINN:s};
//  &TAIL @WIRE(mode="straight", linecolor="#263442", linewidth=0.16) {%tail #MTAIL:d};
//  %port_INP = $IO_PORT @ATTACH &INP => @PLACE(-32, 8) => @ORIENT("R0");
//  %port_INP @TEXT("INP", key="name", size=1, bold=true);
//  %port_INN = $IO_PORT @ATTACH &INN => @PLACE(32, 8) => @ORIENT("MY");
//  %port_INN @TEXT("INN", key="name", size=1, bold=true);
//  &INP @WIRE(mode="straight", linecolor="#263442", linewidth=0.16) {%port_INP:p #MINP:g};
//  &INN @WIRE(mode="straight", linecolor="#263442", linewidth=0.16) {%port_INN:p #MINN:g};
//  (4, -3) @TEXT("TAIL", size=0.9, bold=false, halign="start", textcolor="#526171");
//  #MOPP @PLACE(-136, 57) => @ORIENT("MY");
//  #MOPP @TEXT("MOPP", key="name", size=1.15, bold=true, halign="end", textcolor="#273747") => @PLACE(-138.8, 58.2);
//  #MOPP @TEXT("4\mu{}m/30nm  nf4", key="dims", size=1, halign="end", textcolor="#526171") => @PLACE(-138.8, 55.5);
//  #MOPN @PLACE(-136, 43) => @ORIENT("MY");
//  #MOPN @TEXT("MOPN", key="name", size=1.15, bold=true, halign="end", textcolor="#273747") => @PLACE(-138.8, 44.2);
//  #MOPN @TEXT("2\mu{}m/30nm  nf2", key="dims", size=1, halign="end", textcolor="#526171") => @PLACE(-138.8, 41.5);
//  %outp_buffer_in = (-130, 50);
//  $JUNCTION @ATTACH %outp_buffer_in => @SET-STYLE $p_wire;
//  %outp_buffer_out = (-136, 50);
//  $JUNCTION @ATTACH %outp_buffer_out => @SET-STYLE $p_wire;
//  &QP @WIRE(mode="straight", linecolor="#3f5597", linewidth=0.16) {#MOPP:g (-130, 57) %outp_buffer_in (-130, 43) #MOPN:g};
//  &OUTP @WIRE(mode="straight", linecolor="#3f5597", linewidth=0.16) {#MOPP:d %outp_buffer_out #MOPN:d};
//  &QP @WIRE(mode="straight", linecolor="#3f5597", linewidth=0.16) {%qp_delayed %outp_buffer_in};
//  %port_OUTP = $IO_PORT @ATTACH &OUTP => @PLACE(-168, 50) => @ORIENT("R0");
//  %port_OUTP @TEXT("OUTP", key="name", size=1, bold=true);
//  &OUTP @WIRE(mode="straight", linecolor="#3f5597", linewidth=0.16) {%outp_buffer_out %port_OUTP:p};
//  %outp_vdd_0 = (-144, 66);
//  %outp_vdd_1 = (-136, 66);
//  $JUNCTION @ATTACH %outp_vdd_1 => @SET-STYLE $power_wire;
//  %outp_vdd_2 = (-128, 66);
//  &AVDD @WIRE(mode="straight", linecolor="#697887", linewidth=0.11) {%outp_vdd_0 %outp_vdd_1 %outp_vdd_2};
//  %s_MOPP = (-136, 60);
//  $JUNCTION @ATTACH %s_MOPP => @SET-STYLE $power_wire;
//  &AVDD @WIRE(mode="straight", linecolor="#697887", linewidth=0.11) {#MOPP:s %s_MOPP};
//  &AVDD @WIRE(mode="straight", linecolor="#697887", linewidth=0.11) {#MOPP:b (-138, 57) (-138, 60) %s_MOPP};
//  &AVDD @WIRE(mode="straight", linecolor="#697887", linewidth=0.11) {%s_MOPP %outp_vdd_1};
//  %outp_vdd_tag = $SUPPLY @ATTACH &AVDD => @PLACE(-136.0, 68.5);
//  %outp_vdd_tag => @SET-STYLE $power_wire;
//  &AVDD @WIRE(mode="straight", linecolor="#697887", linewidth=0.11) {%outp_vdd_1 %outp_vdd_tag:p};
//  %outp_vss_0 = (-144, 34);
//  %outp_vss_1 = (-136, 34);
//  $JUNCTION @ATTACH %outp_vss_1 => @SET-STYLE $power_wire;
//  %outp_vss_2 = (-128, 34);
//  &VSS @WIRE(mode="straight", linecolor="#697887", linewidth=0.11) {%outp_vss_0 %outp_vss_1 %outp_vss_2};
//  %s_MOPN = (-136, 40);
//  $JUNCTION @ATTACH %s_MOPN => @SET-STYLE $power_wire;
//  &VSS @WIRE(mode="straight", linecolor="#697887", linewidth=0.11) {#MOPN:s %s_MOPN};
//  &VSS @WIRE(mode="straight", linecolor="#697887", linewidth=0.11) {#MOPN:b (-138, 43) (-138, 40) %s_MOPN};
//  &VSS @WIRE(mode="straight", linecolor="#697887", linewidth=0.11) {%s_MOPN %outp_vss_1};
//  %outp_vss_tag = $GROUND @ATTACH &VSS => @PLACE(-136.0, 32.5);
//  %outp_vss_tag => @SET-STYLE $power_wire;
//  &VSS @WIRE(mode="straight", linecolor="#697887", linewidth=0.11) {%outp_vss_1 %outp_vss_tag:p};
//  {#MOPP #MOPN} @GROUP;
//  #MONP @PLACE(136, 57) => @ORIENT("R0");
//  #MONP @TEXT("MONP", key="name", size=1.15, bold=true, halign="start", textcolor="#273747") => @PLACE(138.8, 58.2);
//  #MONP @TEXT("4\mu{}m/30nm  nf4", key="dims", size=1, halign="start", textcolor="#526171") => @PLACE(138.8, 55.5);
//  #MONN @PLACE(136, 43) => @ORIENT("R0");
//  #MONN @TEXT("MONN", key="name", size=1.15, bold=true, halign="start", textcolor="#273747") => @PLACE(138.8, 44.2);
//  #MONN @TEXT("2\mu{}m/30nm  nf2", key="dims", size=1, halign="start", textcolor="#526171") => @PLACE(138.8, 41.5);
//  %outn_buffer_in = (130, 50);
//  $JUNCTION @ATTACH %outn_buffer_in => @SET-STYLE $n_wire;
//  %outn_buffer_out = (136, 50);
//  $JUNCTION @ATTACH %outn_buffer_out => @SET-STYLE $n_wire;
//  &QN @WIRE(mode="straight", linecolor="#16817a", linewidth=0.16) {#MONP:g (130, 57) %outn_buffer_in (130, 43) #MONN:g};
//  &OUTN @WIRE(mode="straight", linecolor="#16817a", linewidth=0.16) {#MONP:d %outn_buffer_out #MONN:d};
//  &QN @WIRE(mode="straight", linecolor="#16817a", linewidth=0.16) {%qn_delayed (116, 45) (116, 50) %outn_buffer_in};
//  %port_OUTN = $IO_PORT @ATTACH &OUTN => @PLACE(168, 50) => @ORIENT("MY");
//  %port_OUTN @TEXT("OUTN", key="name", size=1, bold=true);
//  &OUTN @WIRE(mode="straight", linecolor="#16817a", linewidth=0.16) {%outn_buffer_out %port_OUTN:p};
//  %outn_vdd_0 = (128, 66);
//  %outn_vdd_1 = (136, 66);
//  $JUNCTION @ATTACH %outn_vdd_1 => @SET-STYLE $power_wire;
//  %outn_vdd_2 = (144, 66);
//  &AVDD @WIRE(mode="straight", linecolor="#697887", linewidth=0.11) {%outn_vdd_0 %outn_vdd_1 %outn_vdd_2};
//  %s_MONP = (136, 60);
//  $JUNCTION @ATTACH %s_MONP => @SET-STYLE $power_wire;
//  &AVDD @WIRE(mode="straight", linecolor="#697887", linewidth=0.11) {#MONP:s %s_MONP};
//  &AVDD @WIRE(mode="straight", linecolor="#697887", linewidth=0.11) {#MONP:b (138, 57) (138, 60) %s_MONP};
//  &AVDD @WIRE(mode="straight", linecolor="#697887", linewidth=0.11) {%s_MONP %outn_vdd_1};
//  %outn_vdd_tag = $SUPPLY @ATTACH &AVDD => @PLACE(136.0, 68.5);
//  %outn_vdd_tag => @SET-STYLE $power_wire;
//  &AVDD @WIRE(mode="straight", linecolor="#697887", linewidth=0.11) {%outn_vdd_1 %outn_vdd_tag:p};
//  %outn_vss_0 = (128, 34);
//  %outn_vss_1 = (136, 34);
//  $JUNCTION @ATTACH %outn_vss_1 => @SET-STYLE $power_wire;
//  %outn_vss_2 = (144, 34);
//  &VSS @WIRE(mode="straight", linecolor="#697887", linewidth=0.11) {%outn_vss_0 %outn_vss_1 %outn_vss_2};
//  %s_MONN = (136, 40);
//  $JUNCTION @ATTACH %s_MONN => @SET-STYLE $power_wire;
//  &VSS @WIRE(mode="straight", linecolor="#697887", linewidth=0.11) {#MONN:s %s_MONN};
//  &VSS @WIRE(mode="straight", linecolor="#697887", linewidth=0.11) {#MONN:b (138, 43) (138, 40) %s_MONN};
//  &VSS @WIRE(mode="straight", linecolor="#697887", linewidth=0.11) {%s_MONN %outn_vss_1};
//  %outn_vss_tag = $GROUND @ATTACH &VSS => @PLACE(136.0, 32.5);
//  %outn_vss_tag => @SET-STYLE $power_wire;
//  &VSS @WIRE(mode="straight", linecolor="#697887", linewidth=0.11) {%outn_vss_1 %outn_vss_tag:p};
//  {#MONP #MONN} @GROUP;
//  #MCKP @PLACE(-166, -3) => @ORIENT("R0");
//  #MCKP @TEXT("MCKP", key="name", size=1.15, bold=true, halign="start", textcolor="#273747") => @PLACE(-163.2, -1.8);
//  #MCKP @TEXT("2\mu{}m/30nm  nf2", key="dims", size=1, halign="start", textcolor="#526171") => @PLACE(-163.2, -4.5);
//  #MCKN @PLACE(-166, -17) => @ORIENT("R0");
//  #MCKN @TEXT("MCKN", key="name", size=1.15, bold=true, halign="start", textcolor="#273747") => @PLACE(-163.2, -15.8);
//  #MCKN @TEXT("2\mu{}m/30nm  nf2", key="dims", size=1, halign="start", textcolor="#526171") => @PLACE(-163.2, -18.5);
//  %clock1_in = (-172, -10);
//  $JUNCTION @ATTACH %clock1_in => @SET-STYLE $clock_wire;
//  %clock1_out = (-166, -10);
//  $JUNCTION @ATTACH %clock1_out => @SET-STYLE $clock_wire;
//  &CLKC @WIRE(mode="straight", linecolor="#ab6c15", linewidth=0.16) {#MCKP:g (-172, -3) %clock1_in (-172, -17) #MCKN:g};
//  &CKB @WIRE(mode="straight", linecolor="#ab6c15", linewidth=0.16) {#MCKP:d %clock1_out #MCKN:d};
//  #MCK2P @PLACE(-132, -3) => @ORIENT("R0");
//  #MCK2P @TEXT("MCK2P", key="name", size=1.15, bold=true, halign="start", textcolor="#273747") => @PLACE(-129.2, -1.8);
//  #MCK2P @TEXT("8\mu{}m/30nm  nf8", key="dims", size=1, halign="start", textcolor="#526171") => @PLACE(-129.2, -4.5);
//  #MCK2N @PLACE(-132, -17) => @ORIENT("R0");
//  #MCK2N @TEXT("MCK2N", key="name", size=1.15, bold=true, halign="start", textcolor="#273747") => @PLACE(-129.2, -15.8);
//  #MCK2N @TEXT("4\mu{}m/30nm  nf4", key="dims", size=1, halign="start", textcolor="#526171") => @PLACE(-129.2, -18.5);
//  %clock2_in = (-138, -10);
//  $JUNCTION @ATTACH %clock2_in => @SET-STYLE $clock_wire;
//  %clock2_out = (-132, -10);
//  $JUNCTION @ATTACH %clock2_out => @SET-STYLE $clock_wire;
//  &CKB @WIRE(mode="straight", linecolor="#ab6c15", linewidth=0.16) {#MCK2P:g (-138, -3) %clock2_in (-138, -17) #MCK2N:g};
//  &CKD @WIRE(mode="straight", linecolor="#ab6c15", linewidth=0.16) {#MCK2P:d %clock2_out #MCK2N:d};
//  %ckb_damping = (-150, -10);
//  $JUNCTION @ATTACH %ckb_damping => @SET-STYLE $clock_wire;
//  %ckd_damping = (-116, -10);
//  $JUNCTION @ATTACH %ckd_damping => @SET-STYLE $clock_wire;
//  &CKB @WIRE(mode="straight", linecolor="#ab6c15", linewidth=0.16) {%clock1_out %ckb_damping %clock2_in};
//  &CKD @WIRE(mode="straight", linecolor="#ab6c15", linewidth=0.16) {%clock2_out %ckd_damping};
//  %clock_vdd_0 = (-166, 6);
//  $JUNCTION @ATTACH %clock_vdd_0 => @SET-STYLE $power_wire;
//  %clock_vdd_1 = (-149.0, 6);
//  $JUNCTION @ATTACH %clock_vdd_1 => @SET-STYLE $power_wire;
//  %clock_vdd_2 = (-132, 6);
//  $JUNCTION @ATTACH %clock_vdd_2 => @SET-STYLE $power_wire;
//  &AVDD @WIRE(mode="straight", linecolor="#697887", linewidth=0.11) {%clock_vdd_0 %clock_vdd_1 %clock_vdd_2};
//  %s_MCKP = (-166, 0);
//  $JUNCTION @ATTACH %s_MCKP => @SET-STYLE $power_wire;
//  &AVDD @WIRE(mode="straight", linecolor="#697887", linewidth=0.11) {#MCKP:s %s_MCKP};
//  &AVDD @WIRE(mode="straight", linecolor="#697887", linewidth=0.11) {#MCKP:b (-164, -3) (-164, 0) %s_MCKP};
//  &AVDD @WIRE(mode="straight", linecolor="#697887", linewidth=0.11) {%s_MCKP %clock_vdd_0};
//  %s_MCK2P = (-132, 0);
//  $JUNCTION @ATTACH %s_MCK2P => @SET-STYLE $power_wire;
//  &AVDD @WIRE(mode="straight", linecolor="#697887", linewidth=0.11) {#MCK2P:s %s_MCK2P};
//  &AVDD @WIRE(mode="straight", linecolor="#697887", linewidth=0.11) {#MCK2P:b (-130, -3) (-130, 0) %s_MCK2P};
//  &AVDD @WIRE(mode="straight", linecolor="#697887", linewidth=0.11) {%s_MCK2P %clock_vdd_2};
//  %clock_vdd_tag = $SUPPLY @ATTACH &AVDD => @PLACE(-149.0, 8.5);
//  %clock_vdd_tag => @SET-STYLE $power_wire;
//  &AVDD @WIRE(mode="straight", linecolor="#697887", linewidth=0.11) {%clock_vdd_1 %clock_vdd_tag:p};
//  %s_MCKN = (-166, -20);
//  $JUNCTION @ATTACH %s_MCKN => @SET-STYLE $power_wire;
//  &VSS @WIRE(mode="straight", linecolor="#697887", linewidth=0.11) {#MCKN:s %s_MCKN};
//  &VSS @WIRE(mode="straight", linecolor="#697887", linewidth=0.11) {#MCKN:b (-164, -17) (-164, -20) %s_MCKN};
//  %g_MCKN = $GROUND @ATTACH &VSS => @PLACE(-166, -26);
//  %g_MCKN => @SET-STYLE $power_wire;
//  &VSS @WIRE(mode="straight", linecolor="#697887", linewidth=0.11) {%s_MCKN %g_MCKN:p};
//  %s_MCK2N = (-132, -20);
//  $JUNCTION @ATTACH %s_MCK2N => @SET-STYLE $power_wire;
//  &VSS @WIRE(mode="straight", linecolor="#697887", linewidth=0.11) {#MCK2N:s %s_MCK2N};
//  &VSS @WIRE(mode="straight", linecolor="#697887", linewidth=0.11) {#MCK2N:b (-130, -17) (-130, -20) %s_MCK2N};
//  %g_MCK2N = $GROUND @ATTACH &VSS => @PLACE(-132, -26);
//  %g_MCK2N => @SET-STYLE $power_wire;
//  &VSS @WIRE(mode="straight", linecolor="#697887", linewidth=0.11) {%s_MCK2N %g_MCK2N:p};
//  #CCB @PLACE(-150, -28) => @ORIENT("MY");
//  #CCB @TEXT("CCB", key="name", size=1.15, bold=true, halign="start", textcolor="#273747") => @PLACE(-147, -26.5);
//  #CCB @TEXT("4.46051 fF nominal", key="value", size=0.95, halign="start", textcolor="#526171") => @PLACE(-147, -29.3);
//  #CCB @TEXT("nr=16, lr=1\mu{}m", key="geometry", size=0.9, halign="start", textcolor="#526171") => @PLACE(-147, -32.1);
//  &CKB @WIRE(mode="straight", linecolor="#ab6c15", linewidth=0.16) {%ckb_damping #CCB:p};
//  %g_CCB = $GROUND @ATTACH &VSS => @PLACE(-150, -36);
//  %g_CCB => @SET-STYLE $power_wire;
//  &VSS @WIRE(mode="straight", linecolor="#697887", linewidth=0.11) {#CCB:n %g_CCB:p};
//  #CCD @PLACE(-116, -28) => @ORIENT("R0");
//  #CCD @TEXT("CCD", key="name", size=1.15, bold=true, halign="end", textcolor="#273747") => @PLACE(-119, -26.5);
//  #CCD @TEXT("4.46051 fF nominal", key="value", size=0.95, halign="end", textcolor="#526171") => @PLACE(-119, -29.3);
//  #CCD @TEXT("nr=16, lr=1\mu{}m", key="geometry", size=0.9, halign="end", textcolor="#526171") => @PLACE(-119, -32.1);
//  &CKD @WIRE(mode="straight", linecolor="#ab6c15", linewidth=0.16) {%ckd_damping #CCD:p};
//  %g_CCD = $GROUND @ATTACH &VSS => @PLACE(-116, -36);
//  %g_CCD => @SET-STYLE $power_wire;
//  &VSS @WIRE(mode="straight", linecolor="#697887", linewidth=0.11) {#CCD:n %g_CCD:p};
//  (-157, -7.5) @TEXT("CKB", size=1, bold=true, halign="middle", textcolor="#ab6c15");
//  (-123, -7.5) @TEXT("CKD", size=1, bold=true, halign="middle", textcolor="#ab6c15");
//  %port_CLKC = $IO_PORT @ATTACH &CLKC => @PLACE(-198, -10) => @ORIENT("R0");
//  %port_CLKC @TEXT("CLKC", key="name", size=1, bold=true);
//  %clk_direct = (-186, -10);
//  $JUNCTION @ATTACH %clk_direct => @SET-STYLE $clock_wire;
//  &CLKC @WIRE(mode="straight", linecolor="#ab6c15", linewidth=0.16) {%port_CLKC:p %clk_direct %clock1_in};
//  %clk_left = (-108, 14);
//  $JUNCTION @ATTACH %clk_left => @SET-STYLE $clock_wire;
//  %clk_right = (108, 14);
//  %clk_qp = (-32, 14);
//  $JUNCTION @ATTACH %clk_qp => @SET-STYLE $clock_wire;
//  %clk_qn = (32, 14);
//  $JUNCTION @ATTACH %clk_qn => @SET-STYLE $clock_wire;
//  %clk_tail_branch = (-108, -30);
//  $JUNCTION @ATTACH %clk_tail_branch => @SET-STYLE $clock_wire;
//  &CLKC @WIRE(mode="straight", linecolor="#ab6c15", linewidth=0.16) {%clk_direct (-186, -48) (-108, -48) %clk_tail_branch %clk_left %clk_qp %clk_qn %clk_right};
//  &CLKC @WIRE(mode="straight", linecolor="#ab6c15", linewidth=0.16) {%clk_left (-108, 56) #MRDP:g};
//  &CLKC @WIRE(mode="straight", linecolor="#ab6c15", linewidth=0.16) {%clk_right (108, 56) #MRDN:g};
//  &CLKC @WIRE(mode="straight", linecolor="#ab6c15", linewidth=0.16) {%clk_qp (-32, 76) #MRQP:g};
//  &CLKC @WIRE(mode="straight", linecolor="#ab6c15", linewidth=0.16) {%clk_qn (32, 76) #MRQN:g};
//  &CLKC @WIRE(mode="straight", linecolor="#ab6c15", linewidth=0.16) {%clk_tail_branch (-8, -30) (-8, -12) #MTAIL:g};
//  (-105, -34) @TEXT("CLKC", size=1, bold=true, halign="start", textcolor="#ab6c15");
//  (0, 16) @TEXT("CLKC", size=1, bold=true, halign="middle", textcolor="#ab6c15");
//  %ckd_qp = (-70, 88);
//  $JUNCTION @ATTACH %ckd_qp => @SET-STYLE $clock_wire;
//  %ckd_qn = (70, 88);
//  $JUNCTION @ATTACH %ckd_qn => @SET-STYLE $clock_wire;
//  &CKD @WIRE(mode="straight", linecolor="#ab6c15", linewidth=0.16) {%ckd_damping (-116, 88) %ckd_series_p %ckd_qp %ckd_qn (100, 88) (100, 76) #MPDN:g};
//  %ckd_series_p = (-100, 88);
//  $JUNCTION @ATTACH %ckd_series_p => @SET-STYLE $clock_wire;
//  &CKD @WIRE(mode="straight", linecolor="#ab6c15", linewidth=0.16) {%ckd_series_p (-100, 76) #MPDP:g};
//  &CKD @WIRE(mode="straight", linecolor="#ab6c15", linewidth=0.16) {%ckd_qp (-70, 76) #MPQP:g};
//  &CKD @WIRE(mode="straight", linecolor="#ab6c15", linewidth=0.16) {%ckd_qn (70, 76) #MPQN:g};
//  (0, 90.4) @TEXT("CKD", size=1, bold=true, halign="middle", textcolor="#ab6c15");
//  (-118, 82) @TEXT("CKD", size=1, bold=true, halign="end", textcolor="#ab6c15");
//  (0, -42) @TEXT("Dots mark connections. Crossings without dots are separate nets.", size=0.9, bold=false, halign="middle", textcolor="#526171");
//  (0, -34) @TEXT("DP/DN: series precharge. QP/QN: parallel precharge.", size=0.9, bold=false, halign="middle", textcolor="#526171");
//  %input_pair = #MINP(in_p) #MINN(in_n) #MTAIL(tail) @AS $DIFFERENTIAL_PAIR;
//  %core_axis = (0, 0);
//  {#MINP #MINN} @AS $MATCHED;
//  #MINP(a) #MINN(b) %core_axis(axis) @AS $MIRRORED;
//  {#MRDP #MRDN} @AS $MATCHED;
//  #MRDP(a) #MRDN(b) %core_axis(axis) @AS $MIRRORED;
//  {#MPDP #MPDN} @AS $MATCHED;
//  #MPDP(a) #MPDN(b) %core_axis(axis) @AS $MIRRORED;
//  {#MRQP #MRQN} @AS $MATCHED;
//  #MRQP(a) #MRQN(b) %core_axis(axis) @AS $MIRRORED;
//  {#MPQP #MPQN} @AS $MATCHED;
//  #MPQP(a) #MPQN(b) %core_axis(axis) @AS $MIRRORED;
//  {#MLNP #MLNN} @AS $MATCHED;
//  #MLNP(a) #MLNN(b) %core_axis(axis) @AS $MIRRORED;
//  {#MLPP #MLPN} @AS $MATCHED;
//  #MLPP(a) #MLPN(b) %core_axis(axis) @AS $MIRRORED;
//  {#MOPN #MONN} @AS $MATCHED;
//  #MOPN(a) #MONN(b) %core_axis(axis) @AS $MIRRORED;
//  {#MOPP #MONP} @AS $MATCHED;
//  #MOPP(a) #MONP(b) %core_axis(axis) @AS $MIRRORED;
//  {#MINP #MINN #MTAIL #MLNP #MLNN #MLPP #MLPN} @GROUP;
//  {#MPDP #MRDP} @GROUP;
//  {#MPDN #MRDN} @GROUP;
//  {#MRQP #MPQP} @GROUP;
//  {#MRQN #MPQN} @GROUP;
//  {#MCKN #MCKP #MCK2N #MCK2P #CCB #CCD} @GROUP;
//  {#CDP #CDN} @AS $MATCHED;
//  #CDP(a) #CDN(b) %core_axis(axis) @AS $MIRRORED;
//  {#CCB #CCD} @AS $MATCHED;
// }
ends adc_comp
