// Canonical many-question-strongarm promoted from RESET-V19; electrical source is unchanged.
// @RNL(type="header") {
//   @VERSION("0.3");
//   @USE-PACKAGE(name="adc28", version="0.1", path="../../../rnl/adc28.rnl")
// }
simulator lang=spectre
subckt adc_comp (INP INN CLKC OUTP OUTN AVDD VSS)
// Geometry and terminal parasitics are from successful device callbacks.
// INP > INN asserts OUTP. CLKC low resets both external outputs to zero.
MINP (DP INP TAIL VSS) nch_ulvt_mac l=3e-08 w=5.6e-05 nf=56 m=1 ad=2.8e-12 as=2.85e-12 pd=6.16e-05 ps=6.37e-05 nrd=0.009138 nrs=0.009138 sa=1.36619e-06 sb=1.36619e-06 sd=1e-07
MINN (DN INN TAIL VSS) nch_ulvt_mac l=3e-08 w=5.6e-05 nf=56 m=1 ad=2.8e-12 as=2.85e-12 pd=6.16e-05 ps=6.37e-05 nrd=0.009138 nrs=0.009138 sa=1.36619e-06 sb=1.36619e-06 sd=1e-07
MTAIL (TAIL CLKC VSS VSS) nch_ulvt_mac l=3e-08 w=3e-06 nf=3 m=1 ad=1.75e-13 as=1.75e-13 pd=4.35e-06 ps=4.35e-06 nrd=0.136842 nrs=0.136842 sa=1.47042e-07 sb=1.47042e-07 sd=1e-07
MRDP (DP CLKC AVDD AVDD) pch_ulvt_mac l=3e-08 w=2.2e-06 nf=2 m=1 ad=1.1e-13 as=1.65e-13 pd=2.4e-06 ps=4.7e-06 nrd=0.082492 nrs=0.082492 sa=1.12742e-07 sb=1.12742e-07 sd=1e-07
MRDN (DN CLKC AVDD AVDD) pch_ulvt_mac l=3e-08 w=2.2e-06 nf=2 m=1 ad=1.1e-13 as=1.65e-13 pd=2.4e-06 ps=4.7e-06 nrd=0.082492 nrs=0.082492 sa=1.12742e-07 sb=1.12742e-07 sd=1e-07
MLNP (QP QN DP VSS) nch_ulvt_mac l=3e-08 w=1.2e-05 nf=12 m=1 ad=6e-13 as=6.5e-13 pd=1.32e-05 ps=1.53e-05 nrd=0.040569 nrs=0.040569 sa=4.01767e-07 sb=4.01767e-07 sd=1e-07
MLNN (QN QP DN VSS) nch_ulvt_mac l=3e-08 w=1.2e-05 nf=12 m=1 ad=6e-13 as=6.5e-13 pd=1.32e-05 ps=1.53e-05 nrd=0.040569 nrs=0.040569 sa=4.01767e-07 sb=4.01767e-07 sd=1e-07
MLPP (QP QN AVDD AVDD) pch_ulvt_mac l=3e-08 w=8e-06 nf=8 m=1 ad=4e-13 as=4.5e-13 pd=8.8e-06 ps=1.09e-05 nrd=0.024976 nrs=0.024976 sa=2.95835e-07 sb=2.95835e-07 sd=1e-07
MLPN (QN QP AVDD AVDD) pch_ulvt_mac l=3e-08 w=8e-06 nf=8 m=1 ad=4e-13 as=4.5e-13 pd=8.8e-06 ps=1.09e-05 nrd=0.024976 nrs=0.024976 sa=2.95835e-07 sb=2.95835e-07 sd=1e-07
MRQP (QP CLKC AVDD AVDD) pch_ulvt_mac l=3e-08 w=3e-06 nf=3 m=1 ad=1.75e-13 as=1.75e-13 pd=4.35e-06 ps=4.35e-06 nrd=0.063502 nrs=0.063502 sa=1.47042e-07 sb=1.47042e-07 sd=1e-07
MRQN (QN CLKC AVDD AVDD) pch_ulvt_mac l=3e-08 w=3e-06 nf=3 m=1 ad=1.75e-13 as=1.75e-13 pd=4.35e-06 ps=4.35e-06 nrd=0.063502 nrs=0.063502 sa=1.47042e-07 sb=1.47042e-07 sd=1e-07
MOPN (OUTP QP VSS VSS) nch_ulvt_mac l=3e-08 w=4e-06 nf=4 m=1 ad=2e-13 as=2.5e-13 pd=4.4e-06 ps=6.5e-06 nrd=0.108289 nrs=0.108289 sa=1.79203e-07 sb=1.79203e-07 sd=1e-07
MOPP (OUTP QP AVDD AVDD) pch_ulvt_mac l=3e-08 w=4e-06 nf=4 m=1 ad=2e-13 as=2.5e-13 pd=4.4e-06 ps=6.5e-06 nrd=0.048530 nrs=0.048530 sa=1.79203e-07 sb=1.79203e-07 sd=1e-07
MONN (OUTN QN VSS VSS) nch_ulvt_mac l=3e-08 w=4e-06 nf=4 m=1 ad=2e-13 as=2.5e-13 pd=4.4e-06 ps=6.5e-06 nrd=0.108289 nrs=0.108289 sa=1.79203e-07 sb=1.79203e-07 sd=1e-07
MONP (OUTN QN AVDD AVDD) pch_ulvt_mac l=3e-08 w=4e-06 nf=4 m=1 ad=2e-13 as=2.5e-13 pd=4.4e-06 ps=6.5e-06 nrd=0.048530 nrs=0.048530 sa=1.79203e-07 sb=1.79203e-07 sd=1e-07
CDP (DP VSS) cfmom_2t nr=48 lr=1e-06 w=5e-08 s=5e-08 stm=1 spm=3 multi=1
CDN (DN VSS) cfmom_2t nr=48 lr=1e-06 w=5e-08 s=5e-08 stm=1 spm=3 multi=1
MDQP (QP CKB VSS VSS) nch_ulvt_mac l=3e-08 w=5e-07 nf=1 m=1 ad=3.75e-14 as=3.75e-14 pd=1.15e-06 ps=1.15e-06 nrd=0.662935 nrs=0.662935 sa=7.5e-08 sb=7.5e-08 sd=1e-07
MDQN (QN CKB VSS VSS) nch_ulvt_mac l=3e-08 w=5e-07 nf=1 m=1 ad=3.75e-14 as=3.75e-14 pd=1.15e-06 ps=1.15e-06 nrd=0.662935 nrs=0.662935 sa=7.5e-08 sb=7.5e-08 sd=1e-07
MDDP (DP DP VSS VSS) nch_ulvt_mac l=5e-07 w=5e-07 nf=1 m=1 ad=4.75e-14 as=4.75e-14 pd=1.19e-06 ps=1.19e-06 nrd=0.645705 nrs=0.645705 sa=9.5e-08 sb=9.5e-08 sd=1.2e-07
MDDN (DN DN VSS VSS) nch_ulvt_mac l=5e-07 w=5e-07 nf=1 m=1 ad=4.75e-14 as=4.75e-14 pd=1.19e-06 ps=1.19e-06 nrd=0.645705 nrs=0.645705 sa=9.5e-08 sb=9.5e-08 sd=1.2e-07
MCKN (CKB CLKC VSS VSS) nch_ulvt_mac l=3e-08 w=4e-06 nf=4 m=1 ad=2e-13 as=2.5e-13 pd=4.4e-06 ps=6.5e-06 nrd=0.108289 nrs=0.108289 sa=1.79203e-07 sb=1.79203e-07 sd=1e-07
MCKP (CKB CLKC AVDD AVDD) pch_ulvt_mac l=3e-08 w=2.7e-06 nf=3 m=1 ad=1.575e-13 as=1.575e-13 pd=3.95e-06 ps=3.95e-06 nrd=0.071617 nrs=0.071617 sa=1.47042e-07 sb=1.47042e-07 sd=1e-07
CCB (CKB VSS) cfmom_2t nr=16 lr=1e-06 w=5e-08 s=5e-08 stm=1 spm=3 multi=1
MBLEED (CKB AVDD VSS VSS) nch_ulvt_mac l=5e-07 w=5e-07 nf=1 m=1 ad=4.75e-14 as=4.75e-14 pd=1.19e-06 ps=1.19e-06 nrd=0.645705 nrs=0.645705 sa=9.5e-08 sb=9.5e-08 sd=1.2e-07
MUP (CKB VSS AVDD AVDD) pch_ulvt_mac l=1e-07 w=5e-07 nf=1 m=1 ad=4.75e-14 as=4.75e-14 pd=1.19e-06 ps=1.19e-06 nrd=0.256086 nrs=0.256086 sa=9.5e-08 sb=9.5e-08 sd=1.2e-07
CQP (QP VSS) cfmom_2t nr=16 lr=1e-06 w=5e-08 s=5e-08 stm=1 spm=3 multi=1
CQN (QN VSS) cfmom_2t nr=16 lr=1e-06 w=5e-08 s=5e-08 stm=1 spm=3 multi=1
// @RNL(author="schematic-review") {
//  &VSS @ADD-TO $GROUND_NET_SET;
//  &AVDD @ADD-TO $SUPPLY_NET_SET;
//  # @SELECT-INSTANCE => @TEXT("", key="model");
//  # @SELECT-INSTANCE => @TEXT("", key="name");
//  $clock_wire = @DEFINE-STYLE(linecolor="#ab6c15", fillcolor="#ab6c15", textcolor="#ab6c15") {};
//  $p_wire = @DEFINE-STYLE(linecolor="#3f5597", fillcolor="#3f5597", textcolor="#3f5597") {};
//  $n_wire = @DEFINE-STYLE(linecolor="#16817a", fillcolor="#16817a", textcolor="#16817a") {};
//  $dynamic_wire = @DEFINE-STYLE(linecolor="#286e97", fillcolor="#286e97", textcolor="#286e97") {};
//  $power_wire = @DEFINE-STYLE(linecolor="#697887", fillcolor="#697887", textcolor="#697887") {};
//  $signal_wire = @DEFINE-STYLE(linecolor="#263442", fillcolor="#263442", textcolor="#263442") {};
//  @LINE(linecolor="#d3dbe4", linewidth=0.08, linestyle="dashed") {(-112, -36) (112, -36) (112, 110) (-112, 110) (-112, -36)};
//  @LINE(linecolor="#d3dbe4", linewidth=0.08, linestyle="dashed") {(-158, 30) (-118, 30) (-118, 76) (-158, 76) (-158, 30)};
//  @LINE(linecolor="#d3dbe4", linewidth=0.08, linestyle="dashed") {(118, 30) (158, 30) (158, 76) (118, 76) (118, 30)};
//  (0, 123) @TEXT("StrongARM RESET-V19", size=2, bold=true, halign="middle", textcolor="#273747");
//  (0, 117) @TEXT("Smaller clock PMOS reduces external clock-gate load", size=1.1, bold=false, halign="middle", textcolor="#526171");
//  (0, 112) @TEXT("28 nm HPC+ | ULVT MOS | device labels: W/L and nf", size=0.9, bold=false, halign="middle", textcolor="#526171");
//  (0, 106) @TEXT("Regenerative core", size=1.35, bold=true, halign="middle", textcolor="#273747");
//  (-90, 103) @TEXT("Single DP", size=1.1, bold=true, halign="middle", textcolor="#273747");
//  (-50, 103) @TEXT("Direct QP", size=1.1, bold=true, halign="middle", textcolor="#273747");
//  (90, 103) @TEXT("Single DN", size=1.1, bold=true, halign="middle", textcolor="#273747");
//  (50, 103) @TEXT("Direct QN", size=1.1, bold=true, halign="middle", textcolor="#273747");
//  (-138, 73) @TEXT("RTZ OUTP", size=1.35, bold=true, halign="middle", textcolor="#273747");
//  (138, 73) @TEXT("RTZ OUTN", size=1.35, bold=true, halign="middle", textcolor="#273747");
//  #MLPP @PLACE(-18, 62) => @ORIENT("MY");
//  #MLPP @TEXT("MLPP", key="name", size=1.15, bold=true, halign="end", textcolor="#273747") => @PLACE(-20.8, 63.2);
//  #MLPP @TEXT("8\mu{}m/30nm  nf8", key="dims", size=1, halign="end", textcolor="#526171") => @PLACE(-20.8, 60.5);
//  #MLPN @PLACE(18, 62) => @ORIENT("R0");
//  #MLPN @TEXT("MLPN", key="name", size=1.15, bold=true, halign="start", textcolor="#273747") => @PLACE(20.8, 63.2);
//  #MLPN @TEXT("8\mu{}m/30nm  nf8", key="dims", size=1, halign="start", textcolor="#526171") => @PLACE(20.8, 60.5);
//  #MLNP @PLACE(-18, 38) => @ORIENT("MY");
//  #MLNP @TEXT("MLNP", key="name", size=1.15, bold=true, halign="end", textcolor="#273747") => @PLACE(-20.8, 42.5);
//  #MLNP @TEXT("12\mu{}m/30nm  nf12", key="dims", size=1, halign="end", textcolor="#526171") => @PLACE(-20.8, 40.2);
//  #MLNN @PLACE(18, 38) => @ORIENT("R0");
//  #MLNN @TEXT("MLNN", key="name", size=1.15, bold=true, halign="start", textcolor="#273747") => @PLACE(20.8, 42.5);
//  #MLNN @TEXT("12\mu{}m/30nm  nf12", key="dims", size=1, halign="start", textcolor="#526171") => @PLACE(20.8, 40.2);
//  #MRQP @PLACE(-38, 76) => @ORIENT("MY");
//  #MRQP @TEXT("MRQP", key="name", size=1.15, bold=true, halign="end", textcolor="#273747") => @PLACE(-40.8, 77.2);
//  #MRQP @TEXT("3\mu{}m/30nm  nf3", key="dims", size=1, halign="end", textcolor="#526171") => @PLACE(-40.8, 74.5);
//  #MRQN @PLACE(38, 76) => @ORIENT("R0");
//  #MRQN @TEXT("MRQN", key="name", size=1.15, bold=true, halign="start", textcolor="#273747") => @PLACE(40.8, 77.2);
//  #MRQN @TEXT("3\mu{}m/30nm  nf3", key="dims", size=1, halign="start", textcolor="#526171") => @PLACE(40.8, 74.5);
//  #MRDP @PLACE(-90, 56) => @ORIENT("R0");
//  #MRDP @TEXT("MRDP", key="name", size=1.15, bold=true, halign="start", textcolor="#273747") => @PLACE(-87.2, 57.2);
//  #MRDP @TEXT("2.2\mu{}m/30nm  nf2", key="dims", size=1, halign="start", textcolor="#526171") => @PLACE(-87.2, 54.5);
//  #MRDN @PLACE(90, 56) => @ORIENT("MY");
//  #MRDN @TEXT("MRDN", key="name", size=1.15, bold=true, halign="end", textcolor="#273747") => @PLACE(87.2, 57.2);
//  #MRDN @TEXT("2.2\mu{}m/30nm  nf2", key="dims", size=1, halign="end", textcolor="#526171") => @PLACE(87.2, 54.5);
//  #MINP @PLACE(-18, 8) => @ORIENT("R0");
//  #MINP @TEXT("MINP", key="name", size=1.15, bold=true, halign="start", textcolor="#273747") => @PLACE(-15.2, 12.5);
//  #MINP @TEXT("56\mu{}m/30nm  nf56", key="dims", size=1, halign="start", textcolor="#526171") => @PLACE(-15.2, 10.2);
//  #MINN @PLACE(18, 8) => @ORIENT("MY");
//  #MINN @TEXT("MINN", key="name", size=1.15, bold=true, halign="end", textcolor="#273747") => @PLACE(15.2, 12.5);
//  #MINN @TEXT("56\mu{}m/30nm  nf56", key="dims", size=1, halign="end", textcolor="#526171") => @PLACE(15.2, 10.2);
//  #MTAIL @PLACE(0, -12) => @ORIENT("R0");
//  #MTAIL @TEXT("MTAIL", key="name", size=1.15, bold=true, halign="start", textcolor="#273747") => @PLACE(2.8, -10.8);
//  #MTAIL @TEXT("3\mu{}m/30nm  nf3", key="dims", size=1, halign="start", textcolor="#526171") => @PLACE(2.8, -13.5);
//  %core_vdd_0 = (-98, 96);
//  %core_vdd_1 = (-90, 96);
//  $JUNCTION @ATTACH %core_vdd_1 => @SET-STYLE $power_wire;
//  %core_vdd_2 = (-62, 96);
//  $JUNCTION @ATTACH %core_vdd_2 => @SET-STYLE $power_wire;
//  %core_vdd_3 = (-38, 96);
//  $JUNCTION @ATTACH %core_vdd_3 => @SET-STYLE $power_wire;
//  %core_vdd_4 = (-18, 96);
//  $JUNCTION @ATTACH %core_vdd_4 => @SET-STYLE $power_wire;
//  %core_vdd_5 = (0.0, 96);
//  $JUNCTION @ATTACH %core_vdd_5 => @SET-STYLE $power_wire;
//  %core_vdd_6 = (18, 96);
//  $JUNCTION @ATTACH %core_vdd_6 => @SET-STYLE $power_wire;
//  %core_vdd_7 = (38, 96);
//  $JUNCTION @ATTACH %core_vdd_7 => @SET-STYLE $power_wire;
//  %core_vdd_8 = (62, 96);
//  $JUNCTION @ATTACH %core_vdd_8 => @SET-STYLE $power_wire;
//  %core_vdd_9 = (90, 96);
//  $JUNCTION @ATTACH %core_vdd_9 => @SET-STYLE $power_wire;
//  %core_vdd_10 = (98, 96);
//  &AVDD @WIRE(mode="straight", linecolor="#697887", linewidth=0.11) {%core_vdd_0 %core_vdd_1 %core_vdd_2 %core_vdd_3 %core_vdd_4 %core_vdd_5 %core_vdd_6 %core_vdd_7 %core_vdd_8 %core_vdd_9 %core_vdd_10};
//  %s_MRQP = (-38, 79);
//  $JUNCTION @ATTACH %s_MRQP => @SET-STYLE $power_wire;
//  &AVDD @WIRE(mode="straight", linecolor="#697887", linewidth=0.11) {#MRQP:s %s_MRQP};
//  &AVDD @WIRE(mode="straight", linecolor="#697887", linewidth=0.11) {#MRQP:b (-40, 76) (-40, 79) %s_MRQP};
//  &AVDD @WIRE(mode="straight", linecolor="#697887", linewidth=0.11) {%s_MRQP %core_vdd_3};
//  %s_MLPP = (-18, 65);
//  $JUNCTION @ATTACH %s_MLPP => @SET-STYLE $power_wire;
//  &AVDD @WIRE(mode="straight", linecolor="#697887", linewidth=0.11) {#MLPP:s %s_MLPP};
//  &AVDD @WIRE(mode="straight", linecolor="#697887", linewidth=0.11) {#MLPP:b (-20, 62) (-20, 65) %s_MLPP};
//  &AVDD @WIRE(mode="straight", linecolor="#697887", linewidth=0.11) {%s_MLPP %core_vdd_4};
//  %s_MLPN = (18, 65);
//  $JUNCTION @ATTACH %s_MLPN => @SET-STYLE $power_wire;
//  &AVDD @WIRE(mode="straight", linecolor="#697887", linewidth=0.11) {#MLPN:s %s_MLPN};
//  &AVDD @WIRE(mode="straight", linecolor="#697887", linewidth=0.11) {#MLPN:b (20, 62) (20, 65) %s_MLPN};
//  &AVDD @WIRE(mode="straight", linecolor="#697887", linewidth=0.11) {%s_MLPN %core_vdd_6};
//  %s_MRQN = (38, 79);
//  $JUNCTION @ATTACH %s_MRQN => @SET-STYLE $power_wire;
//  &AVDD @WIRE(mode="straight", linecolor="#697887", linewidth=0.11) {#MRQN:s %s_MRQN};
//  &AVDD @WIRE(mode="straight", linecolor="#697887", linewidth=0.11) {#MRQN:b (40, 76) (40, 79) %s_MRQN};
//  &AVDD @WIRE(mode="straight", linecolor="#697887", linewidth=0.11) {%s_MRQN %core_vdd_7};
//  %core_vdd_tag = $SUPPLY @ATTACH &AVDD => @PLACE(0.0, 98.5);
//  %core_vdd_tag => @SET-STYLE $power_wire;
//  &AVDD @WIRE(mode="straight", linecolor="#697887", linewidth=0.11) {%core_vdd_5 %core_vdd_tag:p};
//  %b_MRDP = $SUPPLY @ATTACH &AVDD => @PLACE(-79, 60);
//  %b_MRDP => @SET-STYLE $power_wire;
//  &AVDD @WIRE(mode="straight", linecolor="#697887", linewidth=0.11) {#MRDP:b (-79, 56) %b_MRDP:p};
//  %b_MRDN = $SUPPLY @ATTACH &AVDD => @PLACE(79, 60);
//  %b_MRDN => @SET-STYLE $power_wire;
//  &AVDD @WIRE(mode="straight", linecolor="#697887", linewidth=0.11) {#MRDN:b (79, 56) %b_MRDN:p};
//  %b_MLNP = $GROUND @ATTACH &VSS => @PLACE(-29, 35);
//  %b_MLNP => @SET-STYLE $power_wire;
//  %b_MLNP @TEXT("", key="name");
//  &VSS @WIRE(mode="straight", linecolor="#697887", linewidth=0.11) {#MLNP:b (-29, 38) %b_MLNP:p};
//  %b_MLNN = $GROUND @ATTACH &VSS => @PLACE(29, 35);
//  %b_MLNN => @SET-STYLE $power_wire;
//  %b_MLNN @TEXT("", key="name");
//  &VSS @WIRE(mode="straight", linecolor="#697887", linewidth=0.11) {#MLNN:b (29, 38) %b_MLNN:p};
//  %b_MINP = $GROUND @ATTACH &VSS => @PLACE(-7, 5);
//  %b_MINP => @SET-STYLE $power_wire;
//  %b_MINP @TEXT("", key="name");
//  &VSS @WIRE(mode="straight", linecolor="#697887", linewidth=0.11) {#MINP:b (-7, 8) %b_MINP:p};
//  %b_MINN = $GROUND @ATTACH &VSS => @PLACE(7, 5);
//  %b_MINN => @SET-STYLE $power_wire;
//  %b_MINN @TEXT("", key="name");
//  &VSS @WIRE(mode="straight", linecolor="#697887", linewidth=0.11) {#MINN:b (7, 8) %b_MINN:p};
//  %s_MTAIL = (0, -15);
//  $JUNCTION @ATTACH %s_MTAIL => @SET-STYLE $power_wire;
//  &VSS @WIRE(mode="straight", linecolor="#697887", linewidth=0.11) {#MTAIL:s %s_MTAIL};
//  &VSS @WIRE(mode="straight", linecolor="#697887", linewidth=0.11) {#MTAIL:b (2, -12) (2, -15) %s_MTAIL};
//  %g_MTAIL = $GROUND @ATTACH &VSS => @PLACE(0, -22);
//  %g_MTAIL => @SET-STYLE $power_wire;
//  &VSS @WIRE(mode="straight", linecolor="#697887", linewidth=0.11) {%s_MTAIL %g_MTAIL:p};
//  %dp = (-18, 22);
//  $JUNCTION @ATTACH %dp => @SET-STYLE $dynamic_wire;
//  %dn = (18, 22);
//  $JUNCTION @ATTACH %dn => @SET-STYLE $dynamic_wire;
//  %dp_cap = (-66, 22);
//  $JUNCTION @ATTACH %dp_cap => @SET-STYLE $dynamic_wire;
//  %dn_cap = (66, 22);
//  $JUNCTION @ATTACH %dn_cap => @SET-STYLE $dynamic_wire;
//  &DP @WIRE(mode="straight", linecolor="#286e97", linewidth=0.16) {#MRDP:d (-90, 22) %dp_cap %dp};
//  &DN @WIRE(mode="straight", linecolor="#286e97", linewidth=0.16) {#MRDN:d (90, 22) %dn_cap %dn};
//  &DP @WIRE(mode="straight", linecolor="#286e97", linewidth=0.16) {#MLNP:s %dp #MINP:d};
//  &DN @WIRE(mode="straight", linecolor="#286e97", linewidth=0.16) {#MLNN:s %dn #MINN:d};
//  #CDP @PLACE(-66, 8) => @ORIENT("R0");
//  #CDP @TEXT("CDP", key="name", size=1.15, bold=true, halign="end", textcolor="#273747") => @PLACE(-69, 9.5);
//  #CDP @TEXT("14.06 fF nominal", key="value", size=0.95, halign="end", textcolor="#526171") => @PLACE(-69, 6.7);
//  #CDP @TEXT("nr=48, lr=1\mu{}m", key="geometry", size=0.9, halign="end", textcolor="#526171") => @PLACE(-69, 3.9000000000000004);
//  &DP @WIRE(mode="straight", linecolor="#286e97", linewidth=0.16) {%dp_cap #CDP:p};
//  %g_CDP = $GROUND @ATTACH &VSS => @PLACE(-66, 0);
//  %g_CDP => @SET-STYLE $power_wire;
//  &VSS @WIRE(mode="straight", linecolor="#697887", linewidth=0.11) {#CDP:n %g_CDP:p};
//  #CDN @PLACE(66, 8) => @ORIENT("MY");
//  #CDN @TEXT("CDN", key="name", size=1.15, bold=true, halign="start", textcolor="#273747") => @PLACE(69, 9.5);
//  #CDN @TEXT("14.06 fF nominal", key="value", size=0.95, halign="start", textcolor="#526171") => @PLACE(69, 6.7);
//  #CDN @TEXT("nr=48, lr=1\mu{}m", key="geometry", size=0.9, halign="start", textcolor="#526171") => @PLACE(69, 3.9000000000000004);
//  &DN @WIRE(mode="straight", linecolor="#286e97", linewidth=0.16) {%dn_cap #CDN:p};
//  %g_CDN = $GROUND @ATTACH &VSS => @PLACE(66, 0);
//  %g_CDN => @SET-STYLE $power_wire;
//  &VSS @WIRE(mode="straight", linecolor="#697887", linewidth=0.11) {#CDN:n %g_CDN:p};
//  (-22, 24) @TEXT("DP", size=1, bold=true, halign="middle", textcolor="#286e97");
//  (22, 24) @TEXT("DN", size=1, bold=true, halign="middle", textcolor="#286e97");
//  %qp = (-18, 50);
//  $JUNCTION @ATTACH %qp => @SET-STYLE $p_wire;
//  %qn = (18, 45);
//  $JUNCTION @ATTACH %qn => @SET-STYLE $n_wire;
//  %qp_direct = (-38, 50);
//  $JUNCTION @ATTACH %qp_direct => @SET-STYLE $p_wire;
//  %qn_direct = (38, 45);
//  $JUNCTION @ATTACH %qn_direct => @SET-STYLE $n_wire;
//  %qp_delayed = (-62, 50);
//  $JUNCTION @ATTACH %qp_delayed => @SET-STYLE $p_wire;
//  %qn_delayed = (62, 45);
//  $JUNCTION @ATTACH %qn_delayed => @SET-STYLE $n_wire;
//  &QP @WIRE(mode="straight", linecolor="#3f5597", linewidth=0.16) {#MLPP:d %qp #MLNP:d};
//  &QN @WIRE(mode="straight", linecolor="#16817a", linewidth=0.16) {#MLPN:d %qn #MLNN:d};
//  &QP @WIRE(mode="straight", linecolor="#3f5597", linewidth=0.16) {%qp %qp_direct %qp_delayed};
//  &QN @WIRE(mode="straight", linecolor="#16817a", linewidth=0.16) {%qn %qn_direct %qn_delayed};
//  &QP @WIRE(mode="straight", linecolor="#3f5597", linewidth=0.16) {#MRQP:d %qp_direct};
//  &QN @WIRE(mode="straight", linecolor="#16817a", linewidth=0.16) {#MRQN:d %qn_direct};
//  %feedback_qp = (8, 50);
//  $JUNCTION @ATTACH %feedback_qp => @SET-STYLE $p_wire;
//  %feedback_qn = (-8, 45);
//  $JUNCTION @ATTACH %feedback_qn => @SET-STYLE $n_wire;
//  &QP @WIRE(mode="straight", linecolor="#3f5597", linewidth=0.16) {%qp %feedback_qp};
//  &QP @WIRE(mode="straight", linecolor="#3f5597", linewidth=0.16) {#MLPN:g (8, 62) %feedback_qp (8, 38) #MLNN:g};
//  &QN @WIRE(mode="straight", linecolor="#16817a", linewidth=0.16) {%qn %feedback_qn};
//  &QN @WIRE(mode="straight", linecolor="#16817a", linewidth=0.16) {#MLPP:g (-8, 62) %feedback_qn (-8, 38) #MLNP:g};
//  (-26, 52) @TEXT("QP", size=1, bold=true, halign="middle", textcolor="#3f5597");
//  (26, 47) @TEXT("QN", size=1, bold=true, halign="middle", textcolor="#16817a");
//  %tail = (0, 0);
//  $JUNCTION @ATTACH %tail => @SET-STYLE $signal_wire;
//  &TAIL @WIRE(mode="straight", linecolor="#263442", linewidth=0.16) {#MINP:s (-18, 0) %tail (18, 0) #MINN:s};
//  &TAIL @WIRE(mode="straight", linecolor="#263442", linewidth=0.16) {%tail #MTAIL:d};
//  %port_INP = $IO_PORT @ATTACH &INP => @PLACE(-32, 8) => @ORIENT("R0");
//  %port_INP @TEXT("INP", key="name", size=1, bold=true);
//  %port_INN = $IO_PORT @ATTACH &INN => @PLACE(32, 8) => @ORIENT("MY");
//  %port_INN @TEXT("INN", key="name", size=1, bold=true);
//  &INP @WIRE(mode="straight", linecolor="#263442", linewidth=0.16) {%port_INP:p #MINP:g};
//  &INN @WIRE(mode="straight", linecolor="#263442", linewidth=0.16) {%port_INN:p #MINN:g};
//  (4, -3) @TEXT("TAIL", size=0.9, bold=false, halign="start", textcolor="#526171");
//  #MOPP @PLACE(-136, 57) => @ORIENT("MY");
//  #MOPP @TEXT("MOPP", key="name", size=1.15, bold=true, halign="end", textcolor="#273747") => @PLACE(-138.8, 58.2);
//  #MOPP @TEXT("4\mu{}m/30nm  nf4", key="dims", size=1, halign="end", textcolor="#526171") => @PLACE(-138.8, 55.5);
//  #MOPN @PLACE(-136, 43) => @ORIENT("MY");
//  #MOPN @TEXT("MOPN", key="name", size=1.15, bold=true, halign="end", textcolor="#273747") => @PLACE(-138.8, 44.2);
//  #MOPN @TEXT("4\mu{}m/30nm  nf4", key="dims", size=1, halign="end", textcolor="#526171") => @PLACE(-138.8, 41.5);
//  %outp_buffer_in = (-130, 50);
//  $JUNCTION @ATTACH %outp_buffer_in => @SET-STYLE $p_wire;
//  %outp_buffer_out = (-136, 50);
//  $JUNCTION @ATTACH %outp_buffer_out => @SET-STYLE $p_wire;
//  &QP @WIRE(mode="straight", linecolor="#3f5597", linewidth=0.16) {#MOPP:g (-130, 57) %outp_buffer_in (-130, 43) #MOPN:g};
//  &OUTP @WIRE(mode="straight", linecolor="#3f5597", linewidth=0.16) {#MOPP:d %outp_buffer_out #MOPN:d};
//  &QP @WIRE(mode="straight", linecolor="#3f5597", linewidth=0.16) {%qp_delayed %outp_buffer_in};
//  %port_OUTP = $IO_PORT @ATTACH &OUTP => @PLACE(-168, 50) => @ORIENT("R0");
//  %port_OUTP @TEXT("OUTP", key="name", size=1, bold=true);
//  &OUTP @WIRE(mode="straight", linecolor="#3f5597", linewidth=0.16) {%outp_buffer_out %port_OUTP:p};
//  %outp_vdd_0 = (-144, 66);
//  %outp_vdd_1 = (-136, 66);
//  $JUNCTION @ATTACH %outp_vdd_1 => @SET-STYLE $power_wire;
//  %outp_vdd_2 = (-128, 66);
//  &AVDD @WIRE(mode="straight", linecolor="#697887", linewidth=0.11) {%outp_vdd_0 %outp_vdd_1 %outp_vdd_2};
//  %s_MOPP = (-136, 60);
//  $JUNCTION @ATTACH %s_MOPP => @SET-STYLE $power_wire;
//  &AVDD @WIRE(mode="straight", linecolor="#697887", linewidth=0.11) {#MOPP:s %s_MOPP};
//  &AVDD @WIRE(mode="straight", linecolor="#697887", linewidth=0.11) {#MOPP:b (-138, 57) (-138, 60) %s_MOPP};
//  &AVDD @WIRE(mode="straight", linecolor="#697887", linewidth=0.11) {%s_MOPP %outp_vdd_1};
//  %outp_vdd_tag = $SUPPLY @ATTACH &AVDD => @PLACE(-136.0, 68.5);
//  %outp_vdd_tag => @SET-STYLE $power_wire;
//  &AVDD @WIRE(mode="straight", linecolor="#697887", linewidth=0.11) {%outp_vdd_1 %outp_vdd_tag:p};
//  %outp_vss_0 = (-144, 34);
//  %outp_vss_1 = (-136, 34);
//  $JUNCTION @ATTACH %outp_vss_1 => @SET-STYLE $power_wire;
//  %outp_vss_2 = (-128, 34);
//  &VSS @WIRE(mode="straight", linecolor="#697887", linewidth=0.11) {%outp_vss_0 %outp_vss_1 %outp_vss_2};
//  %s_MOPN = (-136, 40);
//  $JUNCTION @ATTACH %s_MOPN => @SET-STYLE $power_wire;
//  &VSS @WIRE(mode="straight", linecolor="#697887", linewidth=0.11) {#MOPN:s %s_MOPN};
//  &VSS @WIRE(mode="straight", linecolor="#697887", linewidth=0.11) {#MOPN:b (-138, 43) (-138, 40) %s_MOPN};
//  &VSS @WIRE(mode="straight", linecolor="#697887", linewidth=0.11) {%s_MOPN %outp_vss_1};
//  %outp_vss_tag = $GROUND @ATTACH &VSS => @PLACE(-136.0, 32.5);
//  %outp_vss_tag => @SET-STYLE $power_wire;
//  &VSS @WIRE(mode="straight", linecolor="#697887", linewidth=0.11) {%outp_vss_1 %outp_vss_tag:p};
//  {#MOPP #MOPN} @GROUP;
//  #MONP @PLACE(136, 57) => @ORIENT("R0");
//  #MONP @TEXT("MONP", key="name", size=1.15, bold=true, halign="start", textcolor="#273747") => @PLACE(138.8, 58.2);
//  #MONP @TEXT("4\mu{}m/30nm  nf4", key="dims", size=1, halign="start", textcolor="#526171") => @PLACE(138.8, 55.5);
//  #MONN @PLACE(136, 43) => @ORIENT("R0");
//  #MONN @TEXT("MONN", key="name", size=1.15, bold=true, halign="start", textcolor="#273747") => @PLACE(138.8, 44.2);
//  #MONN @TEXT("4\mu{}m/30nm  nf4", key="dims", size=1, halign="start", textcolor="#526171") => @PLACE(138.8, 41.5);
//  %outn_buffer_in = (130, 50);
//  $JUNCTION @ATTACH %outn_buffer_in => @SET-STYLE $n_wire;
//  %outn_buffer_out = (136, 50);
//  $JUNCTION @ATTACH %outn_buffer_out => @SET-STYLE $n_wire;
//  &QN @WIRE(mode="straight", linecolor="#16817a", linewidth=0.16) {#MONP:g (130, 57) %outn_buffer_in (130, 43) #MONN:g};
//  &OUTN @WIRE(mode="straight", linecolor="#16817a", linewidth=0.16) {#MONP:d %outn_buffer_out #MONN:d};
//  &QN @WIRE(mode="straight", linecolor="#16817a", linewidth=0.16) {%qn_delayed (116, 45) (116, 50) %outn_buffer_in};
//  %port_OUTN = $IO_PORT @ATTACH &OUTN => @PLACE(168, 50) => @ORIENT("MY");
//  %port_OUTN @TEXT("OUTN", key="name", size=1, bold=true);
//  &OUTN @WIRE(mode="straight", linecolor="#16817a", linewidth=0.16) {%outn_buffer_out %port_OUTN:p};
//  %outn_vdd_0 = (128, 66);
//  %outn_vdd_1 = (136, 66);
//  $JUNCTION @ATTACH %outn_vdd_1 => @SET-STYLE $power_wire;
//  %outn_vdd_2 = (144, 66);
//  &AVDD @WIRE(mode="straight", linecolor="#697887", linewidth=0.11) {%outn_vdd_0 %outn_vdd_1 %outn_vdd_2};
//  %s_MONP = (136, 60);
//  $JUNCTION @ATTACH %s_MONP => @SET-STYLE $power_wire;
//  &AVDD @WIRE(mode="straight", linecolor="#697887", linewidth=0.11) {#MONP:s %s_MONP};
//  &AVDD @WIRE(mode="straight", linecolor="#697887", linewidth=0.11) {#MONP:b (138, 57) (138, 60) %s_MONP};
//  &AVDD @WIRE(mode="straight", linecolor="#697887", linewidth=0.11) {%s_MONP %outn_vdd_1};
//  %outn_vdd_tag = $SUPPLY @ATTACH &AVDD => @PLACE(136.0, 68.5);
//  %outn_vdd_tag => @SET-STYLE $power_wire;
//  &AVDD @WIRE(mode="straight", linecolor="#697887", linewidth=0.11) {%outn_vdd_1 %outn_vdd_tag:p};
//  %outn_vss_0 = (128, 34);
//  %outn_vss_1 = (136, 34);
//  $JUNCTION @ATTACH %outn_vss_1 => @SET-STYLE $power_wire;
//  %outn_vss_2 = (144, 34);
//  &VSS @WIRE(mode="straight", linecolor="#697887", linewidth=0.11) {%outn_vss_0 %outn_vss_1 %outn_vss_2};
//  %s_MONN = (136, 40);
//  $JUNCTION @ATTACH %s_MONN => @SET-STYLE $power_wire;
//  &VSS @WIRE(mode="straight", linecolor="#697887", linewidth=0.11) {#MONN:s %s_MONN};
//  &VSS @WIRE(mode="straight", linecolor="#697887", linewidth=0.11) {#MONN:b (138, 43) (138, 40) %s_MONN};
//  &VSS @WIRE(mode="straight", linecolor="#697887", linewidth=0.11) {%s_MONN %outn_vss_1};
//  %outn_vss_tag = $GROUND @ATTACH &VSS => @PLACE(136.0, 32.5);
//  %outn_vss_tag => @SET-STYLE $power_wire;
//  &VSS @WIRE(mode="straight", linecolor="#697887", linewidth=0.11) {%outn_vss_1 %outn_vss_tag:p};
//  {#MONP #MONN} @GROUP;
//  &AVDD @WIRE(mode="straight", linecolor="#697887", linewidth=0.11) {#MRDP:s %core_vdd_1};
//  &AVDD @WIRE(mode="straight", linecolor="#697887", linewidth=0.11) {#MRDN:s %core_vdd_9};
//  #MRDP:g @TEXT("CLKC", key="netname", size=1, bold=true, halign="end", valign="middle", dx=-.8, textcolor="#ab6c15");
//  #MRDN:g @TEXT("CLKC", key="netname", size=1, bold=true, halign="start", valign="middle", dx=.8, textcolor="#ab6c15");
//  #MRQP:g @TEXT("CLKC", key="netname", size=1, bold=true, halign="start", valign="middle", dx=.8, textcolor="#ab6c15");
//  #MRQN:g @TEXT("CLKC", key="netname", size=1, bold=true, halign="end", valign="middle", dx=-.8, textcolor="#ab6c15");
//  #MTAIL:g @TEXT("CLKC", key="netname", size=1, bold=true, halign="end", valign="middle", dx=-.8, textcolor="#ab6c15");
//  %port_CLKC = $IO_PORT @ATTACH &CLKC => @PLACE(-32, -12) => @ORIENT("R0");
//  %port_CLKC @TEXT("CLKC", key="name", size=1, bold=true);
//  &CLKC @WIRE(mode="straight", linecolor="#ab6c15", linewidth=0.16) {%port_CLKC:p #MTAIL:g};
//  %inputs = #MINP(in_p) and #MINN(in_n) treated @AS $DIFFERENTIAL_PAIR;
//  (-100, -29) @TEXT("23 MOS + 5 MOM. Precharge and tail use CLKC; Q loads use CKB.", size=1, halign="start");
//  (-100, -34) @TEXT("Dots mark connections; crossing wires without dots are separate.", size=1, halign="start");
//  (0, -72) @TEXT("Reset-gated Q loads and diode-connected input-drain loads", size=1.3, bold=true, halign="middle");
//  #MDQP @PLACE(-96, -90) => @ORIENT("R0");
//  #MDQP @TEXT("MDQP", key="name", size=1.05, halign="start") => @PLACE(-93, -88.5);
//  #MDQP @TEXT("0.5um/30nm nf1", key="dims", size=.95, halign="start") => @PLACE(-93, -91.5);
//  %g_MDQP = $GROUND @ATTACH &VSS => @PLACE(-96, -100);
//  &VSS @WIRE(mode="straight", linewidth=.16) {#MDQP:s %g_MDQP:p};
//  &VSS @WIRE(mode="straight", linewidth=.16) {#MDQP:b (-94, -90) (-94, -100) %g_MDQP:p};
//  %d_MDQP = (-96, -80);
//  $JUNCTION @ATTACH %d_MDQP;
//  &QP @WIRE(mode="straight", linewidth=.16) {#MDQP:d %d_MDQP};
//  (-96, -78) @TEXT("QP", size=1, bold=true, halign="middle");
//  #MDQN @PLACE(-32, -90) => @ORIENT("R0");
//  #MDQN @TEXT("MDQN", key="name", size=1.05, halign="start") => @PLACE(-29, -88.5);
//  #MDQN @TEXT("0.5um/30nm nf1", key="dims", size=.95, halign="start") => @PLACE(-29, -91.5);
//  %g_MDQN = $GROUND @ATTACH &VSS => @PLACE(-32, -100);
//  &VSS @WIRE(mode="straight", linewidth=.16) {#MDQN:s %g_MDQN:p};
//  &VSS @WIRE(mode="straight", linewidth=.16) {#MDQN:b (-30, -90) (-30, -100) %g_MDQN:p};
//  %d_MDQN = (-32, -80);
//  $JUNCTION @ATTACH %d_MDQN;
//  &QN @WIRE(mode="straight", linewidth=.16) {#MDQN:d %d_MDQN};
//  (-32, -78) @TEXT("QN", size=1, bold=true, halign="middle");
//  #MDDP @PLACE(32, -90) => @ORIENT("R0");
//  #MDDP @TEXT("MDDP", key="name", size=1.05, halign="start") => @PLACE(35, -88.5);
//  #MDDP @TEXT("0.5um/500nm nf1", key="dims", size=.95, halign="start") => @PLACE(35, -91.5);
//  %g_MDDP = $GROUND @ATTACH &VSS => @PLACE(32, -100);
//  &VSS @WIRE(mode="straight", linewidth=.16) {#MDDP:s %g_MDDP:p};
//  &VSS @WIRE(mode="straight", linewidth=.16) {#MDDP:b (34, -90) (34, -100) %g_MDDP:p};
//  %d_MDDP = (32, -80);
//  $JUNCTION @ATTACH %d_MDDP;
//  &DP @WIRE(mode="straight", linewidth=.16) {#MDDP:d %d_MDDP (24, -80) (24, -90) #MDDP:g};
//  (32, -78) @TEXT("DP", size=1, bold=true, halign="middle");
//  #MDDN @PLACE(96, -90) => @ORIENT("R0");
//  #MDDN @TEXT("MDDN", key="name", size=1.05, halign="start") => @PLACE(99, -88.5);
//  #MDDN @TEXT("0.5um/500nm nf1", key="dims", size=.95, halign="start") => @PLACE(99, -91.5);
//  %g_MDDN = $GROUND @ATTACH &VSS => @PLACE(96, -100);
//  &VSS @WIRE(mode="straight", linewidth=.16) {#MDDN:s %g_MDDN:p};
//  &VSS @WIRE(mode="straight", linewidth=.16) {#MDDN:b (98, -90) (98, -100) %g_MDDN:p};
//  %d_MDDN = (96, -80);
//  $JUNCTION @ATTACH %d_MDDN;
//  &DN @WIRE(mode="straight", linewidth=.16) {#MDDN:d %d_MDDN (88, -80) (88, -90) #MDDN:g};
//  (96, -78) @TEXT("DN", size=1, bold=true, halign="middle");
//  {#MDQP #MDQN} @AS $MATCHED;
//  {#MDDP #MDDN} @AS $MATCHED;
//  (0, -110) @TEXT("23 MOS + 5 MOM. Q shunts conduct in reset; physical clock generation and DC current are measured.", size=1, halign="middle");
//  #MDQP:g @TEXT("CKB", key="netname", size=1, bold=true, halign="end", dx=-.8, textcolor="#ab6c15");
//  #MDQN:g @TEXT("CKB", key="netname", size=1, bold=true, halign="end", dx=-.8, textcolor="#ab6c15");
//  #MCKP @PLACE(-178, 8) => @ORIENT("R0");
//  #MCKP @TEXT("MCKP", key="name", size=1.05, halign="start") => @PLACE(-175, 9.5);
//  #MCKP @TEXT("2.7um/30nm nf3", key="dims", size=.95, halign="start") => @PLACE(-175, 6.5);
//  %s_MCKP = $SUPPLY @ATTACH &AVDD => @PLACE(-178, 16);
//  &AVDD @WIRE(mode="straight", linecolor="#697887", linewidth=0.16) {#MCKP:s %s_MCKP:p};
//  &AVDD @WIRE(mode="straight", linecolor="#697887", linewidth=0.16) {#MCKP:b (-176, 8) (-176, 16) %s_MCKP:p};
//  #MCKN @PLACE(-178, -16) => @ORIENT("R0");
//  #MCKN @TEXT("MCKN", key="name", size=1.05, halign="start") => @PLACE(-175, -14.5);
//  #MCKN @TEXT("4um/30nm nf4", key="dims", size=.95, halign="start") => @PLACE(-175, -17.5);
//  %s_MCKN = $GROUND @ATTACH &VSS => @PLACE(-178, -24);
//  &VSS @WIRE(mode="straight", linecolor="#697887", linewidth=0.16) {#MCKN:s %s_MCKN:p};
//  &VSS @WIRE(mode="straight", linecolor="#697887", linewidth=0.16) {#MCKN:b (-176, -16) (-176, -24) %s_MCKN:p};
//  &CLKC @WIRE(mode="straight", linecolor="#ab6c15", linewidth=0.16) {#MCKP:g (-184, 8) (-184, -16) #MCKN:g};
//  (-186, -4) @TEXT("CLKC", size=1, bold=true, halign="end", textcolor="#ab6c15");
//  &CKB @WIRE(mode="straight", linecolor="#ab6c15", linewidth=0.16) {#MCKP:d (-178, -4) #MCKN:d};
//  &CKB @WIRE(mode="straight", linecolor="#ab6c15", linewidth=0.16) {(-178, -4) (-150, -4)};
//  (-157, -2) @TEXT("CKB", size=1, bold=true, textcolor="#ab6c15");
//  #CCB @PLACE(-150, -16) => @ORIENT("R0");
//  #CCB @TEXT("CCB 4.46fF", key="name", size=1, halign="start") => @PLACE(-147, -14);
//  &CKB @WIRE(mode="straight", linecolor="#ab6c15", linewidth=0.16) {(-150, -4) #CCB:p};
//  %g_CCB = $GROUND @ATTACH &VSS => @PLACE(-150, -24);
//  &VSS @WIRE(mode="straight", linecolor="#697887", linewidth=0.16) {#CCB:n %g_CCB:p};
//  (-174, 23) @TEXT("Physical Q-load enable", size=1.1, bold=true, halign="middle");
//  #MBLEED @PLACE(-126, -16) => @ORIENT("R0");
//  #MBLEED @TEXT("MBLEED", key="name", size=1, halign="start") => @PLACE(-123, -14.5);
//  #MBLEED @TEXT("0.5um/500nm nf1", key="dims", size=.9, halign="start") => @PLACE(-123, -17.5);
//  &CKB @WIRE(mode="straight", linecolor="#ab6c15", linewidth=.16) {(-150, -4) (-126, -4) #MBLEED:d};
//  %bl_vdd = $SUPPLY @ATTACH &AVDD => @PLACE(-138, -9);
//  &AVDD @WIRE(mode="straight", linecolor="#697887", linewidth=.11) {%bl_vdd:p (-138, -16) #MBLEED:g};
//  %bl_gnd = $GROUND @ATTACH &VSS => @PLACE(-126, -26);
//  &VSS @WIRE(mode="straight", linecolor="#697887", linewidth=.11) {#MBLEED:s %bl_gnd:p};
//  &VSS @WIRE(mode="straight", linecolor="#697887", linewidth=.11) {#MBLEED:b (-124, -16) (-124, -26) %bl_gnd:p};
//  #MUP @PLACE(-126, 8) => @ORIENT("R0");
//  #MUP @TEXT("MUP", key="name", size=1, halign="start") => @PLACE(-123, 9.5);
//  #MUP @TEXT("0.5um/100nm nf1", key="dims", size=.9, halign="start") => @PLACE(-123, 6.5);
//  %up_vdd = $SUPPLY @ATTACH &AVDD => @PLACE(-126, 16);
//  &AVDD @WIRE(mode="straight", linewidth=.16) {#MUP:s %up_vdd:p};
//  &AVDD @WIRE(mode="straight", linewidth=.16) {#MUP:b (-124, 8) (-124, 16) %up_vdd:p};
//  &CKB @WIRE(mode="straight", linecolor="#ab6c15", linewidth=.16) {#MUP:d (-126, -4)};
//  %up_gate = $GROUND @ATTACH &VSS => @PLACE(-138, 3);
//  &VSS @WIRE(mode="straight", linewidth=.16) {#MUP:g (-138, 8) %up_gate:p};
//  #CQP @PLACE(-64, -90) => @ORIENT("R0");
//  #CQP @TEXT("CQP", key="name", size=1, halign="start") => @PLACE(-61, -88.5);
//  #CQP @TEXT("4.46fF", key="value", size=.95, halign="start") => @PLACE(-61, -91.5);
//  &QP @WIRE(mode="straight", linewidth=.16) {%d_MDQP (-64, -80) #CQP:p};
//  %g_CQP = $GROUND @ATTACH &VSS => @PLACE(-64, -100);
//  &VSS @WIRE(mode="straight", linewidth=.16) {#CQP:n %g_CQP:p};
//  #CQN @PLACE(0, -90) => @ORIENT("R0");
//  #CQN @TEXT("CQN", key="name", size=1, halign="start") => @PLACE(3, -88.5);
//  #CQN @TEXT("4.46fF", key="value", size=.95, halign="start") => @PLACE(3, -91.5);
//  &QN @WIRE(mode="straight", linewidth=.16) {%d_MDQN (0, -80) #CQN:p};
//  %g_CQN = $GROUND @ATTACH &VSS => @PLACE(0, -100);
//  &VSS @WIRE(mode="straight", linewidth=.16) {#CQN:n %g_CQN:p};
//  {#CQP #CQN} @AS $MATCHED;
// }
ends adc_comp
