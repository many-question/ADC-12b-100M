// Miyahara comparator core with return-to-zero output interface.
// @RNL(type="header") {
//   @VERSION("0.3");
//   @USE-PACKAGE(name="adc28", version="0.1", path="../../../rnl/adc28.rnl")
// }
simulator lang=spectre
subckt adc_comp (INP INN CLKC OUTP OUTN AVDD VSS)
// Geometry and terminal parasitics are from successful device callbacks.
// INP > INN asserts OUTP. CLKC low resets both external outputs to zero.
MINP (DP INP TAIL VSS) nch_ulvt_mac l=3e-08 w=5.6e-05 nf=56 m=1 ad=2.8e-12 as=2.85e-12 pd=6.16e-05 ps=6.37e-05 nrd=0.009138 nrs=0.009138 sa=1.36619e-06 sb=1.36619e-06 sd=1e-07
MINN (DN INN TAIL VSS) nch_ulvt_mac l=3e-08 w=5.6e-05 nf=56 m=1 ad=2.8e-12 as=2.85e-12 pd=6.16e-05 ps=6.37e-05 nrd=0.009138 nrs=0.009138 sa=1.36619e-06 sb=1.36619e-06 sd=1e-07
MTAIL (TAIL CLKC VSS VSS) nch_ulvt_mac l=3e-08 w=3e-06 nf=3 m=1 ad=1.75e-13 as=1.75e-13 pd=4.35e-06 ps=4.35e-06 nrd=0.136842 nrs=0.136842 sa=1.47042e-07 sb=1.47042e-07 sd=1e-07
MRDP (DP CKR AVDD AVDD) pch_ulvt_mac l=3e-08 w=4e-06 nf=4 m=1 ad=2e-13 as=2.5e-13 pd=4.4e-06 ps=6.5e-06 nrd=0.048530 nrs=0.048530 sa=1.79203e-07 sb=1.79203e-07 sd=1e-07
MRDN (DN CKR AVDD AVDD) pch_ulvt_mac l=3e-08 w=4e-06 nf=4 m=1 ad=2e-13 as=2.5e-13 pd=4.4e-06 ps=6.5e-06 nrd=0.048530 nrs=0.048530 sa=1.79203e-07 sb=1.79203e-07 sd=1e-07
M14 (XP DP AVDD AVDD) pch_ulvt_mac l=3e-08 w=4e-06 nf=4 m=1 ad=2e-13 as=2.5e-13 pd=4.4e-06 ps=6.5e-06 nrd=0.048530 nrs=0.048530 sa=1.79203e-07 sb=1.79203e-07 sd=1e-07
M15 (XN DN AVDD AVDD) pch_ulvt_mac l=3e-08 w=4e-06 nf=4 m=1 ad=2e-13 as=2.5e-13 pd=4.4e-06 ps=6.5e-06 nrd=0.048530 nrs=0.048530 sa=1.79203e-07 sb=1.79203e-07 sd=1e-07
M12 (XP DP VSS VSS) nch_ulvt_mac l=3e-08 w=1e-06 nf=2 m=1 ad=5e-14 as=7.5e-14 pd=1.2e-06 ps=2.3e-06 nrd=0.425847 nrs=0.425847 sa=1.12742e-07 sb=1.12742e-07 sd=1e-07
M13 (XN DN VSS VSS) nch_ulvt_mac l=3e-08 w=1e-06 nf=2 m=1 ad=5e-14 as=7.5e-14 pd=1.2e-06 ps=2.3e-06 nrd=0.425847 nrs=0.425847 sa=1.12742e-07 sb=1.12742e-07 sd=1e-07
M10 (OUTP OUTN XP AVDD) pch_ulvt_mac l=3e-08 w=4e-06 nf=4 m=1 ad=2e-13 as=2.5e-13 pd=4.4e-06 ps=6.5e-06 nrd=0.048530 nrs=0.048530 sa=1.79203e-07 sb=1.79203e-07 sd=1e-07
M11 (OUTN OUTP XN AVDD) pch_ulvt_mac l=3e-08 w=4e-06 nf=4 m=1 ad=2e-13 as=2.5e-13 pd=4.4e-06 ps=6.5e-06 nrd=0.048530 nrs=0.048530 sa=1.79203e-07 sb=1.79203e-07 sd=1e-07
M6 (OUTP OUTN VSS VSS) nch_ulvt_mac l=3e-08 w=2e-06 nf=2 m=1 ad=1e-13 as=1.5e-13 pd=2.2e-06 ps=4.3e-06 nrd=0.185844 nrs=0.185844 sa=1.12742e-07 sb=1.12742e-07 sd=1e-07
M7 (OUTN OUTP VSS VSS) nch_ulvt_mac l=3e-08 w=2e-06 nf=2 m=1 ad=1e-13 as=1.5e-13 pd=2.2e-06 ps=4.3e-06 nrd=0.185844 nrs=0.185844 sa=1.12742e-07 sb=1.12742e-07 sd=1e-07
M8 (OUTP DP VSS VSS) nch_ulvt_mac l=3e-08 w=2e-06 nf=2 m=1 ad=1e-13 as=1.5e-13 pd=2.2e-06 ps=4.3e-06 nrd=0.185844 nrs=0.185844 sa=1.12742e-07 sb=1.12742e-07 sd=1e-07
M9 (OUTN DN VSS VSS) nch_ulvt_mac l=3e-08 w=2e-06 nf=2 m=1 ad=1e-13 as=1.5e-13 pd=2.2e-06 ps=4.3e-06 nrd=0.185844 nrs=0.185844 sa=1.12742e-07 sb=1.12742e-07 sd=1e-07
CDP (DP VSS) cfmom_2t nr=48 lr=1e-06 w=5e-08 s=5e-08 stm=1 spm=3 multi=1
CDN (DN VSS) cfmom_2t nr=48 lr=1e-06 w=5e-08 s=5e-08 stm=1 spm=3 multi=1
MCKN (CKB CLKC VSS VSS) nch_ulvt_mac l=3e-08 w=3e-06 nf=3 m=1 ad=1.75e-13 as=1.75e-13 pd=4.35e-06 ps=4.35e-06 nrd=0.136842 nrs=0.136842 sa=1.47042e-07 sb=1.47042e-07 sd=1e-07
MCKP (CKB CLKC AVDD AVDD) pch_ulvt_mac l=3e-08 w=8e-06 nf=8 m=1 ad=4e-13 as=4.5e-13 pd=8.8e-06 ps=1.09e-05 nrd=0.024976 nrs=0.024976 sa=2.95835e-07 sb=2.95835e-07 sd=1e-07
MCK2N (CKR CKB VSS VSS) nch_ulvt_mac l=3e-08 w=4e-06 nf=4 m=1 ad=2e-13 as=2.5e-13 pd=4.4e-06 ps=6.5e-06 nrd=0.108289 nrs=0.108289 sa=1.79203e-07 sb=1.79203e-07 sd=1e-07
MCK2P (CKR CKB AVDD AVDD) pch_ulvt_mac l=3e-08 w=8e-06 nf=8 m=1 ad=4e-13 as=4.5e-13 pd=8.8e-06 ps=1.09e-05 nrd=0.024976 nrs=0.024976 sa=2.95835e-07 sb=2.95835e-07 sd=1e-07
MRQP (OUTP CKB VSS VSS) nch_ulvt_mac l=3e-08 w=2e-06 nf=2 m=1 ad=1e-13 as=1.5e-13 pd=2.2e-06 ps=4.3e-06 nrd=0.185844 nrs=0.185844 sa=1.12742e-07 sb=1.12742e-07 sd=1e-07
MRQN (OUTN CKB VSS VSS) nch_ulvt_mac l=3e-08 w=2e-06 nf=2 m=1 ad=1e-13 as=1.5e-13 pd=2.2e-06 ps=4.3e-06 nrd=0.185844 nrs=0.185844 sa=1.12742e-07 sb=1.12742e-07 sd=1e-07
MAP (DP CLKC AVDD AVDD) pch_ulvt_mac l=3e-08 w=2e-06 nf=2 m=1 ad=1e-13 as=1.5e-13 pd=2.2e-06 ps=4.3e-06 nrd=0.091833 nrs=0.091833 sa=1.12742e-07 sb=1.12742e-07 sd=1e-07
MAN (DN CLKC AVDD AVDD) pch_ulvt_mac l=3e-08 w=2e-06 nf=2 m=1 ad=1e-13 as=1.5e-13 pd=2.2e-06 ps=4.3e-06 nrd=0.091833 nrs=0.091833 sa=1.12742e-07 sb=1.12742e-07 sd=1e-07
CCB (CKB VSS) cfmom_2t nr=16 lr=1e-06 w=5e-08 s=5e-08 stm=1 spm=3 multi=1
CCR (CKR VSS) cfmom_2t nr=16 lr=1e-06 w=5e-08 s=5e-08 stm=1 spm=3 multi=1
// @RNL(author="schematic-review") {
//  &VSS @ADD-TO $GROUND_NET_SET;
//  &AVDD @ADD-TO $SUPPLY_NET_SET;
//  # @SELECT-INSTANCE => @TEXT("", key="model");
//  # @SELECT-INSTANCE => @TEXT("", key="name");
//  $clock_wire = @DEFINE-STYLE(linecolor="#ab6c15", fillcolor="#ab6c15", textcolor="#ab6c15") {};
//  $p_wire = @DEFINE-STYLE(linecolor="#3f5597", fillcolor="#3f5597", textcolor="#3f5597") {};
//  $n_wire = @DEFINE-STYLE(linecolor="#16817a", fillcolor="#16817a", textcolor="#16817a") {};
//  $dynamic_wire = @DEFINE-STYLE(linecolor="#286e97", fillcolor="#286e97", textcolor="#286e97") {};
//  $power_wire = @DEFINE-STYLE(linecolor="#697887", fillcolor="#697887", textcolor="#697887") {};
//  $signal_wire = @DEFINE-STYLE(linecolor="#263442", fillcolor="#263442", textcolor="#263442") {};
//  @LINE(linecolor="#d3dbe4", linewidth=0.08, linestyle="dashed") {(-62, -74) (62, -74) (62, 94) (-62, 94) (-62, -74)};
//  @LINE(linecolor="#d3dbe4", linewidth=0.08, linestyle="dashed") {(-112, 16) (-70, 16) (-70, 54) (-112, 54) (-112, 16)};
//  @LINE(linecolor="#d3dbe4", linewidth=0.08, linestyle="dashed") {(70, 16) (112, 16) (112, 54) (70, 54) (70, 16)};
//  @LINE(linecolor="#d3dbe4", linewidth=0.08, linestyle="dashed") {(-180, -72) (-76, -72) (-76, 0) (-180, 0) (-180, -72)};
//  (0, 104) @TEXT("Miyahara two-stage comparator", size=2, bold=true, halign="middle", textcolor="#273747");
//  (0, 97) @TEXT("28 nm HPC+ | ULVT MOS | device labels: W/L and nf", size=0.9, bold=false, halign="middle", textcolor="#526171");
//  (0, 91.5) @TEXT("Regenerative second stage", size=1.35, bold=true, halign="middle", textcolor="#273747");
//  (0, 7) @TEXT("Dynamic input stage", size=1.35, bold=true, halign="middle", textcolor="#273747");
//  @LINE(linecolor="#d3dbe4", linewidth=0.08, linestyle="dashed") {(-62, 10) (62, 10)};
//  (-91, 50.5) @TEXT("Output reset assist", size=1.25, bold=true, halign="middle", textcolor="#273747");
//  (91, 50.5) @TEXT("Output reset assist", size=1.25, bold=true, halign="middle", textcolor="#273747");
//  (-176, -5) @TEXT("Clock drive and damping", size=1.25, bold=true, halign="start", textcolor="#273747");
//  #M14 @PLACE(-18, 72) => @ORIENT("R0");
//  #M14 @TEXT("M14", key="name", size=1.15, bold=true, halign="start", textcolor="#273747") => @PLACE(-15.2, 73.2);
//  #M14 @TEXT("4\mu{}m/30nm  nf4", key="dims", size=1, halign="start", textcolor="#526171") => @PLACE(-15.2, 70.5);
//  #M15 @PLACE(18, 72) => @ORIENT("MY");
//  #M15 @TEXT("M15", key="name", size=1.15, bold=true, halign="end", textcolor="#273747") => @PLACE(15.2, 73.2);
//  #M15 @TEXT("4\mu{}m/30nm  nf4", key="dims", size=1, halign="end", textcolor="#526171") => @PLACE(15.2, 70.5);
//  #M10 @PLACE(-18, 52) => @ORIENT("MY");
//  #M10 @TEXT("M10", key="name", size=1.15, bold=true, halign="end", textcolor="#273747") => @PLACE(-20.8, 53.2);
//  #M10 @TEXT("4\mu{}m/30nm  nf4", key="dims", size=1, halign="end", textcolor="#526171") => @PLACE(-20.8, 50.5);
//  #M11 @PLACE(18, 52) => @ORIENT("R0");
//  #M11 @TEXT("M11", key="name", size=1.15, bold=true, halign="start", textcolor="#273747") => @PLACE(20.8, 53.2);
//  #M11 @TEXT("4\mu{}m/30nm  nf4", key="dims", size=1, halign="start", textcolor="#526171") => @PLACE(20.8, 50.5);
//  #M6 @PLACE(-18, 30) => @ORIENT("MY");
//  #M6 @TEXT("M6", key="name", size=1.15, bold=true, halign="end", textcolor="#273747") => @PLACE(-20.8, 31.2);
//  #M6 @TEXT("2\mu{}m/30nm  nf2", key="dims", size=1, halign="end", textcolor="#526171") => @PLACE(-20.8, 28.5);
//  #M7 @PLACE(18, 30) => @ORIENT("R0");
//  #M7 @TEXT("M7", key="name", size=1.15, bold=true, halign="start", textcolor="#273747") => @PLACE(20.8, 31.2);
//  #M7 @TEXT("2\mu{}m/30nm  nf2", key="dims", size=1, halign="start", textcolor="#526171") => @PLACE(20.8, 28.5);
//  #M12 @PLACE(-42, 60) => @ORIENT("R0");
//  #M12 @TEXT("M12", key="name", size=1.15, bold=true, halign="start", textcolor="#273747") => @PLACE(-39.2, 61.2);
//  #M12 @TEXT("1\mu{}m/30nm  nf2", key="dims", size=1, halign="start", textcolor="#526171") => @PLACE(-39.2, 58.5);
//  #M13 @PLACE(42, 60) => @ORIENT("MY");
//  #M13 @TEXT("M13", key="name", size=1.15, bold=true, halign="end", textcolor="#273747") => @PLACE(39.2, 61.2);
//  #M13 @TEXT("1\mu{}m/30nm  nf2", key="dims", size=1, halign="end", textcolor="#526171") => @PLACE(39.2, 58.5);
//  #M8 @PLACE(-42, 30) => @ORIENT("R0");
//  #M8 @TEXT("M8", key="name", size=1.15, bold=true, halign="start", textcolor="#273747") => @PLACE(-39.2, 31.2);
//  #M8 @TEXT("2\mu{}m/30nm  nf2", key="dims", size=1, halign="start", textcolor="#526171") => @PLACE(-39.2, 28.5);
//  #M9 @PLACE(42, 30) => @ORIENT("MY");
//  #M9 @TEXT("M9", key="name", size=1.15, bold=true, halign="end", textcolor="#273747") => @PLACE(39.2, 31.2);
//  #M9 @TEXT("2\mu{}m/30nm  nf2", key="dims", size=1, halign="end", textcolor="#526171") => @PLACE(39.2, 28.5);
//  #MRDP @PLACE(-18, -8) => @ORIENT("MY");
//  #MRDP @TEXT("MRDP", key="name", size=1.15, bold=true, halign="end", textcolor="#273747") => @PLACE(-20.8, -6.8);
//  #MRDP @TEXT("4\mu{}m/30nm  nf4", key="dims", size=1, halign="end", textcolor="#526171") => @PLACE(-20.8, -9.5);
//  #MRDN @PLACE(18, -8) => @ORIENT("R0");
//  #MRDN @TEXT("MRDN", key="name", size=1.15, bold=true, halign="start", textcolor="#273747") => @PLACE(20.8, -6.8);
//  #MRDN @TEXT("4\mu{}m/30nm  nf4", key="dims", size=1, halign="start", textcolor="#526171") => @PLACE(20.8, -9.5);
//  #MAP @PLACE(-42, -8) => @ORIENT("MY");
//  #MAP @TEXT("MAP", key="name", size=1.15, bold=true, halign="end", textcolor="#273747") => @PLACE(-44.8, -6.8);
//  #MAP @TEXT("2\mu{}m/30nm  nf2", key="dims", size=1, halign="end", textcolor="#526171") => @PLACE(-44.8, -9.5);
//  #MAN @PLACE(42, -8) => @ORIENT("R0");
//  #MAN @TEXT("MAN", key="name", size=1.15, bold=true, halign="start", textcolor="#273747") => @PLACE(44.8, -6.8);
//  #MAN @TEXT("2\mu{}m/30nm  nf2", key="dims", size=1, halign="start", textcolor="#526171") => @PLACE(44.8, -9.5);
//  #MINP @PLACE(-18, -30) => @ORIENT("R0");
//  #MINP @TEXT("MINP", key="name", size=1.15, bold=true, halign="start", textcolor="#273747") => @PLACE(-15.2, -25.5);
//  #MINP @TEXT("56\mu{}m/30nm  nf56", key="dims", size=1, halign="start", textcolor="#526171") => @PLACE(-15.2, -27.8);
//  #MINN @PLACE(18, -30) => @ORIENT("MY");
//  #MINN @TEXT("MINN", key="name", size=1.15, bold=true, halign="end", textcolor="#273747") => @PLACE(15.2, -25.5);
//  #MINN @TEXT("56\mu{}m/30nm  nf56", key="dims", size=1, halign="end", textcolor="#526171") => @PLACE(15.2, -27.8);
//  #MTAIL @PLACE(0, -50) => @ORIENT("R0");
//  #MTAIL @TEXT("MTAIL", key="name", size=1.15, bold=true, halign="start", textcolor="#273747") => @PLACE(2.8, -48.8);
//  #MTAIL @TEXT("3\mu{}m/30nm  nf3", key="dims", size=1, halign="start", textcolor="#526171") => @PLACE(2.8, -51.5);
//  #MRQP @PLACE(-86, 30) => @ORIENT("MY");
//  #MRQP @TEXT("MRQP", key="name", size=1.15, bold=true, halign="end", textcolor="#273747") => @PLACE(-88.8, 31.2);
//  #MRQP @TEXT("2\mu{}m/30nm  nf2", key="dims", size=1, halign="end", textcolor="#526171") => @PLACE(-88.8, 28.5);
//  #MRQN @PLACE(86, 30) => @ORIENT("R0");
//  #MRQN @TEXT("MRQN", key="name", size=1.15, bold=true, halign="start", textcolor="#273747") => @PLACE(88.8, 31.2);
//  #MRQN @TEXT("2\mu{}m/30nm  nf2", key="dims", size=1, halign="start", textcolor="#526171") => @PLACE(88.8, 28.5);
//  %latch_vdd_0 = (-48, 84);
//  %latch_vdd_1 = (-18, 84);
//  $JUNCTION @ATTACH %latch_vdd_1 => @SET-STYLE $power_wire;
//  %latch_vdd_2 = (0.0, 84);
//  $JUNCTION @ATTACH %latch_vdd_2 => @SET-STYLE $power_wire;
//  %latch_vdd_3 = (18, 84);
//  $JUNCTION @ATTACH %latch_vdd_3 => @SET-STYLE $power_wire;
//  %latch_vdd_4 = (48, 84);
//  &AVDD @WIRE(mode="straight", linecolor="#697887", linewidth=0.11) {%latch_vdd_0 %latch_vdd_1 %latch_vdd_2 %latch_vdd_3 %latch_vdd_4};
//  %s_M14 = (-18, 75);
//  $JUNCTION @ATTACH %s_M14 => @SET-STYLE $power_wire;
//  &AVDD @WIRE(mode="straight", linecolor="#697887", linewidth=0.11) {#M14:s %s_M14};
//  &AVDD @WIRE(mode="straight", linecolor="#697887", linewidth=0.11) {#M14:b (-16, 72) (-16, 75) %s_M14};
//  &AVDD @WIRE(mode="straight", linecolor="#697887", linewidth=0.11) {%s_M14 %latch_vdd_1};
//  %s_M15 = (18, 75);
//  $JUNCTION @ATTACH %s_M15 => @SET-STYLE $power_wire;
//  &AVDD @WIRE(mode="straight", linecolor="#697887", linewidth=0.11) {#M15:s %s_M15};
//  &AVDD @WIRE(mode="straight", linecolor="#697887", linewidth=0.11) {#M15:b (16, 72) (16, 75) %s_M15};
//  &AVDD @WIRE(mode="straight", linecolor="#697887", linewidth=0.11) {%s_M15 %latch_vdd_3};
//  %latch_vdd_tag = $SUPPLY @ATTACH &AVDD => @PLACE(0.0, 86.5);
//  %latch_vdd_tag => @SET-STYLE $power_wire;
//  &AVDD @WIRE(mode="straight", linecolor="#697887", linewidth=0.11) {%latch_vdd_2 %latch_vdd_tag:p};
//  %latch_vss_0 = (-48, 20);
//  %latch_vss_1 = (-42, 20);
//  $JUNCTION @ATTACH %latch_vss_1 => @SET-STYLE $power_wire;
//  %latch_vss_2 = (-18, 20);
//  $JUNCTION @ATTACH %latch_vss_2 => @SET-STYLE $power_wire;
//  %latch_vss_3 = (0.0, 20);
//  $JUNCTION @ATTACH %latch_vss_3 => @SET-STYLE $power_wire;
//  %latch_vss_4 = (18, 20);
//  $JUNCTION @ATTACH %latch_vss_4 => @SET-STYLE $power_wire;
//  %latch_vss_5 = (42, 20);
//  $JUNCTION @ATTACH %latch_vss_5 => @SET-STYLE $power_wire;
//  %latch_vss_6 = (48, 20);
//  &VSS @WIRE(mode="straight", linecolor="#697887", linewidth=0.11) {%latch_vss_0 %latch_vss_1 %latch_vss_2 %latch_vss_3 %latch_vss_4 %latch_vss_5 %latch_vss_6};
//  %s_M8 = (-42, 27);
//  $JUNCTION @ATTACH %s_M8 => @SET-STYLE $power_wire;
//  &VSS @WIRE(mode="straight", linecolor="#697887", linewidth=0.11) {#M8:s %s_M8};
//  &VSS @WIRE(mode="straight", linecolor="#697887", linewidth=0.11) {#M8:b (-40, 30) (-40, 27) %s_M8};
//  &VSS @WIRE(mode="straight", linecolor="#697887", linewidth=0.11) {%s_M8 %latch_vss_1};
//  %s_M6 = (-18, 27);
//  $JUNCTION @ATTACH %s_M6 => @SET-STYLE $power_wire;
//  &VSS @WIRE(mode="straight", linecolor="#697887", linewidth=0.11) {#M6:s %s_M6};
//  &VSS @WIRE(mode="straight", linecolor="#697887", linewidth=0.11) {#M6:b (-20, 30) (-20, 27) %s_M6};
//  &VSS @WIRE(mode="straight", linecolor="#697887", linewidth=0.11) {%s_M6 %latch_vss_2};
//  %s_M7 = (18, 27);
//  $JUNCTION @ATTACH %s_M7 => @SET-STYLE $power_wire;
//  &VSS @WIRE(mode="straight", linecolor="#697887", linewidth=0.11) {#M7:s %s_M7};
//  &VSS @WIRE(mode="straight", linecolor="#697887", linewidth=0.11) {#M7:b (20, 30) (20, 27) %s_M7};
//  &VSS @WIRE(mode="straight", linecolor="#697887", linewidth=0.11) {%s_M7 %latch_vss_4};
//  %s_M9 = (42, 27);
//  $JUNCTION @ATTACH %s_M9 => @SET-STYLE $power_wire;
//  &VSS @WIRE(mode="straight", linecolor="#697887", linewidth=0.11) {#M9:s %s_M9};
//  &VSS @WIRE(mode="straight", linecolor="#697887", linewidth=0.11) {#M9:b (40, 30) (40, 27) %s_M9};
//  &VSS @WIRE(mode="straight", linecolor="#697887", linewidth=0.11) {%s_M9 %latch_vss_5};
//  %latch_vss_tag = $GROUND @ATTACH &VSS => @PLACE(0.0, 18.5);
//  %latch_vss_tag => @SET-STYLE $power_wire;
//  &VSS @WIRE(mode="straight", linecolor="#697887", linewidth=0.11) {%latch_vss_3 %latch_vss_tag:p};
//  %b_M10 = $SUPPLY @ATTACH &AVDD => @PLACE(-29, 56);
//  %b_M10 => @SET-STYLE $power_wire;
//  &AVDD @WIRE(mode="straight", linecolor="#697887", linewidth=0.11) {#M10:b (-29, 52) %b_M10:p};
//  %b_M11 = $SUPPLY @ATTACH &AVDD => @PLACE(29, 56);
//  %b_M11 => @SET-STYLE $power_wire;
//  &AVDD @WIRE(mode="straight", linecolor="#697887", linewidth=0.11) {#M11:b (29, 52) %b_M11:p};
//  %s_M12 = (-42, 57);
//  $JUNCTION @ATTACH %s_M12 => @SET-STYLE $power_wire;
//  &VSS @WIRE(mode="straight", linecolor="#697887", linewidth=0.11) {#M12:s %s_M12};
//  &VSS @WIRE(mode="straight", linecolor="#697887", linewidth=0.11) {#M12:b (-40, 60) (-40, 57) %s_M12};
//  %g_M12 = $GROUND @ATTACH &VSS => @PLACE(-42, 54);
//  %g_M12 => @SET-STYLE $power_wire;
//  &VSS @WIRE(mode="straight", linecolor="#697887", linewidth=0.11) {%s_M12 %g_M12:p};
//  %s_M13 = (42, 57);
//  $JUNCTION @ATTACH %s_M13 => @SET-STYLE $power_wire;
//  &VSS @WIRE(mode="straight", linecolor="#697887", linewidth=0.11) {#M13:s %s_M13};
//  &VSS @WIRE(mode="straight", linecolor="#697887", linewidth=0.11) {#M13:b (40, 60) (40, 57) %s_M13};
//  %g_M13 = $GROUND @ATTACH &VSS => @PLACE(42, 54);
//  %g_M13 => @SET-STYLE $power_wire;
//  &VSS @WIRE(mode="straight", linecolor="#697887", linewidth=0.11) {%s_M13 %g_M13:p};
//  %input_vdd_0 = (-48, 0);
//  %input_vdd_1 = (-42, 0);
//  $JUNCTION @ATTACH %input_vdd_1 => @SET-STYLE $power_wire;
//  %input_vdd_2 = (-18, 0);
//  $JUNCTION @ATTACH %input_vdd_2 => @SET-STYLE $power_wire;
//  %input_vdd_3 = (0.0, 0);
//  $JUNCTION @ATTACH %input_vdd_3 => @SET-STYLE $power_wire;
//  %input_vdd_4 = (18, 0);
//  $JUNCTION @ATTACH %input_vdd_4 => @SET-STYLE $power_wire;
//  %input_vdd_5 = (42, 0);
//  $JUNCTION @ATTACH %input_vdd_5 => @SET-STYLE $power_wire;
//  %input_vdd_6 = (48, 0);
//  &AVDD @WIRE(mode="straight", linecolor="#697887", linewidth=0.11) {%input_vdd_0 %input_vdd_1 %input_vdd_2 %input_vdd_3 %input_vdd_4 %input_vdd_5 %input_vdd_6};
//  %s_MAP = (-42, -5);
//  $JUNCTION @ATTACH %s_MAP => @SET-STYLE $power_wire;
//  &AVDD @WIRE(mode="straight", linecolor="#697887", linewidth=0.11) {#MAP:s %s_MAP};
//  &AVDD @WIRE(mode="straight", linecolor="#697887", linewidth=0.11) {#MAP:b (-44, -8) (-44, -5) %s_MAP};
//  &AVDD @WIRE(mode="straight", linecolor="#697887", linewidth=0.11) {%s_MAP %input_vdd_1};
//  %s_MRDP = (-18, -5);
//  $JUNCTION @ATTACH %s_MRDP => @SET-STYLE $power_wire;
//  &AVDD @WIRE(mode="straight", linecolor="#697887", linewidth=0.11) {#MRDP:s %s_MRDP};
//  &AVDD @WIRE(mode="straight", linecolor="#697887", linewidth=0.11) {#MRDP:b (-20, -8) (-20, -5) %s_MRDP};
//  &AVDD @WIRE(mode="straight", linecolor="#697887", linewidth=0.11) {%s_MRDP %input_vdd_2};
//  %s_MRDN = (18, -5);
//  $JUNCTION @ATTACH %s_MRDN => @SET-STYLE $power_wire;
//  &AVDD @WIRE(mode="straight", linecolor="#697887", linewidth=0.11) {#MRDN:s %s_MRDN};
//  &AVDD @WIRE(mode="straight", linecolor="#697887", linewidth=0.11) {#MRDN:b (20, -8) (20, -5) %s_MRDN};
//  &AVDD @WIRE(mode="straight", linecolor="#697887", linewidth=0.11) {%s_MRDN %input_vdd_4};
//  %s_MAN = (42, -5);
//  $JUNCTION @ATTACH %s_MAN => @SET-STYLE $power_wire;
//  &AVDD @WIRE(mode="straight", linecolor="#697887", linewidth=0.11) {#MAN:s %s_MAN};
//  &AVDD @WIRE(mode="straight", linecolor="#697887", linewidth=0.11) {#MAN:b (44, -8) (44, -5) %s_MAN};
//  &AVDD @WIRE(mode="straight", linecolor="#697887", linewidth=0.11) {%s_MAN %input_vdd_5};
//  %input_vdd_tag = $SUPPLY @ATTACH &AVDD => @PLACE(0.0, 2.5);
//  %input_vdd_tag => @SET-STYLE $power_wire;
//  &AVDD @WIRE(mode="straight", linecolor="#697887", linewidth=0.11) {%input_vdd_3 %input_vdd_tag:p};
//  %b_MINP = $GROUND @ATTACH &VSS => @PLACE(-7, -33);
//  %b_MINP => @SET-STYLE $power_wire;
//  %b_MINP @TEXT("", key="name");
//  &VSS @WIRE(mode="straight", linecolor="#697887", linewidth=0.11) {#MINP:b (-7, -30) %b_MINP:p};
//  %b_MINN = $GROUND @ATTACH &VSS => @PLACE(7, -33);
//  %b_MINN => @SET-STYLE $power_wire;
//  %b_MINN @TEXT("", key="name");
//  &VSS @WIRE(mode="straight", linecolor="#697887", linewidth=0.11) {#MINN:b (7, -30) %b_MINN:p};
//  %s_MTAIL = (0, -53);
//  $JUNCTION @ATTACH %s_MTAIL => @SET-STYLE $power_wire;
//  &VSS @WIRE(mode="straight", linecolor="#697887", linewidth=0.11) {#MTAIL:s %s_MTAIL};
//  &VSS @WIRE(mode="straight", linecolor="#697887", linewidth=0.11) {#MTAIL:b (2, -50) (2, -53) %s_MTAIL};
//  %g_MTAIL = $GROUND @ATTACH &VSS => @PLACE(0, -58);
//  %g_MTAIL => @SET-STYLE $power_wire;
//  &VSS @WIRE(mode="straight", linecolor="#697887", linewidth=0.11) {%s_MTAIL %g_MTAIL:p};
//  %xp = (-18, 64);
//  $JUNCTION @ATTACH %xp => @SET-STYLE $dynamic_wire;
//  %xn = (18, 64);
//  $JUNCTION @ATTACH %xn => @SET-STYLE $dynamic_wire;
//  &XP @WIRE(mode="straight", linecolor="#286e97", linewidth=0.16) {#M14:d %xp #M10:s};
//  &XP @WIRE(mode="straight", linecolor="#286e97", linewidth=0.16) {#M12:d (-42, 64) %xp};
//  &XN @WIRE(mode="straight", linecolor="#286e97", linewidth=0.16) {#M15:d %xn #M11:s};
//  &XN @WIRE(mode="straight", linecolor="#286e97", linewidth=0.16) {#M13:d (42, 64) %xn};
//  %outp = (-18, 42);
//  $JUNCTION @ATTACH %outp => @SET-STYLE $p_wire;
//  %outn = (18, 37);
//  $JUNCTION @ATTACH %outn => @SET-STYLE $n_wire;
//  %outp_reset = (-42, 42);
//  $JUNCTION @ATTACH %outp_reset => @SET-STYLE $p_wire;
//  %outn_reset = (42, 37);
//  $JUNCTION @ATTACH %outn_reset => @SET-STYLE $n_wire;
//  &OUTP @WIRE(mode="straight", linecolor="#3f5597", linewidth=0.16) {#M10:d %outp #M6:d};
//  &OUTP @WIRE(mode="straight", linecolor="#3f5597", linewidth=0.16) {%outp %outp_reset #M8:d};
//  &OUTN @WIRE(mode="straight", linecolor="#16817a", linewidth=0.16) {#M11:d %outn #M7:d};
//  &OUTN @WIRE(mode="straight", linecolor="#16817a", linewidth=0.16) {%outn %outn_reset #M9:d};
//  %feedback_outp = (8, 42);
//  $JUNCTION @ATTACH %feedback_outp => @SET-STYLE $p_wire;
//  %feedback_outn = (-8, 37);
//  $JUNCTION @ATTACH %feedback_outn => @SET-STYLE $n_wire;
//  &OUTP @WIRE(mode="straight", linecolor="#3f5597", linewidth=0.16) {%outp %feedback_outp};
//  &OUTP @WIRE(mode="straight", linecolor="#3f5597", linewidth=0.16) {#M11:g (8, 52) %feedback_outp (8, 30) #M7:g};
//  &OUTN @WIRE(mode="straight", linecolor="#16817a", linewidth=0.16) {%outn %feedback_outn};
//  &OUTN @WIRE(mode="straight", linecolor="#16817a", linewidth=0.16) {#M10:g (-8, 52) %feedback_outn (-8, 30) #M6:g};
//  %dp = (-18, -18);
//  $JUNCTION @ATTACH %dp => @SET-STYLE $dynamic_wire;
//  %dn = (18, -18);
//  $JUNCTION @ATTACH %dn => @SET-STYLE $dynamic_wire;
//  &DP @WIRE(mode="straight", linecolor="#286e97", linewidth=0.16) {#MRDP:d %dp #MINP:d};
//  &DN @WIRE(mode="straight", linecolor="#286e97", linewidth=0.16) {#MRDN:d %dn #MINN:d};
//  %dp_cap_branch = (-42, -18);
//  $JUNCTION @ATTACH %dp_cap_branch => @SET-STYLE $dynamic_wire;
//  %dp_bottom = (-56, -18);
//  %dp_reset = (-56, 30);
//  $JUNCTION @ATTACH %dp_reset => @SET-STYLE $dynamic_wire;
//  %dp_internal_reset = (-56, 60);
//  $JUNCTION @ATTACH %dp_internal_reset => @SET-STYLE $dynamic_wire;
//  %dp_top = (-56, 72);
//  &DP @WIRE(mode="straight", linecolor="#286e97", linewidth=0.16) {%dp %dp_cap_branch %dp_bottom %dp_reset %dp_internal_reset %dp_top #M14:g};
//  &DP @WIRE(mode="straight", linecolor="#286e97", linewidth=0.16) {%dp_internal_reset #M12:g};
//  &DP @WIRE(mode="straight", linecolor="#286e97", linewidth=0.16) {%dp_reset #M8:g};
//  &DP @WIRE(mode="straight", linecolor="#286e97", linewidth=0.16) {#MAP:d %dp_cap_branch};
//  #CDP @PLACE(-42, -32) => @ORIENT("R0");
//  #CDP @TEXT("CDP", key="name", size=1.15, bold=true, halign="end", textcolor="#273747") => @PLACE(-45, -30.5);
//  #CDP @TEXT("14.06 fF nominal", key="value", size=0.95, halign="end", textcolor="#526171") => @PLACE(-45, -33.3);
//  #CDP @TEXT("nr=48, lr=1\mu{}m", key="geometry", size=0.9, halign="end", textcolor="#526171") => @PLACE(-45, -36.1);
//  &DP @WIRE(mode="straight", linecolor="#286e97", linewidth=0.16) {%dp_cap_branch #CDP:p};
//  %g_CDP = $GROUND @ATTACH &VSS => @PLACE(-42, -40);
//  %g_CDP => @SET-STYLE $power_wire;
//  &VSS @WIRE(mode="straight", linecolor="#697887", linewidth=0.11) {#CDP:n %g_CDP:p};
//  (-54, 79) @TEXT("DP", size=0.95, bold=true, halign="middle", textcolor="#286e97");
//  %dn_cap_branch = (42, -18);
//  $JUNCTION @ATTACH %dn_cap_branch => @SET-STYLE $dynamic_wire;
//  %dn_bottom = (56, -18);
//  %dn_reset = (56, 30);
//  $JUNCTION @ATTACH %dn_reset => @SET-STYLE $dynamic_wire;
//  %dn_internal_reset = (56, 60);
//  $JUNCTION @ATTACH %dn_internal_reset => @SET-STYLE $dynamic_wire;
//  %dn_top = (56, 72);
//  &DN @WIRE(mode="straight", linecolor="#286e97", linewidth=0.16) {%dn %dn_cap_branch %dn_bottom %dn_reset %dn_internal_reset %dn_top #M15:g};
//  &DN @WIRE(mode="straight", linecolor="#286e97", linewidth=0.16) {%dn_internal_reset #M13:g};
//  &DN @WIRE(mode="straight", linecolor="#286e97", linewidth=0.16) {%dn_reset #M9:g};
//  &DN @WIRE(mode="straight", linecolor="#286e97", linewidth=0.16) {#MAN:d %dn_cap_branch};
//  #CDN @PLACE(42, -32) => @ORIENT("MY");
//  #CDN @TEXT("CDN", key="name", size=1.15, bold=true, halign="start", textcolor="#273747") => @PLACE(45, -30.5);
//  #CDN @TEXT("14.06 fF nominal", key="value", size=0.95, halign="start", textcolor="#526171") => @PLACE(45, -33.3);
//  #CDN @TEXT("nr=48, lr=1\mu{}m", key="geometry", size=0.9, halign="start", textcolor="#526171") => @PLACE(45, -36.1);
//  &DN @WIRE(mode="straight", linecolor="#286e97", linewidth=0.16) {%dn_cap_branch #CDN:p};
//  %g_CDN = $GROUND @ATTACH &VSS => @PLACE(42, -40);
//  %g_CDN => @SET-STYLE $power_wire;
//  &VSS @WIRE(mode="straight", linecolor="#697887", linewidth=0.11) {#CDN:n %g_CDN:p};
//  (54, 79) @TEXT("DN", size=0.95, bold=true, halign="middle", textcolor="#286e97");
//  %tail = (0, -38);
//  $JUNCTION @ATTACH %tail => @SET-STYLE $signal_wire;
//  &TAIL @WIRE(mode="straight", linecolor="#263442", linewidth=0.16) {#MINP:s (-18, -38) %tail (18, -38) #MINN:s};
//  &TAIL @WIRE(mode="straight", linecolor="#263442", linewidth=0.16) {%tail #MTAIL:d};
//  %port_INP = $IO_PORT @ATTACH &INP => @PLACE(-31, -30) => @ORIENT("R0");
//  %port_INP @TEXT("INP", key="name", size=1, bold=true);
//  %port_INN = $IO_PORT @ATTACH &INN => @PLACE(31, -30) => @ORIENT("MY");
//  %port_INN @TEXT("INN", key="name", size=1, bold=true);
//  &INP @WIRE(mode="straight", linecolor="#263442", linewidth=0.16) {%port_INP:p #MINP:g};
//  &INN @WIRE(mode="straight", linecolor="#263442", linewidth=0.16) {%port_INN:p #MINN:g};
//  %ckr_core = (0, -8);
//  $JUNCTION @ATTACH %ckr_core => @SET-STYLE $clock_wire;
//  &CKR @WIRE(mode="straight", linecolor="#ab6c15", linewidth=0.16) {#MRDP:g %ckr_core #MRDN:g};
//  %clk_precharge_p = (-36, -78);
//  $JUNCTION @ATTACH %clk_precharge_p => @SET-STYLE $clock_wire;
//  %clk_tail = (-6, -78);
//  $JUNCTION @ATTACH %clk_tail => @SET-STYLE $clock_wire;
//  %clk_precharge_n = (36, -78);
//  &CLKC @WIRE(mode="straight", linecolor="#ab6c15", linewidth=0.16) {%clk_precharge_p %clk_tail %clk_precharge_n};
//  &CLKC @WIRE(mode="straight", linecolor="#ab6c15", linewidth=0.16) {%clk_precharge_p (-36, -8) #MAP:g};
//  &CLKC @WIRE(mode="straight", linecolor="#ab6c15", linewidth=0.16) {%clk_precharge_n (36, -8) #MAN:g};
//  &CLKC @WIRE(mode="straight", linecolor="#ab6c15", linewidth=0.16) {%clk_tail (-6, -50) #MTAIL:g};
//  (-50, -14) @TEXT("CLKC", size=0.85, bold=true, halign="middle", textcolor="#ab6c15");
//  (50, -14) @TEXT("CLKC", size=0.85, bold=true, halign="middle", textcolor="#ab6c15");
//  (-34, -74.5) @TEXT("CLKC", size=0.95, bold=true, halign="start", textcolor="#ab6c15");
//  (0, -12) @TEXT("CKR", size=0.85, bold=true, halign="middle", textcolor="#ab6c15");
//  #MCKP @PLACE(-162, -23) => @ORIENT("R0");
//  #MCKP @TEXT("MCKP", key="name", size=1.15, bold=true, halign="start", textcolor="#273747") => @PLACE(-159.2, -21.8);
//  #MCKP @TEXT("8\mu{}m/30nm  nf8", key="dims", size=1, halign="start", textcolor="#526171") => @PLACE(-159.2, -24.5);
//  #MCKN @PLACE(-162, -37) => @ORIENT("R0");
//  #MCKN @TEXT("MCKN", key="name", size=1.15, bold=true, halign="start", textcolor="#273747") => @PLACE(-159.2, -35.8);
//  #MCKN @TEXT("3\mu{}m/30nm  nf3", key="dims", size=1, halign="start", textcolor="#526171") => @PLACE(-159.2, -38.5);
//  %clock1_in = (-168, -30);
//  $JUNCTION @ATTACH %clock1_in => @SET-STYLE $clock_wire;
//  %clock1_out = (-162, -30);
//  $JUNCTION @ATTACH %clock1_out => @SET-STYLE $clock_wire;
//  &CLKC @WIRE(mode="straight", linecolor="#ab6c15", linewidth=0.16) {#MCKP:g (-168, -23) %clock1_in (-168, -37) #MCKN:g};
//  &CKB @WIRE(mode="straight", linecolor="#ab6c15", linewidth=0.16) {#MCKP:d %clock1_out #MCKN:d};
//  #MCK2P @PLACE(-118, -23) => @ORIENT("R0");
//  #MCK2P @TEXT("MCK2P", key="name", size=1.15, bold=true, halign="start", textcolor="#273747") => @PLACE(-115.2, -21.8);
//  #MCK2P @TEXT("8\mu{}m/30nm  nf8", key="dims", size=1, halign="start", textcolor="#526171") => @PLACE(-115.2, -24.5);
//  #MCK2N @PLACE(-118, -37) => @ORIENT("R0");
//  #MCK2N @TEXT("MCK2N", key="name", size=1.15, bold=true, halign="start", textcolor="#273747") => @PLACE(-115.2, -35.8);
//  #MCK2N @TEXT("4\mu{}m/30nm  nf4", key="dims", size=1, halign="start", textcolor="#526171") => @PLACE(-115.2, -38.5);
//  %clock2_in = (-124, -30);
//  $JUNCTION @ATTACH %clock2_in => @SET-STYLE $clock_wire;
//  %clock2_out = (-118, -30);
//  $JUNCTION @ATTACH %clock2_out => @SET-STYLE $clock_wire;
//  &CKB @WIRE(mode="straight", linecolor="#ab6c15", linewidth=0.16) {#MCK2P:g (-124, -23) %clock2_in (-124, -37) #MCK2N:g};
//  &CKR @WIRE(mode="straight", linecolor="#ab6c15", linewidth=0.16) {#MCK2P:d %clock2_out #MCK2N:d};
//  %ckb_fanout = (-140, -30);
//  $JUNCTION @ATTACH %ckb_fanout => @SET-STYLE $clock_wire;
//  %ckr_fanout = (-96, -30);
//  $JUNCTION @ATTACH %ckr_fanout => @SET-STYLE $clock_wire;
//  &CKB @WIRE(mode="straight", linecolor="#ab6c15", linewidth=0.16) {%clock1_out %ckb_fanout %clock2_in};
//  &CKR @WIRE(mode="straight", linecolor="#ab6c15", linewidth=0.16) {%clock2_out %ckr_fanout};
//  #CCB @PLACE(-140, -56) => @ORIENT("R0");
//  #CCB @TEXT("CCB", key="name", size=1.15, bold=true, halign="end", textcolor="#273747") => @PLACE(-143, -54.5);
//  #CCB @TEXT("4.46051 fF nominal", key="value", size=0.95, halign="end", textcolor="#526171") => @PLACE(-143, -57.3);
//  #CCB @TEXT("nr=16, lr=1\mu{}m", key="geometry", size=0.9, halign="end", textcolor="#526171") => @PLACE(-143, -60.1);
//  &CKB @WIRE(mode="straight", linecolor="#ab6c15", linewidth=0.16) {%ckb_fanout #CCB:p};
//  %g_CCB = $GROUND @ATTACH &VSS => @PLACE(-140, -64);
//  %g_CCB => @SET-STYLE $power_wire;
//  &VSS @WIRE(mode="straight", linecolor="#697887", linewidth=0.11) {#CCB:n %g_CCB:p};
//  #CCR @PLACE(-96, -56) => @ORIENT("R0");
//  #CCR @TEXT("CCR", key="name", size=1.15, bold=true, halign="end", textcolor="#273747") => @PLACE(-99, -54.5);
//  #CCR @TEXT("4.46051 fF nominal", key="value", size=0.95, halign="end", textcolor="#526171") => @PLACE(-99, -57.3);
//  #CCR @TEXT("nr=16, lr=1\mu{}m", key="geometry", size=0.9, halign="end", textcolor="#526171") => @PLACE(-99, -60.1);
//  &CKR @WIRE(mode="straight", linecolor="#ab6c15", linewidth=0.16) {%ckr_fanout #CCR:p};
//  %g_CCR = $GROUND @ATTACH &VSS => @PLACE(-96, -64);
//  %g_CCR => @SET-STYLE $power_wire;
//  &VSS @WIRE(mode="straight", linecolor="#697887", linewidth=0.11) {#CCR:n %g_CCR:p};
//  %clock_vdd_p = (-162, -14);
//  $JUNCTION @ATTACH %clock_vdd_p => @SET-STYLE $power_wire;
//  %clock_vdd_n = (-118, -14);
//  $JUNCTION @ATTACH %clock_vdd_n => @SET-STYLE $power_wire;
//  &AVDD @WIRE(mode="straight", linecolor="#697887", linewidth=0.11) {%clock_vdd_p %clock_vdd_n};
//  %s_MCKP = (-162, -20);
//  $JUNCTION @ATTACH %s_MCKP => @SET-STYLE $power_wire;
//  &AVDD @WIRE(mode="straight", linecolor="#697887", linewidth=0.11) {#MCKP:s %s_MCKP};
//  &AVDD @WIRE(mode="straight", linecolor="#697887", linewidth=0.11) {#MCKP:b (-160, -23) (-160, -20) %s_MCKP};
//  &AVDD @WIRE(mode="straight", linecolor="#697887", linewidth=0.11) {%s_MCKP %clock_vdd_p};
//  %s_MCK2P = (-118, -20);
//  $JUNCTION @ATTACH %s_MCK2P => @SET-STYLE $power_wire;
//  &AVDD @WIRE(mode="straight", linecolor="#697887", linewidth=0.11) {#MCK2P:s %s_MCK2P};
//  &AVDD @WIRE(mode="straight", linecolor="#697887", linewidth=0.11) {#MCK2P:b (-116, -23) (-116, -20) %s_MCK2P};
//  &AVDD @WIRE(mode="straight", linecolor="#697887", linewidth=0.11) {%s_MCK2P %clock_vdd_n};
//  %clock_vdd_tag = $SUPPLY @ATTACH &AVDD => @PLACE(-168, -11.5);
//  %clock_vdd_tag => @SET-STYLE $power_wire;
//  &AVDD @WIRE(mode="straight", linecolor="#697887", linewidth=0.11) {%clock_vdd_p (-168, -14) %clock_vdd_tag:p};
//  %s_MCKN = (-162, -40);
//  $JUNCTION @ATTACH %s_MCKN => @SET-STYLE $power_wire;
//  &VSS @WIRE(mode="straight", linecolor="#697887", linewidth=0.11) {#MCKN:s %s_MCKN};
//  &VSS @WIRE(mode="straight", linecolor="#697887", linewidth=0.11) {#MCKN:b (-160, -37) (-160, -40) %s_MCKN};
//  %g_MCKN = $GROUND @ATTACH &VSS => @PLACE(-162, -44);
//  %g_MCKN => @SET-STYLE $power_wire;
//  &VSS @WIRE(mode="straight", linecolor="#697887", linewidth=0.11) {%s_MCKN %g_MCKN:p};
//  %s_MCK2N = (-118, -40);
//  $JUNCTION @ATTACH %s_MCK2N => @SET-STYLE $power_wire;
//  &VSS @WIRE(mode="straight", linecolor="#697887", linewidth=0.11) {#MCK2N:s %s_MCK2N};
//  &VSS @WIRE(mode="straight", linecolor="#697887", linewidth=0.11) {#MCK2N:b (-116, -37) (-116, -40) %s_MCK2N};
//  %g_MCK2N = $GROUND @ATTACH &VSS => @PLACE(-118, -44);
//  %g_MCK2N => @SET-STYLE $power_wire;
//  &VSS @WIRE(mode="straight", linecolor="#697887", linewidth=0.11) {%s_MCK2N %g_MCK2N:p};
//  %port_CLKC = $IO_PORT @ATTACH &CLKC => @PLACE(-198, -30) => @ORIENT("R0");
//  %port_CLKC @TEXT("CLKC", key="name", size=1, bold=true);
//  %clk_direct = (-184, -30);
//  $JUNCTION @ATTACH %clk_direct => @SET-STYLE $clock_wire;
//  &CLKC @WIRE(mode="straight", linecolor="#ab6c15", linewidth=0.16) {%port_CLKC:p %clk_direct %clock1_in};
//  &CLKC @WIRE(mode="straight", linecolor="#ab6c15", linewidth=0.16) {%clk_direct (-184, -78) %clk_precharge_p};
//  &CKR @WIRE(mode="straight", linecolor="#ab6c15", linewidth=0.16) {%ckr_fanout (-68, -30) (-68, -4) (0, -4) %ckr_core};
//  (-145, -27.5) @TEXT("CKB", size=0.95, bold=true, halign="end", textcolor="#ab6c15");
//  (-91, -27.5) @TEXT("CKR", size=0.95, bold=true, halign="start", textcolor="#ab6c15");
//  (-35, -2) @TEXT("CKR", size=0.95, bold=true, halign="middle", textcolor="#ab6c15");
//  {#MCKP #MCKN #MCK2P #MCK2N #CCB #CCR} @GROUP;
//  %outp_assist = (-86, 42);
//  $JUNCTION @ATTACH %outp_assist => @SET-STYLE $p_wire;
//  %outn_assist = (86, 37);
//  $JUNCTION @ATTACH %outn_assist => @SET-STYLE $n_wire;
//  &OUTP @WIRE(mode="straight", linecolor="#3f5597", linewidth=0.16) {%outp_reset %outp_assist #MRQP:d};
//  &OUTN @WIRE(mode="straight", linecolor="#16817a", linewidth=0.16) {%outn_reset %outn_assist #MRQN:d};
//  %port_OUTP = $IO_PORT @ATTACH &OUTP => @PLACE(-126, 42) => @ORIENT("R0");
//  %port_OUTP @TEXT("OUTP", key="name", size=1, bold=true);
//  %port_OUTN = $IO_PORT @ATTACH &OUTN => @PLACE(126, 42) => @ORIENT("MY");
//  %port_OUTN @TEXT("OUTN", key="name", size=1, bold=true);
//  &OUTP @WIRE(mode="straight", linecolor="#3f5597", linewidth=0.16) {%outp_assist %port_OUTP:p};
//  &OUTN @WIRE(mode="straight", linecolor="#16817a", linewidth=0.16) {%outn_assist (114, 37) (114, 42) %port_OUTN:p};
//  %assist_vss_p = (-86, 20);
//  $JUNCTION @ATTACH %assist_vss_p => @SET-STYLE $power_wire;
//  %assist_vss_n = (86, 20);
//  $JUNCTION @ATTACH %assist_vss_n => @SET-STYLE $power_wire;
//  %s_MRQP = (-86, 27);
//  $JUNCTION @ATTACH %s_MRQP => @SET-STYLE $power_wire;
//  &VSS @WIRE(mode="straight", linecolor="#697887", linewidth=0.11) {#MRQP:s %s_MRQP};
//  &VSS @WIRE(mode="straight", linecolor="#697887", linewidth=0.11) {#MRQP:b (-88, 30) (-88, 27) %s_MRQP};
//  &VSS @WIRE(mode="straight", linecolor="#697887", linewidth=0.11) {%s_MRQP %assist_vss_p %latch_vss_0};
//  %s_MRQN = (86, 27);
//  $JUNCTION @ATTACH %s_MRQN => @SET-STYLE $power_wire;
//  &VSS @WIRE(mode="straight", linecolor="#697887", linewidth=0.11) {#MRQN:s %s_MRQN};
//  &VSS @WIRE(mode="straight", linecolor="#697887", linewidth=0.11) {#MRQN:b (88, 30) (88, 27) %s_MRQN};
//  &VSS @WIRE(mode="straight", linecolor="#697887", linewidth=0.11) {%s_MRQN %assist_vss_n %latch_vss_6};
//  %ckb_reset_p = (-76, 12);
//  $JUNCTION @ATTACH %ckb_reset_p => @SET-STYLE $clock_wire;
//  %ckb_reset_n = (76, 12);
//  $JUNCTION @ATTACH %ckb_reset_n => @SET-STYLE $clock_wire;
//  &CKB @WIRE(mode="straight", linecolor="#ab6c15", linewidth=0.16) {%ckb_fanout (-140, 12) %ckb_reset_p %ckb_reset_n};
//  &CKB @WIRE(mode="straight", linecolor="#ab6c15", linewidth=0.16) {%ckb_reset_p (-76, 30) #MRQP:g};
//  &CKB @WIRE(mode="straight", linecolor="#ab6c15", linewidth=0.16) {%ckb_reset_n (76, 30) #MRQN:g};
//  (-30, 14.5) @TEXT("CKB", size=0.95, bold=true, halign="middle", textcolor="#ab6c15");
//  (78, 15) @TEXT("CKB", size=0.95, bold=true, halign="start", textcolor="#ab6c15");
//  (-23, 65.5) @TEXT("XP", size=0.85, bold=true, halign="middle", textcolor="#286e97");
//  (23, 65.5) @TEXT("XN", size=0.85, bold=true, halign="middle", textcolor="#286e97");
//  (-27, 44) @TEXT("OUTP", size=0.9, bold=true, halign="middle", textcolor="#3f5597");
//  (27, 39) @TEXT("OUTN", size=0.9, bold=true, halign="middle", textcolor="#16817a");
//  (4, -41) @TEXT("TAIL", size=0.8, bold=false, halign="start", textcolor="#526171");
//  (0, -84) @TEXT("Dots mark connections. Crossings without dots are separate nets.", size=0.85, bold=false, halign="middle", textcolor="#526171");
//  %input_pair = #MINP(in_p) #MINN(in_n) #MTAIL(tail) @AS $DIFFERENTIAL_PAIR;
//  %core_axis = (0, 0);
//  {#MINP #MINN} @AS $MATCHED;
//  #MINP(a) #MINN(b) %core_axis(axis) @AS $MIRRORED;
//  {#MRDP #MRDN} @AS $MATCHED;
//  #MRDP(a) #MRDN(b) %core_axis(axis) @AS $MIRRORED;
//  {#MAP #MAN} @AS $MATCHED;
//  #MAP(a) #MAN(b) %core_axis(axis) @AS $MIRRORED;
//  {#M14 #M15} @AS $MATCHED;
//  #M14(a) #M15(b) %core_axis(axis) @AS $MIRRORED;
//  {#M12 #M13} @AS $MATCHED;
//  #M12(a) #M13(b) %core_axis(axis) @AS $MIRRORED;
//  {#M10 #M11} @AS $MATCHED;
//  #M10(a) #M11(b) %core_axis(axis) @AS $MIRRORED;
//  {#M6 #M7} @AS $MATCHED;
//  #M6(a) #M7(b) %core_axis(axis) @AS $MIRRORED;
//  {#M8 #M9} @AS $MATCHED;
//  #M8(a) #M9(b) %core_axis(axis) @AS $MIRRORED;
//  {#MRQP #MRQN} @AS $MATCHED;
//  #MRQP(a) #MRQN(b) %core_axis(axis) @AS $MIRRORED;
//  {#CDP #CDN} @AS $MATCHED;
//  #CDP(a) #CDN(b) %core_axis(axis) @AS $MIRRORED;
//  {#MINP #MINN #MTAIL #MRDP #MRDN #MAP #MAN #CDP #CDN} @GROUP;
//  {#M14 #M15 #M12 #M13 #M10 #M11 #M6 #M7 #M8 #M9} @GROUP;
//  {#MRQP #MRQN} @GROUP;
// }
ends adc_comp
