// Miyahara comparator core with return-to-zero output interface.
// @RNL(type="header") {
//   @VERSION("0.3");
//   @USE-PACKAGE(name="adc28", version="0.1", path="../../../rnl/adc28.rnl")
// }
simulator lang=spectre
subckt adc_comp (INP INN CLKC OUTP OUTN AVDD VSS)
// Geometry and terminal parasitics are from successful device callbacks.
// INP > INN asserts OUTP. CLKC low resets both external outputs to zero.
MCKN (CKB CLKC VSS VSS) nch_ulvt_mac l=3e-08 w=2e-06 nf=2 m=1 ad=1e-13 as=1.5e-13 pd=2.2e-06 ps=4.3e-06 nrd=0.185844 nrs=0.185844 sa=1.12742e-07 sb=1.12742e-07 sd=1e-07
MCKP (CKB CLKC AVDD AVDD) pch_ulvt_mac l=3e-08 w=4e-06 nf=4 m=1 ad=2e-13 as=2.5e-13 pd=4.4e-06 ps=6.5e-06 nrd=0.048530 nrs=0.048530 sa=1.79203e-07 sb=1.79203e-07 sd=1e-07
MCK2N (CKE CKB VSS VSS) nch_ulvt_mac l=3e-08 w=4e-06 nf=4 m=1 ad=2e-13 as=2.5e-13 pd=4.4e-06 ps=6.5e-06 nrd=0.108289 nrs=0.108289 sa=1.79203e-07 sb=1.79203e-07 sd=1e-07
MCK2P (CKE CKB AVDD AVDD) pch_ulvt_mac l=3e-08 w=8e-06 nf=8 m=1 ad=4e-13 as=4.5e-13 pd=8.8e-06 ps=1.09e-05 nrd=0.024976 nrs=0.024976 sa=2.95835e-07 sb=2.95835e-07 sd=1e-07
MINP (DP INP TAIL VSS) nch_ulvt_mac l=3e-08 w=4.8e-05 nf=48 m=1 ad=2.4e-12 as=2.45e-12 pd=5.28e-05 ps=5.49e-05 nrd=0.010636 nrs=0.010636 sa=1.20441e-06 sb=1.20441e-06 sd=1e-07
MINN (DN INN TAIL VSS) nch_ulvt_mac l=3e-08 w=4.8e-05 nf=48 m=1 ad=2.4e-12 as=2.45e-12 pd=5.28e-05 ps=5.49e-05 nrd=0.010636 nrs=0.010636 sa=1.20441e-06 sb=1.20441e-06 sd=1e-07
MTAIL (TAIL CKE VSS VSS) nch_ulvt_mac l=3e-08 w=4e-06 nf=4 m=1 ad=2e-13 as=2.5e-13 pd=4.4e-06 ps=6.5e-06 nrd=0.108289 nrs=0.108289 sa=1.79203e-07 sb=1.79203e-07 sd=1e-07
MRDP (DP CKE AVDD AVDD) pch_ulvt_mac l=3e-08 w=4e-06 nf=4 m=1 ad=2e-13 as=2.5e-13 pd=4.4e-06 ps=6.5e-06 nrd=0.048530 nrs=0.048530 sa=1.79203e-07 sb=1.79203e-07 sd=1e-07
MRDN (DN CKE AVDD AVDD) pch_ulvt_mac l=3e-08 w=4e-06 nf=4 m=1 ad=2e-13 as=2.5e-13 pd=4.4e-06 ps=6.5e-06 nrd=0.048530 nrs=0.048530 sa=1.79203e-07 sb=1.79203e-07 sd=1e-07
M14 (XP DP AVDD AVDD) pch_ulvt_mac l=3e-08 w=4e-06 nf=4 m=1 ad=2e-13 as=2.5e-13 pd=4.4e-06 ps=6.5e-06 nrd=0.048530 nrs=0.048530 sa=1.79203e-07 sb=1.79203e-07 sd=1e-07
M15 (XN DN AVDD AVDD) pch_ulvt_mac l=3e-08 w=4e-06 nf=4 m=1 ad=2e-13 as=2.5e-13 pd=4.4e-06 ps=6.5e-06 nrd=0.048530 nrs=0.048530 sa=1.79203e-07 sb=1.79203e-07 sd=1e-07
M12 (XP DP VSS VSS) nch_ulvt_mac l=3e-08 w=1e-06 nf=2 m=1 ad=5e-14 as=7.5e-14 pd=1.2e-06 ps=2.3e-06 nrd=0.425847 nrs=0.425847 sa=1.12742e-07 sb=1.12742e-07 sd=1e-07
M13 (XN DN VSS VSS) nch_ulvt_mac l=3e-08 w=1e-06 nf=2 m=1 ad=5e-14 as=7.5e-14 pd=1.2e-06 ps=2.3e-06 nrd=0.425847 nrs=0.425847 sa=1.12742e-07 sb=1.12742e-07 sd=1e-07
M10 (QP QN XP AVDD) pch_ulvt_mac l=3e-08 w=4e-06 nf=4 m=1 ad=2e-13 as=2.5e-13 pd=4.4e-06 ps=6.5e-06 nrd=0.048530 nrs=0.048530 sa=1.79203e-07 sb=1.79203e-07 sd=1e-07
M11 (QN QP XN AVDD) pch_ulvt_mac l=3e-08 w=4e-06 nf=4 m=1 ad=2e-13 as=2.5e-13 pd=4.4e-06 ps=6.5e-06 nrd=0.048530 nrs=0.048530 sa=1.79203e-07 sb=1.79203e-07 sd=1e-07
M6 (QP QN VSS VSS) nch_ulvt_mac l=3e-08 w=2e-06 nf=2 m=1 ad=1e-13 as=1.5e-13 pd=2.2e-06 ps=4.3e-06 nrd=0.185844 nrs=0.185844 sa=1.12742e-07 sb=1.12742e-07 sd=1e-07
M7 (QN QP VSS VSS) nch_ulvt_mac l=3e-08 w=2e-06 nf=2 m=1 ad=1e-13 as=1.5e-13 pd=2.2e-06 ps=4.3e-06 nrd=0.185844 nrs=0.185844 sa=1.12742e-07 sb=1.12742e-07 sd=1e-07
M8 (QP DP VSS VSS) nch_ulvt_mac l=3e-08 w=1e-06 nf=2 m=1 ad=5e-14 as=7.5e-14 pd=1.2e-06 ps=2.3e-06 nrd=0.425847 nrs=0.425847 sa=1.12742e-07 sb=1.12742e-07 sd=1e-07
M9 (QN DN VSS VSS) nch_ulvt_mac l=3e-08 w=1e-06 nf=2 m=1 ad=5e-14 as=7.5e-14 pd=1.2e-06 ps=2.3e-06 nrd=0.425847 nrs=0.425847 sa=1.12742e-07 sb=1.12742e-07 sd=1e-07
MBPN (BP QP VSS VSS) nch_ulvt_mac l=3e-08 w=1e-06 nf=2 m=1 ad=5e-14 as=7.5e-14 pd=1.2e-06 ps=2.3e-06 nrd=0.425847 nrs=0.425847 sa=1.12742e-07 sb=1.12742e-07 sd=1e-07
MBPP (BP QP AVDD AVDD) pch_ulvt_mac l=3e-08 w=2e-06 nf=2 m=1 ad=1e-13 as=1.5e-13 pd=2.2e-06 ps=4.3e-06 nrd=0.091833 nrs=0.091833 sa=1.12742e-07 sb=1.12742e-07 sd=1e-07
MBNN (BN QN VSS VSS) nch_ulvt_mac l=3e-08 w=1e-06 nf=2 m=1 ad=5e-14 as=7.5e-14 pd=1.2e-06 ps=2.3e-06 nrd=0.425847 nrs=0.425847 sa=1.12742e-07 sb=1.12742e-07 sd=1e-07
MBNP (BN QN AVDD AVDD) pch_ulvt_mac l=3e-08 w=2e-06 nf=2 m=1 ad=1e-13 as=1.5e-13 pd=2.2e-06 ps=4.3e-06 nrd=0.091833 nrs=0.091833 sa=1.12742e-07 sb=1.12742e-07 sd=1e-07
MOPN (OUTP BP VSS VSS) nch_ulvt_mac l=3e-08 w=2e-06 nf=2 m=1 ad=1e-13 as=1.5e-13 pd=2.2e-06 ps=4.3e-06 nrd=0.185844 nrs=0.185844 sa=1.12742e-07 sb=1.12742e-07 sd=1e-07
MOPP (OUTP BP AVDD AVDD) pch_ulvt_mac l=3e-08 w=4e-06 nf=4 m=1 ad=2e-13 as=2.5e-13 pd=4.4e-06 ps=6.5e-06 nrd=0.048530 nrs=0.048530 sa=1.79203e-07 sb=1.79203e-07 sd=1e-07
MONN (OUTN BN VSS VSS) nch_ulvt_mac l=3e-08 w=2e-06 nf=2 m=1 ad=1e-13 as=1.5e-13 pd=2.2e-06 ps=4.3e-06 nrd=0.185844 nrs=0.185844 sa=1.12742e-07 sb=1.12742e-07 sd=1e-07
MONP (OUTN BN AVDD AVDD) pch_ulvt_mac l=3e-08 w=4e-06 nf=4 m=1 ad=2e-13 as=2.5e-13 pd=4.4e-06 ps=6.5e-06 nrd=0.048530 nrs=0.048530 sa=1.79203e-07 sb=1.79203e-07 sd=1e-07
// @RNL(author="schematic-review") {
//  &VSS @ADD-TO $GROUND_NET_SET;
//  &AVDD @ADD-TO $SUPPLY_NET_SET;
//  # @SELECT-INSTANCE => @TEXT("", key="model");
//  # @SELECT-INSTANCE => @TEXT("", key="name");
//  $clock_wire = @DEFINE-STYLE(linecolor="#ab6c15", fillcolor="#ab6c15", textcolor="#ab6c15") {};
//  $p_wire = @DEFINE-STYLE(linecolor="#3f5597", fillcolor="#3f5597", textcolor="#3f5597") {};
//  $n_wire = @DEFINE-STYLE(linecolor="#16817a", fillcolor="#16817a", textcolor="#16817a") {};
//  $dynamic_wire = @DEFINE-STYLE(linecolor="#286e97", fillcolor="#286e97", textcolor="#286e97") {};
//  $power_wire = @DEFINE-STYLE(linecolor="#697887", fillcolor="#697887", textcolor="#697887") {};
//  $signal_wire = @DEFINE-STYLE(linecolor="#263442", fillcolor="#263442", textcolor="#263442") {};
//  @LINE(linecolor="#d3dbe4", linewidth=0.08, linestyle="dashed") {(-62, -64) (62, -64) (62, 94) (-62, 94) (-62, -64)};
//  @LINE(linecolor="#d3dbe4", linewidth=0.08, linestyle="dashed") {(-132, 22) (-72, 22) (-72, 70) (-132, 70) (-132, 22)};
//  @LINE(linecolor="#d3dbe4", linewidth=0.08, linestyle="dashed") {(72, 22) (132, 22) (132, 70) (72, 70) (72, 22)};
//  @LINE(linecolor="#d3dbe4", linewidth=0.08, linestyle="dashed") {(-132, -46) (-66, -46) (-66, 8) (-132, 8) (-132, -46)};
//  (0, 104) @TEXT("Miyahara two-stage comparator", size=2, bold=true, halign="middle", textcolor="#273747");
//  (0, 97) @TEXT("28 nm HPC+ | ULVT MOS | device labels: W/L and nf", size=0.9, bold=false, halign="middle", textcolor="#526171");
//  (0, 91.5) @TEXT("Regenerative second stage", size=1.35, bold=true, halign="middle", textcolor="#273747");
//  (0, 7) @TEXT("Dynamic input stage", size=1.35, bold=true, halign="middle", textcolor="#273747");
//  @LINE(linecolor="#d3dbe4", linewidth=0.08, linestyle="dashed") {(-62, 12) (62, 12)};
//  (-102, 67) @TEXT("OUTP buffer", size=1.35, bold=true, halign="middle", textcolor="#273747");
//  (102, 67) @TEXT("OUTN buffer", size=1.35, bold=true, halign="middle", textcolor="#273747");
//  #M14 @PLACE(-18, 72) => @ORIENT("R0");
//  #M14 @TEXT("M14", key="name", size=1.15, bold=true, halign="start", textcolor="#273747") => @PLACE(-15.2, 73.2);
//  #M14 @TEXT("4\mu{}m/30nm  nf4", key="dims", size=1, halign="start", textcolor="#526171") => @PLACE(-15.2, 70.5);
//  #M15 @PLACE(18, 72) => @ORIENT("MY");
//  #M15 @TEXT("M15", key="name", size=1.15, bold=true, halign="end", textcolor="#273747") => @PLACE(15.2, 73.2);
//  #M15 @TEXT("4\mu{}m/30nm  nf4", key="dims", size=1, halign="end", textcolor="#526171") => @PLACE(15.2, 70.5);
//  #M10 @PLACE(-18, 52) => @ORIENT("MY");
//  #M10 @TEXT("M10", key="name", size=1.15, bold=true, halign="end", textcolor="#273747") => @PLACE(-20.8, 53.2);
//  #M10 @TEXT("4\mu{}m/30nm  nf4", key="dims", size=1, halign="end", textcolor="#526171") => @PLACE(-20.8, 50.5);
//  #M11 @PLACE(18, 52) => @ORIENT("R0");
//  #M11 @TEXT("M11", key="name", size=1.15, bold=true, halign="start", textcolor="#273747") => @PLACE(20.8, 53.2);
//  #M11 @TEXT("4\mu{}m/30nm  nf4", key="dims", size=1, halign="start", textcolor="#526171") => @PLACE(20.8, 50.5);
//  #M6 @PLACE(-18, 30) => @ORIENT("MY");
//  #M6 @TEXT("M6", key="name", size=1.15, bold=true, halign="end", textcolor="#273747") => @PLACE(-20.8, 31.2);
//  #M6 @TEXT("2\mu{}m/30nm  nf2", key="dims", size=1, halign="end", textcolor="#526171") => @PLACE(-20.8, 28.5);
//  #M7 @PLACE(18, 30) => @ORIENT("R0");
//  #M7 @TEXT("M7", key="name", size=1.15, bold=true, halign="start", textcolor="#273747") => @PLACE(20.8, 31.2);
//  #M7 @TEXT("2\mu{}m/30nm  nf2", key="dims", size=1, halign="start", textcolor="#526171") => @PLACE(20.8, 28.5);
//  #M12 @PLACE(-42, 60) => @ORIENT("R0");
//  #M12 @TEXT("M12", key="name", size=1.15, bold=true, halign="start", textcolor="#273747") => @PLACE(-39.2, 61.2);
//  #M12 @TEXT("1\mu{}m/30nm  nf2", key="dims", size=1, halign="start", textcolor="#526171") => @PLACE(-39.2, 58.5);
//  #M13 @PLACE(42, 60) => @ORIENT("MY");
//  #M13 @TEXT("M13", key="name", size=1.15, bold=true, halign="end", textcolor="#273747") => @PLACE(39.2, 61.2);
//  #M13 @TEXT("1\mu{}m/30nm  nf2", key="dims", size=1, halign="end", textcolor="#526171") => @PLACE(39.2, 58.5);
//  #M8 @PLACE(-42, 30) => @ORIENT("R0");
//  #M8 @TEXT("M8", key="name", size=1.15, bold=true, halign="start", textcolor="#273747") => @PLACE(-39.2, 31.2);
//  #M8 @TEXT("1\mu{}m/30nm  nf2", key="dims", size=1, halign="start", textcolor="#526171") => @PLACE(-39.2, 28.5);
//  #M9 @PLACE(42, 30) => @ORIENT("MY");
//  #M9 @TEXT("M9", key="name", size=1.15, bold=true, halign="end", textcolor="#273747") => @PLACE(39.2, 31.2);
//  #M9 @TEXT("1\mu{}m/30nm  nf2", key="dims", size=1, halign="end", textcolor="#526171") => @PLACE(39.2, 28.5);
//  #MRDP @PLACE(-18, -8) => @ORIENT("MY");
//  #MRDP @TEXT("MRDP", key="name", size=1.15, bold=true, halign="end", textcolor="#273747") => @PLACE(-20.8, -6.8);
//  #MRDP @TEXT("4\mu{}m/30nm  nf4", key="dims", size=1, halign="end", textcolor="#526171") => @PLACE(-20.8, -9.5);
//  #MRDN @PLACE(18, -8) => @ORIENT("R0");
//  #MRDN @TEXT("MRDN", key="name", size=1.15, bold=true, halign="start", textcolor="#273747") => @PLACE(20.8, -6.8);
//  #MRDN @TEXT("4\mu{}m/30nm  nf4", key="dims", size=1, halign="start", textcolor="#526171") => @PLACE(20.8, -9.5);
//  #MINP @PLACE(-18, -30) => @ORIENT("R0");
//  #MINP @TEXT("MINP", key="name", size=1.15, bold=true, halign="start", textcolor="#273747") => @PLACE(-15.2, -28.8);
//  #MINP @TEXT("48\mu{}m/30nm  nf48", key="dims", size=1, halign="start", textcolor="#526171") => @PLACE(-15.2, -31.5);
//  #MINN @PLACE(18, -30) => @ORIENT("MY");
//  #MINN @TEXT("MINN", key="name", size=1.15, bold=true, halign="end", textcolor="#273747") => @PLACE(15.2, -28.8);
//  #MINN @TEXT("48\mu{}m/30nm  nf48", key="dims", size=1, halign="end", textcolor="#526171") => @PLACE(15.2, -31.5);
//  #MTAIL @PLACE(0, -50) => @ORIENT("R0");
//  #MTAIL @TEXT("MTAIL", key="name", size=1.15, bold=true, halign="start", textcolor="#273747") => @PLACE(2.8, -48.8);
//  #MTAIL @TEXT("4\mu{}m/30nm  nf4", key="dims", size=1, halign="start", textcolor="#526171") => @PLACE(2.8, -51.5);
//  %latch_vdd_0 = (-48, 84);
//  %latch_vdd_1 = (-18, 84);
//  $JUNCTION @ATTACH %latch_vdd_1 => @SET-STYLE $power_wire;
//  %latch_vdd_2 = (0.0, 84);
//  $JUNCTION @ATTACH %latch_vdd_2 => @SET-STYLE $power_wire;
//  %latch_vdd_3 = (18, 84);
//  $JUNCTION @ATTACH %latch_vdd_3 => @SET-STYLE $power_wire;
//  %latch_vdd_4 = (48, 84);
//  &AVDD @WIRE(mode="straight", linecolor="#697887", linewidth=0.11) {%latch_vdd_0 %latch_vdd_1 %latch_vdd_2 %latch_vdd_3 %latch_vdd_4};
//  %s_M14 = (-18, 75);
//  $JUNCTION @ATTACH %s_M14 => @SET-STYLE $power_wire;
//  &AVDD @WIRE(mode="straight", linecolor="#697887", linewidth=0.11) {#M14:s %s_M14};
//  &AVDD @WIRE(mode="straight", linecolor="#697887", linewidth=0.11) {#M14:b (-16, 72) (-16, 75) %s_M14};
//  &AVDD @WIRE(mode="straight", linecolor="#697887", linewidth=0.11) {%s_M14 %latch_vdd_1};
//  %s_M15 = (18, 75);
//  $JUNCTION @ATTACH %s_M15 => @SET-STYLE $power_wire;
//  &AVDD @WIRE(mode="straight", linecolor="#697887", linewidth=0.11) {#M15:s %s_M15};
//  &AVDD @WIRE(mode="straight", linecolor="#697887", linewidth=0.11) {#M15:b (16, 72) (16, 75) %s_M15};
//  &AVDD @WIRE(mode="straight", linecolor="#697887", linewidth=0.11) {%s_M15 %latch_vdd_3};
//  %latch_vdd_tag = $SUPPLY @ATTACH &AVDD => @PLACE(0.0, 86.5);
//  %latch_vdd_tag => @SET-STYLE $power_wire;
//  &AVDD @WIRE(mode="straight", linecolor="#697887", linewidth=0.11) {%latch_vdd_2 %latch_vdd_tag:p};
//  %latch_vss_0 = (-48, 18);
//  %latch_vss_1 = (-42, 18);
//  $JUNCTION @ATTACH %latch_vss_1 => @SET-STYLE $power_wire;
//  %latch_vss_2 = (-18, 18);
//  $JUNCTION @ATTACH %latch_vss_2 => @SET-STYLE $power_wire;
//  %latch_vss_3 = (0.0, 18);
//  $JUNCTION @ATTACH %latch_vss_3 => @SET-STYLE $power_wire;
//  %latch_vss_4 = (18, 18);
//  $JUNCTION @ATTACH %latch_vss_4 => @SET-STYLE $power_wire;
//  %latch_vss_5 = (42, 18);
//  $JUNCTION @ATTACH %latch_vss_5 => @SET-STYLE $power_wire;
//  %latch_vss_6 = (48, 18);
//  &VSS @WIRE(mode="straight", linecolor="#697887", linewidth=0.11) {%latch_vss_0 %latch_vss_1 %latch_vss_2 %latch_vss_3 %latch_vss_4 %latch_vss_5 %latch_vss_6};
//  %s_M8 = (-42, 27);
//  $JUNCTION @ATTACH %s_M8 => @SET-STYLE $power_wire;
//  &VSS @WIRE(mode="straight", linecolor="#697887", linewidth=0.11) {#M8:s %s_M8};
//  &VSS @WIRE(mode="straight", linecolor="#697887", linewidth=0.11) {#M8:b (-40, 30) (-40, 27) %s_M8};
//  &VSS @WIRE(mode="straight", linecolor="#697887", linewidth=0.11) {%s_M8 %latch_vss_1};
//  %s_M6 = (-18, 27);
//  $JUNCTION @ATTACH %s_M6 => @SET-STYLE $power_wire;
//  &VSS @WIRE(mode="straight", linecolor="#697887", linewidth=0.11) {#M6:s %s_M6};
//  &VSS @WIRE(mode="straight", linecolor="#697887", linewidth=0.11) {#M6:b (-20, 30) (-20, 27) %s_M6};
//  &VSS @WIRE(mode="straight", linecolor="#697887", linewidth=0.11) {%s_M6 %latch_vss_2};
//  %s_M7 = (18, 27);
//  $JUNCTION @ATTACH %s_M7 => @SET-STYLE $power_wire;
//  &VSS @WIRE(mode="straight", linecolor="#697887", linewidth=0.11) {#M7:s %s_M7};
//  &VSS @WIRE(mode="straight", linecolor="#697887", linewidth=0.11) {#M7:b (20, 30) (20, 27) %s_M7};
//  &VSS @WIRE(mode="straight", linecolor="#697887", linewidth=0.11) {%s_M7 %latch_vss_4};
//  %s_M9 = (42, 27);
//  $JUNCTION @ATTACH %s_M9 => @SET-STYLE $power_wire;
//  &VSS @WIRE(mode="straight", linecolor="#697887", linewidth=0.11) {#M9:s %s_M9};
//  &VSS @WIRE(mode="straight", linecolor="#697887", linewidth=0.11) {#M9:b (40, 30) (40, 27) %s_M9};
//  &VSS @WIRE(mode="straight", linecolor="#697887", linewidth=0.11) {%s_M9 %latch_vss_5};
//  %latch_vss_tag = $GROUND @ATTACH &VSS => @PLACE(0.0, 16.5);
//  %latch_vss_tag => @SET-STYLE $power_wire;
//  &VSS @WIRE(mode="straight", linecolor="#697887", linewidth=0.11) {%latch_vss_3 %latch_vss_tag:p};
//  %b_M10 = $SUPPLY @ATTACH &AVDD => @PLACE(-29, 56);
//  %b_M10 => @SET-STYLE $power_wire;
//  &AVDD @WIRE(mode="straight", linecolor="#697887", linewidth=0.11) {#M10:b (-29, 52) %b_M10:p};
//  %b_M11 = $SUPPLY @ATTACH &AVDD => @PLACE(29, 56);
//  %b_M11 => @SET-STYLE $power_wire;
//  &AVDD @WIRE(mode="straight", linecolor="#697887", linewidth=0.11) {#M11:b (29, 52) %b_M11:p};
//  %s_M12 = (-42, 57);
//  $JUNCTION @ATTACH %s_M12 => @SET-STYLE $power_wire;
//  &VSS @WIRE(mode="straight", linecolor="#697887", linewidth=0.11) {#M12:s %s_M12};
//  &VSS @WIRE(mode="straight", linecolor="#697887", linewidth=0.11) {#M12:b (-40, 60) (-40, 57) %s_M12};
//  %g_M12 = $GROUND @ATTACH &VSS => @PLACE(-42, 54);
//  %g_M12 => @SET-STYLE $power_wire;
//  &VSS @WIRE(mode="straight", linecolor="#697887", linewidth=0.11) {%s_M12 %g_M12:p};
//  %s_M13 = (42, 57);
//  $JUNCTION @ATTACH %s_M13 => @SET-STYLE $power_wire;
//  &VSS @WIRE(mode="straight", linecolor="#697887", linewidth=0.11) {#M13:s %s_M13};
//  &VSS @WIRE(mode="straight", linecolor="#697887", linewidth=0.11) {#M13:b (40, 60) (40, 57) %s_M13};
//  %g_M13 = $GROUND @ATTACH &VSS => @PLACE(42, 54);
//  %g_M13 => @SET-STYLE $power_wire;
//  &VSS @WIRE(mode="straight", linecolor="#697887", linewidth=0.11) {%s_M13 %g_M13:p};
//  %input_vdd_0 = (-26, 0);
//  %input_vdd_1 = (-18, 0);
//  $JUNCTION @ATTACH %input_vdd_1 => @SET-STYLE $power_wire;
//  %input_vdd_2 = (0.0, 0);
//  $JUNCTION @ATTACH %input_vdd_2 => @SET-STYLE $power_wire;
//  %input_vdd_3 = (18, 0);
//  $JUNCTION @ATTACH %input_vdd_3 => @SET-STYLE $power_wire;
//  %input_vdd_4 = (26, 0);
//  &AVDD @WIRE(mode="straight", linecolor="#697887", linewidth=0.11) {%input_vdd_0 %input_vdd_1 %input_vdd_2 %input_vdd_3 %input_vdd_4};
//  %s_MRDP = (-18, -5);
//  $JUNCTION @ATTACH %s_MRDP => @SET-STYLE $power_wire;
//  &AVDD @WIRE(mode="straight", linecolor="#697887", linewidth=0.11) {#MRDP:s %s_MRDP};
//  &AVDD @WIRE(mode="straight", linecolor="#697887", linewidth=0.11) {#MRDP:b (-20, -8) (-20, -5) %s_MRDP};
//  &AVDD @WIRE(mode="straight", linecolor="#697887", linewidth=0.11) {%s_MRDP %input_vdd_1};
//  %s_MRDN = (18, -5);
//  $JUNCTION @ATTACH %s_MRDN => @SET-STYLE $power_wire;
//  &AVDD @WIRE(mode="straight", linecolor="#697887", linewidth=0.11) {#MRDN:s %s_MRDN};
//  &AVDD @WIRE(mode="straight", linecolor="#697887", linewidth=0.11) {#MRDN:b (20, -8) (20, -5) %s_MRDN};
//  &AVDD @WIRE(mode="straight", linecolor="#697887", linewidth=0.11) {%s_MRDN %input_vdd_3};
//  %input_vdd_tag = $SUPPLY @ATTACH &AVDD => @PLACE(0.0, 2.5);
//  %input_vdd_tag => @SET-STYLE $power_wire;
//  &AVDD @WIRE(mode="straight", linecolor="#697887", linewidth=0.11) {%input_vdd_2 %input_vdd_tag:p};
//  %b_MINP = $GROUND @ATTACH &VSS => @PLACE(-7, -33);
//  %b_MINP => @SET-STYLE $power_wire;
//  %b_MINP @TEXT("", key="name");
//  &VSS @WIRE(mode="straight", linecolor="#697887", linewidth=0.11) {#MINP:b (-7, -30) %b_MINP:p};
//  %b_MINN = $GROUND @ATTACH &VSS => @PLACE(7, -33);
//  %b_MINN => @SET-STYLE $power_wire;
//  %b_MINN @TEXT("", key="name");
//  &VSS @WIRE(mode="straight", linecolor="#697887", linewidth=0.11) {#MINN:b (7, -30) %b_MINN:p};
//  %s_MTAIL = (0, -53);
//  $JUNCTION @ATTACH %s_MTAIL => @SET-STYLE $power_wire;
//  &VSS @WIRE(mode="straight", linecolor="#697887", linewidth=0.11) {#MTAIL:s %s_MTAIL};
//  &VSS @WIRE(mode="straight", linecolor="#697887", linewidth=0.11) {#MTAIL:b (2, -50) (2, -53) %s_MTAIL};
//  %g_MTAIL = $GROUND @ATTACH &VSS => @PLACE(0, -58);
//  %g_MTAIL => @SET-STYLE $power_wire;
//  &VSS @WIRE(mode="straight", linecolor="#697887", linewidth=0.11) {%s_MTAIL %g_MTAIL:p};
//  %xp = (-18, 64);
//  $JUNCTION @ATTACH %xp => @SET-STYLE $dynamic_wire;
//  %xn = (18, 64);
//  $JUNCTION @ATTACH %xn => @SET-STYLE $dynamic_wire;
//  &XP @WIRE(mode="straight", linecolor="#286e97", linewidth=0.16) {#M14:d %xp #M10:s};
//  &XP @WIRE(mode="straight", linecolor="#286e97", linewidth=0.16) {#M12:d (-42, 64) %xp};
//  &XN @WIRE(mode="straight", linecolor="#286e97", linewidth=0.16) {#M15:d %xn #M11:s};
//  &XN @WIRE(mode="straight", linecolor="#286e97", linewidth=0.16) {#M13:d (42, 64) %xn};
//  %qp = (-18, 42);
//  $JUNCTION @ATTACH %qp => @SET-STYLE $p_wire;
//  %qn = (18, 37);
//  $JUNCTION @ATTACH %qn => @SET-STYLE $n_wire;
//  %qp_reset = (-42, 42);
//  $JUNCTION @ATTACH %qp_reset => @SET-STYLE $p_wire;
//  %qn_reset = (42, 37);
//  $JUNCTION @ATTACH %qn_reset => @SET-STYLE $n_wire;
//  &QP @WIRE(mode="straight", linecolor="#3f5597", linewidth=0.16) {#M10:d %qp #M6:d};
//  &QP @WIRE(mode="straight", linecolor="#3f5597", linewidth=0.16) {%qp %qp_reset #M8:d};
//  &QN @WIRE(mode="straight", linecolor="#16817a", linewidth=0.16) {#M11:d %qn #M7:d};
//  &QN @WIRE(mode="straight", linecolor="#16817a", linewidth=0.16) {%qn %qn_reset #M9:d};
//  %feedback_qp = (8, 42);
//  $JUNCTION @ATTACH %feedback_qp => @SET-STYLE $p_wire;
//  %feedback_qn = (-8, 37);
//  $JUNCTION @ATTACH %feedback_qn => @SET-STYLE $n_wire;
//  &QP @WIRE(mode="straight", linecolor="#3f5597", linewidth=0.16) {%qp %feedback_qp};
//  &QP @WIRE(mode="straight", linecolor="#3f5597", linewidth=0.16) {#M11:g (8, 52) %feedback_qp (8, 30) #M7:g};
//  &QN @WIRE(mode="straight", linecolor="#16817a", linewidth=0.16) {%qn %feedback_qn};
//  &QN @WIRE(mode="straight", linecolor="#16817a", linewidth=0.16) {#M10:g (-8, 52) %feedback_qn (-8, 30) #M6:g};
//  %dp = (-18, -18);
//  $JUNCTION @ATTACH %dp => @SET-STYLE $dynamic_wire;
//  %dn = (18, -18);
//  $JUNCTION @ATTACH %dn => @SET-STYLE $dynamic_wire;
//  &DP @WIRE(mode="straight", linecolor="#286e97", linewidth=0.16) {#MRDP:d %dp #MINP:d};
//  &DN @WIRE(mode="straight", linecolor="#286e97", linewidth=0.16) {#MRDN:d %dn #MINN:d};
//  %dp_bottom = (-56, -18);
//  %dp_reset = (-56, 30);
//  $JUNCTION @ATTACH %dp_reset => @SET-STYLE $dynamic_wire;
//  %dp_internal_reset = (-56, 60);
//  $JUNCTION @ATTACH %dp_internal_reset => @SET-STYLE $dynamic_wire;
//  %dp_top = (-56, 72);
//  &DP @WIRE(mode="straight", linecolor="#286e97", linewidth=0.16) {%dp %dp_bottom %dp_reset %dp_internal_reset %dp_top #M14:g};
//  &DP @WIRE(mode="straight", linecolor="#286e97", linewidth=0.16) {%dp_internal_reset #M12:g};
//  &DP @WIRE(mode="straight", linecolor="#286e97", linewidth=0.16) {%dp_reset #M8:g};
//  (-54, 79) @TEXT("DP", size=0.95, bold=true, halign="middle", textcolor="#286e97");
//  %dn_bottom = (56, -18);
//  %dn_reset = (56, 30);
//  $JUNCTION @ATTACH %dn_reset => @SET-STYLE $dynamic_wire;
//  %dn_internal_reset = (56, 60);
//  $JUNCTION @ATTACH %dn_internal_reset => @SET-STYLE $dynamic_wire;
//  %dn_top = (56, 72);
//  &DN @WIRE(mode="straight", linecolor="#286e97", linewidth=0.16) {%dn %dn_bottom %dn_reset %dn_internal_reset %dn_top #M15:g};
//  &DN @WIRE(mode="straight", linecolor="#286e97", linewidth=0.16) {%dn_internal_reset #M13:g};
//  &DN @WIRE(mode="straight", linecolor="#286e97", linewidth=0.16) {%dn_reset #M9:g};
//  (54, 79) @TEXT("DN", size=0.95, bold=true, halign="middle", textcolor="#286e97");
//  %tail = (0, -38);
//  $JUNCTION @ATTACH %tail => @SET-STYLE $signal_wire;
//  &TAIL @WIRE(mode="straight", linecolor="#263442", linewidth=0.16) {#MINP:s (-18, -38) %tail (18, -38) #MINN:s};
//  &TAIL @WIRE(mode="straight", linecolor="#263442", linewidth=0.16) {%tail #MTAIL:d};
//  %port_INP = $IO_PORT @ATTACH &INP => @PLACE(-31, -30) => @ORIENT("R0");
//  %port_INP @TEXT("INP", key="name", size=1, bold=true);
//  %port_INN = $IO_PORT @ATTACH &INN => @PLACE(31, -30) => @ORIENT("MY");
//  %port_INN @TEXT("INN", key="name", size=1, bold=true);
//  &INP @WIRE(mode="straight", linecolor="#263442", linewidth=0.16) {%port_INP:p #MINP:g};
//  &INN @WIRE(mode="straight", linecolor="#263442", linewidth=0.16) {%port_INN:p #MINN:g};
//  %cke_input = (0, -8);
//  $JUNCTION @ATTACH %cke_input => @SET-STYLE $clock_wire;
//  &CKE @WIRE(mode="straight", linecolor="#ab6c15", linewidth=0.16) {#MRDP:g %cke_input #MRDN:g};
//  #MCKP @PLACE(-110, -17) => @ORIENT("R0");
//  #MCKP @TEXT("MCKP", key="name", size=1.15, bold=true, halign="start", textcolor="#273747") => @PLACE(-107.2, -15.8);
//  #MCKP @TEXT("4\mu{}m/30nm  nf4", key="dims", size=1, halign="start", textcolor="#526171") => @PLACE(-107.2, -18.5);
//  #MCKN @PLACE(-110, -31) => @ORIENT("R0");
//  #MCKN @TEXT("MCKN", key="name", size=1.15, bold=true, halign="start", textcolor="#273747") => @PLACE(-107.2, -29.8);
//  #MCKN @TEXT("2\mu{}m/30nm  nf2", key="dims", size=1, halign="start", textcolor="#526171") => @PLACE(-107.2, -32.5);
//  %clk1_in = (-116, -24);
//  $JUNCTION @ATTACH %clk1_in => @SET-STYLE $clock_wire;
//  %clk1_out = (-110, -24);
//  $JUNCTION @ATTACH %clk1_out => @SET-STYLE $clock_wire;
//  &CLKC @WIRE(mode="straight", linecolor="#ab6c15", linewidth=0.16) {#MCKP:g (-116, -17) %clk1_in (-116, -31) #MCKN:g};
//  &CKB @WIRE(mode="straight", linecolor="#ab6c15", linewidth=0.16) {#MCKP:d %clk1_out #MCKN:d};
//  #MCK2P @PLACE(-82, -17) => @ORIENT("R0");
//  #MCK2P @TEXT("MCK2P", key="name", size=1.15, bold=true, halign="start", textcolor="#273747") => @PLACE(-79.2, -15.8);
//  #MCK2P @TEXT("8\mu{}m/30nm  nf8", key="dims", size=1, halign="start", textcolor="#526171") => @PLACE(-79.2, -18.5);
//  #MCK2N @PLACE(-82, -31) => @ORIENT("R0");
//  #MCK2N @TEXT("MCK2N", key="name", size=1.15, bold=true, halign="start", textcolor="#273747") => @PLACE(-79.2, -29.8);
//  #MCK2N @TEXT("4\mu{}m/30nm  nf4", key="dims", size=1, halign="start", textcolor="#526171") => @PLACE(-79.2, -32.5);
//  %clk2_in = (-88, -24);
//  $JUNCTION @ATTACH %clk2_in => @SET-STYLE $clock_wire;
//  %clk2_out = (-82, -24);
//  $JUNCTION @ATTACH %clk2_out => @SET-STYLE $clock_wire;
//  &CKB @WIRE(mode="straight", linecolor="#ab6c15", linewidth=0.16) {#MCK2P:g (-88, -17) %clk2_in (-88, -31) #MCK2N:g};
//  &CKE @WIRE(mode="straight", linecolor="#ab6c15", linewidth=0.16) {#MCK2P:d %clk2_out #MCK2N:d};
//  %port_CLKC = $IO_PORT @ATTACH &CLKC => @PLACE(-128, -24) => @ORIENT("R0");
//  %port_CLKC @TEXT("CLKC", key="name", size=1, bold=true);
//  &CLKC @WIRE(mode="straight", linecolor="#ab6c15", linewidth=0.16) {%port_CLKC:p %clk1_in};
//  &CKB @WIRE(mode="straight", linecolor="#ab6c15", linewidth=0.16) {%clk1_out %clk2_in};
//  %clock_vdd_0 = (-110, -8);
//  $JUNCTION @ATTACH %clock_vdd_0 => @SET-STYLE $power_wire;
//  %clock_vdd_1 = (-96.0, -8);
//  $JUNCTION @ATTACH %clock_vdd_1 => @SET-STYLE $power_wire;
//  %clock_vdd_2 = (-82, -8);
//  $JUNCTION @ATTACH %clock_vdd_2 => @SET-STYLE $power_wire;
//  &AVDD @WIRE(mode="straight", linecolor="#697887", linewidth=0.11) {%clock_vdd_0 %clock_vdd_1 %clock_vdd_2};
//  %s_MCKP = (-110, -14);
//  $JUNCTION @ATTACH %s_MCKP => @SET-STYLE $power_wire;
//  &AVDD @WIRE(mode="straight", linecolor="#697887", linewidth=0.11) {#MCKP:s %s_MCKP};
//  &AVDD @WIRE(mode="straight", linecolor="#697887", linewidth=0.11) {#MCKP:b (-108, -17) (-108, -14) %s_MCKP};
//  &AVDD @WIRE(mode="straight", linecolor="#697887", linewidth=0.11) {%s_MCKP %clock_vdd_0};
//  %s_MCK2P = (-82, -14);
//  $JUNCTION @ATTACH %s_MCK2P => @SET-STYLE $power_wire;
//  &AVDD @WIRE(mode="straight", linecolor="#697887", linewidth=0.11) {#MCK2P:s %s_MCK2P};
//  &AVDD @WIRE(mode="straight", linecolor="#697887", linewidth=0.11) {#MCK2P:b (-80, -17) (-80, -14) %s_MCK2P};
//  &AVDD @WIRE(mode="straight", linecolor="#697887", linewidth=0.11) {%s_MCK2P %clock_vdd_2};
//  %clock_vdd_tag = $SUPPLY @ATTACH &AVDD => @PLACE(-96.0, -5.5);
//  %clock_vdd_tag => @SET-STYLE $power_wire;
//  &AVDD @WIRE(mode="straight", linecolor="#697887", linewidth=0.11) {%clock_vdd_1 %clock_vdd_tag:p};
//  %clock_vss_0 = (-110, -40);
//  $JUNCTION @ATTACH %clock_vss_0 => @SET-STYLE $power_wire;
//  %clock_vss_1 = (-96.0, -40);
//  $JUNCTION @ATTACH %clock_vss_1 => @SET-STYLE $power_wire;
//  %clock_vss_2 = (-82, -40);
//  $JUNCTION @ATTACH %clock_vss_2 => @SET-STYLE $power_wire;
//  &VSS @WIRE(mode="straight", linecolor="#697887", linewidth=0.11) {%clock_vss_0 %clock_vss_1 %clock_vss_2};
//  %s_MCKN = (-110, -34);
//  $JUNCTION @ATTACH %s_MCKN => @SET-STYLE $power_wire;
//  &VSS @WIRE(mode="straight", linecolor="#697887", linewidth=0.11) {#MCKN:s %s_MCKN};
//  &VSS @WIRE(mode="straight", linecolor="#697887", linewidth=0.11) {#MCKN:b (-108, -31) (-108, -34) %s_MCKN};
//  &VSS @WIRE(mode="straight", linecolor="#697887", linewidth=0.11) {%s_MCKN %clock_vss_0};
//  %s_MCK2N = (-82, -34);
//  $JUNCTION @ATTACH %s_MCK2N => @SET-STYLE $power_wire;
//  &VSS @WIRE(mode="straight", linecolor="#697887", linewidth=0.11) {#MCK2N:s %s_MCK2N};
//  &VSS @WIRE(mode="straight", linecolor="#697887", linewidth=0.11) {#MCK2N:b (-80, -31) (-80, -34) %s_MCK2N};
//  &VSS @WIRE(mode="straight", linecolor="#697887", linewidth=0.11) {%s_MCK2N %clock_vss_2};
//  %clock_vss_tag = $GROUND @ATTACH &VSS => @PLACE(-96.0, -41.5);
//  %clock_vss_tag => @SET-STYLE $power_wire;
//  &VSS @WIRE(mode="straight", linecolor="#697887", linewidth=0.11) {%clock_vss_1 %clock_vss_tag:p};
//  {#MCKP #MCKN #MCK2P #MCK2N} @GROUP;
//  (-96.0, 0) @TEXT("Clock buffer", size=1.35, bold=true, halign="middle", textcolor="#273747");
//  (-96.0, -25) @TEXT("CKB", size=0.8, bold=false, halign="middle", textcolor="#ab6c15");
//  (-74, -22.4) @TEXT("CKE", size=0.8, bold=false, halign="middle", textcolor="#ab6c15");
//  %cke_spine = (-66, -24);
//  $JUNCTION @ATTACH %cke_spine => @SET-STYLE $clock_wire;
//  &CKE @WIRE(mode="straight", linecolor="#ab6c15", linewidth=0.16) {%clk2_out %cke_spine (-66, -4) (0, -4) %cke_input};
//  &CKE @WIRE(mode="straight", linecolor="#ab6c15", linewidth=0.16) {%cke_spine (-66, -54) (-6, -54) (-6, -50) #MTAIL:g};
//  #MBPP @PLACE(-84, 49) => @ORIENT("MY");
//  #MBPP @TEXT("MBPP", key="name", size=1.15, bold=true, halign="end", textcolor="#273747") => @PLACE(-86.8, 50.2);
//  #MBPP @TEXT("2\mu{}m/30nm  nf2", key="dims", size=1, halign="end", textcolor="#526171") => @PLACE(-86.8, 47.5);
//  #MBPN @PLACE(-84, 35) => @ORIENT("MY");
//  #MBPN @TEXT("MBPN", key="name", size=1.15, bold=true, halign="end", textcolor="#273747") => @PLACE(-86.8, 36.2);
//  #MBPN @TEXT("1\mu{}m/30nm  nf2", key="dims", size=1, halign="end", textcolor="#526171") => @PLACE(-86.8, 33.5);
//  %outp_buf1_in = (-78, 42);
//  $JUNCTION @ATTACH %outp_buf1_in => @SET-STYLE $p_wire;
//  %outp_buf1_out = (-84, 42);
//  $JUNCTION @ATTACH %outp_buf1_out => @SET-STYLE $p_wire;
//  &QP @WIRE(mode="straight", linecolor="#3f5597", linewidth=0.16) {#MBPP:g (-78, 49) %outp_buf1_in (-78, 35) #MBPN:g};
//  &BP @WIRE(mode="straight", linecolor="#3f5597", linewidth=0.16) {#MBPP:d %outp_buf1_out #MBPN:d};
//  #MOPP @PLACE(-110, 49) => @ORIENT("MY");
//  #MOPP @TEXT("MOPP", key="name", size=1.15, bold=true, halign="end", textcolor="#273747") => @PLACE(-112.8, 50.2);
//  #MOPP @TEXT("4\mu{}m/30nm  nf4", key="dims", size=1, halign="end", textcolor="#526171") => @PLACE(-112.8, 47.5);
//  #MOPN @PLACE(-110, 35) => @ORIENT("MY");
//  #MOPN @TEXT("MOPN", key="name", size=1.15, bold=true, halign="end", textcolor="#273747") => @PLACE(-112.8, 36.2);
//  #MOPN @TEXT("2\mu{}m/30nm  nf2", key="dims", size=1, halign="end", textcolor="#526171") => @PLACE(-112.8, 33.5);
//  %outp_buf2_in = (-104, 42);
//  $JUNCTION @ATTACH %outp_buf2_in => @SET-STYLE $p_wire;
//  %outp_buf2_out = (-110, 42);
//  $JUNCTION @ATTACH %outp_buf2_out => @SET-STYLE $p_wire;
//  &BP @WIRE(mode="straight", linecolor="#3f5597", linewidth=0.16) {#MOPP:g (-104, 49) %outp_buf2_in (-104, 35) #MOPN:g};
//  &OUTP @WIRE(mode="straight", linecolor="#3f5597", linewidth=0.16) {#MOPP:d %outp_buf2_out #MOPN:d};
//  &QP @WIRE(mode="straight", linecolor="#3f5597", linewidth=0.16) {%qp_reset %outp_buf1_in};
//  &BP @WIRE(mode="straight", linecolor="#3f5597", linewidth=0.16) {%outp_buf1_out %outp_buf2_in};
//  %port_OUTP = $IO_PORT @ATTACH &OUTP => @PLACE(-130, 42) => @ORIENT("R0");
//  %port_OUTP @TEXT("OUTP", key="name", size=1, bold=true);
//  &OUTP @WIRE(mode="straight", linecolor="#3f5597", linewidth=0.16) {%outp_buf2_out %port_OUTP:p};
//  %outp_vdd_0 = (-110, 58);
//  $JUNCTION @ATTACH %outp_vdd_0 => @SET-STYLE $power_wire;
//  %outp_vdd_1 = (-97.0, 58);
//  $JUNCTION @ATTACH %outp_vdd_1 => @SET-STYLE $power_wire;
//  %outp_vdd_2 = (-84, 58);
//  $JUNCTION @ATTACH %outp_vdd_2 => @SET-STYLE $power_wire;
//  &AVDD @WIRE(mode="straight", linecolor="#697887", linewidth=0.11) {%outp_vdd_0 %outp_vdd_1 %outp_vdd_2};
//  %s_MBPP = (-84, 52);
//  $JUNCTION @ATTACH %s_MBPP => @SET-STYLE $power_wire;
//  &AVDD @WIRE(mode="straight", linecolor="#697887", linewidth=0.11) {#MBPP:s %s_MBPP};
//  &AVDD @WIRE(mode="straight", linecolor="#697887", linewidth=0.11) {#MBPP:b (-86, 49) (-86, 52) %s_MBPP};
//  &AVDD @WIRE(mode="straight", linecolor="#697887", linewidth=0.11) {%s_MBPP %outp_vdd_2};
//  %s_MOPP = (-110, 52);
//  $JUNCTION @ATTACH %s_MOPP => @SET-STYLE $power_wire;
//  &AVDD @WIRE(mode="straight", linecolor="#697887", linewidth=0.11) {#MOPP:s %s_MOPP};
//  &AVDD @WIRE(mode="straight", linecolor="#697887", linewidth=0.11) {#MOPP:b (-112, 49) (-112, 52) %s_MOPP};
//  &AVDD @WIRE(mode="straight", linecolor="#697887", linewidth=0.11) {%s_MOPP %outp_vdd_0};
//  %outp_vdd_tag = $SUPPLY @ATTACH &AVDD => @PLACE(-97.0, 60.5);
//  %outp_vdd_tag => @SET-STYLE $power_wire;
//  &AVDD @WIRE(mode="straight", linecolor="#697887", linewidth=0.11) {%outp_vdd_1 %outp_vdd_tag:p};
//  %outp_vss_0 = (-110, 26);
//  $JUNCTION @ATTACH %outp_vss_0 => @SET-STYLE $power_wire;
//  %outp_vss_1 = (-97.0, 26);
//  $JUNCTION @ATTACH %outp_vss_1 => @SET-STYLE $power_wire;
//  %outp_vss_2 = (-84, 26);
//  $JUNCTION @ATTACH %outp_vss_2 => @SET-STYLE $power_wire;
//  &VSS @WIRE(mode="straight", linecolor="#697887", linewidth=0.11) {%outp_vss_0 %outp_vss_1 %outp_vss_2};
//  %s_MBPN = (-84, 32);
//  $JUNCTION @ATTACH %s_MBPN => @SET-STYLE $power_wire;
//  &VSS @WIRE(mode="straight", linecolor="#697887", linewidth=0.11) {#MBPN:s %s_MBPN};
//  &VSS @WIRE(mode="straight", linecolor="#697887", linewidth=0.11) {#MBPN:b (-86, 35) (-86, 32) %s_MBPN};
//  &VSS @WIRE(mode="straight", linecolor="#697887", linewidth=0.11) {%s_MBPN %outp_vss_2};
//  %s_MOPN = (-110, 32);
//  $JUNCTION @ATTACH %s_MOPN => @SET-STYLE $power_wire;
//  &VSS @WIRE(mode="straight", linecolor="#697887", linewidth=0.11) {#MOPN:s %s_MOPN};
//  &VSS @WIRE(mode="straight", linecolor="#697887", linewidth=0.11) {#MOPN:b (-112, 35) (-112, 32) %s_MOPN};
//  &VSS @WIRE(mode="straight", linecolor="#697887", linewidth=0.11) {%s_MOPN %outp_vss_0};
//  %outp_vss_tag = $GROUND @ATTACH &VSS => @PLACE(-97.0, 24.5);
//  %outp_vss_tag => @SET-STYLE $power_wire;
//  &VSS @WIRE(mode="straight", linecolor="#697887", linewidth=0.11) {%outp_vss_1 %outp_vss_tag:p};
//  {#MBPP #MBPN #MOPP #MOPN} @GROUP;
//  #MBNP @PLACE(84, 49) => @ORIENT("R0");
//  #MBNP @TEXT("MBNP", key="name", size=1.15, bold=true, halign="start", textcolor="#273747") => @PLACE(86.8, 50.2);
//  #MBNP @TEXT("2\mu{}m/30nm  nf2", key="dims", size=1, halign="start", textcolor="#526171") => @PLACE(86.8, 47.5);
//  #MBNN @PLACE(84, 35) => @ORIENT("R0");
//  #MBNN @TEXT("MBNN", key="name", size=1.15, bold=true, halign="start", textcolor="#273747") => @PLACE(86.8, 36.2);
//  #MBNN @TEXT("1\mu{}m/30nm  nf2", key="dims", size=1, halign="start", textcolor="#526171") => @PLACE(86.8, 33.5);
//  %outn_buf1_in = (78, 42);
//  $JUNCTION @ATTACH %outn_buf1_in => @SET-STYLE $n_wire;
//  %outn_buf1_out = (84, 42);
//  $JUNCTION @ATTACH %outn_buf1_out => @SET-STYLE $n_wire;
//  &QN @WIRE(mode="straight", linecolor="#16817a", linewidth=0.16) {#MBNP:g (78, 49) %outn_buf1_in (78, 35) #MBNN:g};
//  &BN @WIRE(mode="straight", linecolor="#16817a", linewidth=0.16) {#MBNP:d %outn_buf1_out #MBNN:d};
//  #MONP @PLACE(110, 49) => @ORIENT("R0");
//  #MONP @TEXT("MONP", key="name", size=1.15, bold=true, halign="start", textcolor="#273747") => @PLACE(112.8, 50.2);
//  #MONP @TEXT("4\mu{}m/30nm  nf4", key="dims", size=1, halign="start", textcolor="#526171") => @PLACE(112.8, 47.5);
//  #MONN @PLACE(110, 35) => @ORIENT("R0");
//  #MONN @TEXT("MONN", key="name", size=1.15, bold=true, halign="start", textcolor="#273747") => @PLACE(112.8, 36.2);
//  #MONN @TEXT("2\mu{}m/30nm  nf2", key="dims", size=1, halign="start", textcolor="#526171") => @PLACE(112.8, 33.5);
//  %outn_buf2_in = (104, 42);
//  $JUNCTION @ATTACH %outn_buf2_in => @SET-STYLE $n_wire;
//  %outn_buf2_out = (110, 42);
//  $JUNCTION @ATTACH %outn_buf2_out => @SET-STYLE $n_wire;
//  &BN @WIRE(mode="straight", linecolor="#16817a", linewidth=0.16) {#MONP:g (104, 49) %outn_buf2_in (104, 35) #MONN:g};
//  &OUTN @WIRE(mode="straight", linecolor="#16817a", linewidth=0.16) {#MONP:d %outn_buf2_out #MONN:d};
//  &QN @WIRE(mode="straight", linecolor="#16817a", linewidth=0.16) {%qn_reset (68, 37) (68, 42) %outn_buf1_in};
//  &BN @WIRE(mode="straight", linecolor="#16817a", linewidth=0.16) {%outn_buf1_out %outn_buf2_in};
//  %port_OUTN = $IO_PORT @ATTACH &OUTN => @PLACE(130, 42) => @ORIENT("MY");
//  %port_OUTN @TEXT("OUTN", key="name", size=1, bold=true);
//  &OUTN @WIRE(mode="straight", linecolor="#16817a", linewidth=0.16) {%outn_buf2_out %port_OUTN:p};
//  %outn_vdd_0 = (84, 58);
//  $JUNCTION @ATTACH %outn_vdd_0 => @SET-STYLE $power_wire;
//  %outn_vdd_1 = (97.0, 58);
//  $JUNCTION @ATTACH %outn_vdd_1 => @SET-STYLE $power_wire;
//  %outn_vdd_2 = (110, 58);
//  $JUNCTION @ATTACH %outn_vdd_2 => @SET-STYLE $power_wire;
//  &AVDD @WIRE(mode="straight", linecolor="#697887", linewidth=0.11) {%outn_vdd_0 %outn_vdd_1 %outn_vdd_2};
//  %s_MBNP = (84, 52);
//  $JUNCTION @ATTACH %s_MBNP => @SET-STYLE $power_wire;
//  &AVDD @WIRE(mode="straight", linecolor="#697887", linewidth=0.11) {#MBNP:s %s_MBNP};
//  &AVDD @WIRE(mode="straight", linecolor="#697887", linewidth=0.11) {#MBNP:b (86, 49) (86, 52) %s_MBNP};
//  &AVDD @WIRE(mode="straight", linecolor="#697887", linewidth=0.11) {%s_MBNP %outn_vdd_0};
//  %s_MONP = (110, 52);
//  $JUNCTION @ATTACH %s_MONP => @SET-STYLE $power_wire;
//  &AVDD @WIRE(mode="straight", linecolor="#697887", linewidth=0.11) {#MONP:s %s_MONP};
//  &AVDD @WIRE(mode="straight", linecolor="#697887", linewidth=0.11) {#MONP:b (112, 49) (112, 52) %s_MONP};
//  &AVDD @WIRE(mode="straight", linecolor="#697887", linewidth=0.11) {%s_MONP %outn_vdd_2};
//  %outn_vdd_tag = $SUPPLY @ATTACH &AVDD => @PLACE(97.0, 60.5);
//  %outn_vdd_tag => @SET-STYLE $power_wire;
//  &AVDD @WIRE(mode="straight", linecolor="#697887", linewidth=0.11) {%outn_vdd_1 %outn_vdd_tag:p};
//  %outn_vss_0 = (84, 26);
//  $JUNCTION @ATTACH %outn_vss_0 => @SET-STYLE $power_wire;
//  %outn_vss_1 = (97.0, 26);
//  $JUNCTION @ATTACH %outn_vss_1 => @SET-STYLE $power_wire;
//  %outn_vss_2 = (110, 26);
//  $JUNCTION @ATTACH %outn_vss_2 => @SET-STYLE $power_wire;
//  &VSS @WIRE(mode="straight", linecolor="#697887", linewidth=0.11) {%outn_vss_0 %outn_vss_1 %outn_vss_2};
//  %s_MBNN = (84, 32);
//  $JUNCTION @ATTACH %s_MBNN => @SET-STYLE $power_wire;
//  &VSS @WIRE(mode="straight", linecolor="#697887", linewidth=0.11) {#MBNN:s %s_MBNN};
//  &VSS @WIRE(mode="straight", linecolor="#697887", linewidth=0.11) {#MBNN:b (86, 35) (86, 32) %s_MBNN};
//  &VSS @WIRE(mode="straight", linecolor="#697887", linewidth=0.11) {%s_MBNN %outn_vss_0};
//  %s_MONN = (110, 32);
//  $JUNCTION @ATTACH %s_MONN => @SET-STYLE $power_wire;
//  &VSS @WIRE(mode="straight", linecolor="#697887", linewidth=0.11) {#MONN:s %s_MONN};
//  &VSS @WIRE(mode="straight", linecolor="#697887", linewidth=0.11) {#MONN:b (112, 35) (112, 32) %s_MONN};
//  &VSS @WIRE(mode="straight", linecolor="#697887", linewidth=0.11) {%s_MONN %outn_vss_2};
//  %outn_vss_tag = $GROUND @ATTACH &VSS => @PLACE(97.0, 24.5);
//  %outn_vss_tag => @SET-STYLE $power_wire;
//  &VSS @WIRE(mode="straight", linecolor="#697887", linewidth=0.11) {%outn_vss_1 %outn_vss_tag:p};
//  {#MBNP #MBNN #MONP #MONN} @GROUP;
//  (-23, 65.5) @TEXT("XP", size=0.85, bold=true, halign="middle", textcolor="#286e97");
//  (23, 65.5) @TEXT("XN", size=0.85, bold=true, halign="middle", textcolor="#286e97");
//  (-27, 44) @TEXT("QP", size=0.9, bold=true, halign="middle", textcolor="#3f5597");
//  (27, 39) @TEXT("QN", size=0.9, bold=true, halign="middle", textcolor="#16817a");
//  (4, -41) @TEXT("TAIL", size=0.8, bold=false, halign="start", textcolor="#526171");
//  (0, -70) @TEXT("Dots mark connections. Crossings without dots are separate nets.", size=0.85, bold=false, halign="middle", textcolor="#526171");
//  %input_pair = #MINP(in_p) #MINN(in_n) #MTAIL(tail) @AS $DIFFERENTIAL_PAIR;
//  %core_axis = (0, 0);
//  {#MINP #MINN} @AS $MATCHED;
//  #MINP(a) #MINN(b) %core_axis(axis) @AS $MIRRORED;
//  {#MRDP #MRDN} @AS $MATCHED;
//  #MRDP(a) #MRDN(b) %core_axis(axis) @AS $MIRRORED;
//  {#M14 #M15} @AS $MATCHED;
//  #M14(a) #M15(b) %core_axis(axis) @AS $MIRRORED;
//  {#M12 #M13} @AS $MATCHED;
//  #M12(a) #M13(b) %core_axis(axis) @AS $MIRRORED;
//  {#M10 #M11} @AS $MATCHED;
//  #M10(a) #M11(b) %core_axis(axis) @AS $MIRRORED;
//  {#M6 #M7} @AS $MATCHED;
//  #M6(a) #M7(b) %core_axis(axis) @AS $MIRRORED;
//  {#M8 #M9} @AS $MATCHED;
//  #M8(a) #M9(b) %core_axis(axis) @AS $MIRRORED;
//  {#MINP #MINN #MTAIL #MRDP #MRDN} @GROUP;
//  {#M14 #M15 #M12 #M13 #M10 #M11 #M6 #M7 #M8 #M9} @GROUP;
// }
ends adc_comp
