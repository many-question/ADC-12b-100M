// Canonical many-question-miyahara promoted from BUFFER-V12; electrical source is unchanged.
// @RNL(type="header") {
//   @VERSION("0.3");
//   @USE-PACKAGE(name="adc28", version="0.1", path="../../../rnl/adc28.rnl")
// }
simulator lang=spectre
subckt adc_comp (INP INN CLKC OUTP OUTN AVDD VSS)
// Geometry and terminal parasitics are from successful device callbacks.
// INP > INN asserts OUTP. CLKC low resets both external outputs to zero.
MINP (DP INP TAIL VSS) nch_ulvt_mac l=3e-08 w=5.6e-05 nf=56 m=1 ad=2.8e-12 as=2.85e-12 pd=6.16e-05 ps=6.37e-05 nrd=0.009138 nrs=0.009138 sa=1.36619e-06 sb=1.36619e-06 sd=1e-07
MINN (DN INN TAIL VSS) nch_ulvt_mac l=3e-08 w=5.6e-05 nf=56 m=1 ad=2.8e-12 as=2.85e-12 pd=6.16e-05 ps=6.37e-05 nrd=0.009138 nrs=0.009138 sa=1.36619e-06 sb=1.36619e-06 sd=1e-07
MTAIL (TAIL CLKC VSS VSS) nch_ulvt_mac l=3e-08 w=3e-06 nf=3 m=1 ad=1.75e-13 as=1.75e-13 pd=4.35e-06 ps=4.35e-06 nrd=0.136842 nrs=0.136842 sa=1.47042e-07 sb=1.47042e-07 sd=1e-07
M14 (XP DP AVDD AVDD) pch_ulvt_mac l=3e-08 w=4e-06 nf=4 m=1 ad=2e-13 as=2.5e-13 pd=4.4e-06 ps=6.5e-06 nrd=0.048530 nrs=0.048530 sa=1.79203e-07 sb=1.79203e-07 sd=1e-07
M15 (XN DN AVDD AVDD) pch_ulvt_mac l=3e-08 w=4e-06 nf=4 m=1 ad=2e-13 as=2.5e-13 pd=4.4e-06 ps=6.5e-06 nrd=0.048530 nrs=0.048530 sa=1.79203e-07 sb=1.79203e-07 sd=1e-07
M12 (XP DP VSS VSS) nch_ulvt_mac l=3e-08 w=1e-06 nf=2 m=1 ad=5e-14 as=7.5e-14 pd=1.2e-06 ps=2.3e-06 nrd=0.425847 nrs=0.425847 sa=1.12742e-07 sb=1.12742e-07 sd=1e-07
M13 (XN DN VSS VSS) nch_ulvt_mac l=3e-08 w=1e-06 nf=2 m=1 ad=5e-14 as=7.5e-14 pd=1.2e-06 ps=2.3e-06 nrd=0.425847 nrs=0.425847 sa=1.12742e-07 sb=1.12742e-07 sd=1e-07
M10 (RP RN XP AVDD) pch_ulvt_mac l=3e-08 w=4e-06 nf=4 m=1 ad=2e-13 as=2.5e-13 pd=4.4e-06 ps=6.5e-06 nrd=0.048530 nrs=0.048530 sa=1.79203e-07 sb=1.79203e-07 sd=1e-07
M11 (RN RP XN AVDD) pch_ulvt_mac l=3e-08 w=4e-06 nf=4 m=1 ad=2e-13 as=2.5e-13 pd=4.4e-06 ps=6.5e-06 nrd=0.048530 nrs=0.048530 sa=1.79203e-07 sb=1.79203e-07 sd=1e-07
M6 (RP RN VSS VSS) nch_ulvt_mac l=3e-08 w=2e-06 nf=2 m=1 ad=1e-13 as=1.5e-13 pd=2.2e-06 ps=4.3e-06 nrd=0.185844 nrs=0.185844 sa=1.12742e-07 sb=1.12742e-07 sd=1e-07
M7 (RN RP VSS VSS) nch_ulvt_mac l=3e-08 w=2e-06 nf=2 m=1 ad=1e-13 as=1.5e-13 pd=2.2e-06 ps=4.3e-06 nrd=0.185844 nrs=0.185844 sa=1.12742e-07 sb=1.12742e-07 sd=1e-07
M8 (RP DP VSS VSS) nch_ulvt_mac l=3e-08 w=2e-06 nf=2 m=1 ad=1e-13 as=1.5e-13 pd=2.2e-06 ps=4.3e-06 nrd=0.185844 nrs=0.185844 sa=1.12742e-07 sb=1.12742e-07 sd=1e-07
M9 (RN DN VSS VSS) nch_ulvt_mac l=3e-08 w=2e-06 nf=2 m=1 ad=1e-13 as=1.5e-13 pd=2.2e-06 ps=4.3e-06 nrd=0.185844 nrs=0.185844 sa=1.12742e-07 sb=1.12742e-07 sd=1e-07
CDP (DP VSS) cfmom_2t nr=48 lr=1e-06 w=5e-08 s=5e-08 stm=1 spm=3 multi=1
CDN (DN VSS) cfmom_2t nr=48 lr=1e-06 w=5e-08 s=5e-08 stm=1 spm=3 multi=1
MCKN (CKB CLKC VSS VSS) nch_ulvt_mac l=3e-08 w=1e-06 nf=1 m=1 ad=7.5e-14 as=7.5e-14 pd=2.15e-06 ps=2.15e-06 nrd=0.289519 nrs=0.289519 sa=7.5e-08 sb=7.5e-08 sd=1e-07
MCKP (CKB CLKC AVDD AVDD) pch_ulvt_mac l=3e-08 w=3e-06 nf=3 m=1 ad=1.75e-13 as=1.75e-13 pd=4.35e-06 ps=4.35e-06 nrd=0.063502 nrs=0.063502 sa=1.47042e-07 sb=1.47042e-07 sd=1e-07
MRQP (RP CKB VSS VSS) nch_ulvt_mac l=3e-08 w=4e-06 nf=4 m=1 ad=2e-13 as=2.5e-13 pd=4.4e-06 ps=6.5e-06 nrd=0.108289 nrs=0.108289 sa=1.79203e-07 sb=1.79203e-07 sd=1e-07
MRQN (RN CKB VSS VSS) nch_ulvt_mac l=3e-08 w=4e-06 nf=4 m=1 ad=2e-13 as=2.5e-13 pd=4.4e-06 ps=6.5e-06 nrd=0.108289 nrs=0.108289 sa=1.79203e-07 sb=1.79203e-07 sd=1e-07
MAP (DP CLKC AVDD AVDD) pch_ulvt_mac l=3e-08 w=2.4e-06 nf=3 m=1 ad=1.4e-13 as=1.4e-13 pd=3.55e-06 ps=3.55e-06 nrd=0.082117 nrs=0.082117 sa=1.47042e-07 sb=1.47042e-07 sd=1e-07
MAN (DN CLKC AVDD AVDD) pch_ulvt_mac l=3e-08 w=2.4e-06 nf=3 m=1 ad=1.4e-13 as=1.4e-13 pd=3.55e-06 ps=3.55e-06 nrd=0.082117 nrs=0.082117 sa=1.47042e-07 sb=1.47042e-07 sd=1e-07
CCB (CKB VSS) cfmom_2t nr=48 lr=1e-06 w=5e-08 s=5e-08 stm=1 spm=3 multi=1
MBPP (BP RP AVDD AVDD) pch_ulvt_mac l=3e-08 w=6e-06 nf=6 m=1 ad=3e-13 as=3.5e-13 pd=6.6e-06 ps=8.7e-06 nrd=0.032979 nrs=0.032979 sa=2.39369e-07 sb=2.39369e-07 sd=1e-07
MBPN (BP RP VSS VSS) nch_ulvt_mac l=3e-08 w=2e-06 nf=2 m=1 ad=1e-13 as=1.5e-13 pd=2.2e-06 ps=4.3e-06 nrd=0.185844 nrs=0.185844 sa=1.12742e-07 sb=1.12742e-07 sd=1e-07
MOPP (OUTP BP AVDD AVDD) pch_ulvt_mac l=3e-08 w=4e-06 nf=4 m=1 ad=2e-13 as=2.5e-13 pd=4.4e-06 ps=6.5e-06 nrd=0.048530 nrs=0.048530 sa=1.79203e-07 sb=1.79203e-07 sd=1e-07
MOPN (OUTP BP VSS VSS) nch_ulvt_mac l=3e-08 w=3e-06 nf=3 m=1 ad=1.75e-13 as=1.75e-13 pd=4.35e-06 ps=4.35e-06 nrd=0.136842 nrs=0.136842 sa=1.47042e-07 sb=1.47042e-07 sd=1e-07
MBNP (BN RN AVDD AVDD) pch_ulvt_mac l=3e-08 w=6e-06 nf=6 m=1 ad=3e-13 as=3.5e-13 pd=6.6e-06 ps=8.7e-06 nrd=0.032979 nrs=0.032979 sa=2.39369e-07 sb=2.39369e-07 sd=1e-07
MBNN (BN RN VSS VSS) nch_ulvt_mac l=3e-08 w=2e-06 nf=2 m=1 ad=1e-13 as=1.5e-13 pd=2.2e-06 ps=4.3e-06 nrd=0.185844 nrs=0.185844 sa=1.12742e-07 sb=1.12742e-07 sd=1e-07
MONP (OUTN BN AVDD AVDD) pch_ulvt_mac l=3e-08 w=4e-06 nf=4 m=1 ad=2e-13 as=2.5e-13 pd=4.4e-06 ps=6.5e-06 nrd=0.048530 nrs=0.048530 sa=1.79203e-07 sb=1.79203e-07 sd=1e-07
MONN (OUTN BN VSS VSS) nch_ulvt_mac l=3e-08 w=3e-06 nf=3 m=1 ad=1.75e-13 as=1.75e-13 pd=4.35e-06 ps=4.35e-06 nrd=0.136842 nrs=0.136842 sa=1.47042e-07 sb=1.47042e-07 sd=1e-07
MDDP (DP DP VSS VSS) nch_ulvt_mac l=5e-07 w=5e-07 nf=1 m=1 ad=4.75e-14 as=4.75e-14 pd=1.19e-06 ps=1.19e-06 nrd=0.645705 nrs=0.645705 sa=9.5e-08 sb=9.5e-08 sd=1.2e-07
MDDN (DN DN VSS VSS) nch_ulvt_mac l=5e-07 w=5e-07 nf=1 m=1 ad=4.75e-14 as=4.75e-14 pd=1.19e-06 ps=1.19e-06 nrd=0.645705 nrs=0.645705 sa=9.5e-08 sb=9.5e-08 sd=1.2e-07
CXP (XP VSS) cfmom_2t nr=16 lr=1e-06 w=5e-08 s=5e-08 stm=1 spm=3 multi=1
CXN (XN VSS) cfmom_2t nr=16 lr=1e-06 w=5e-08 s=5e-08 stm=1 spm=3 multi=1
CRP (RP VSS) cfmom_2t nr=8 lr=1e-06 w=5e-08 s=5e-08 stm=1 spm=3 multi=1
CRN (RN VSS) cfmom_2t nr=8 lr=1e-06 w=5e-08 s=5e-08 stm=1 spm=3 multi=1
CBP (BP VSS) cfmom_2t nr=16 lr=1e-06 w=5e-08 s=5e-08 stm=1 spm=3 multi=1
CBN (BN VSS) cfmom_2t nr=16 lr=1e-06 w=5e-08 s=5e-08 stm=1 spm=3 multi=1
MUPRP1 (RP VSS AVDD AVDD) pch_ulvt_mac l=1e-07 w=5e-07 nf=1 m=1 ad=4.75e-14 as=4.75e-14 pd=1.19e-06 ps=1.19e-06 nrd=0.256086 nrs=0.256086 sa=9.5e-08 sb=9.5e-08 sd=1.2e-07
MUPRN1 (RN VSS AVDD AVDD) pch_ulvt_mac l=1e-07 w=5e-07 nf=1 m=1 ad=4.75e-14 as=4.75e-14 pd=1.19e-06 ps=1.19e-06 nrd=0.256086 nrs=0.256086 sa=9.5e-08 sb=9.5e-08 sd=1.2e-07
MUPBP1 (BP VSS AVDD AVDD) pch_ulvt_mac l=1e-07 w=5e-07 nf=1 m=1 ad=4.75e-14 as=4.75e-14 pd=1.19e-06 ps=1.19e-06 nrd=0.256086 nrs=0.256086 sa=9.5e-08 sb=9.5e-08 sd=1.2e-07
MUPBN1 (BN VSS AVDD AVDD) pch_ulvt_mac l=1e-07 w=5e-07 nf=1 m=1 ad=4.75e-14 as=4.75e-14 pd=1.19e-06 ps=1.19e-06 nrd=0.256086 nrs=0.256086 sa=9.5e-08 sb=9.5e-08 sd=1.2e-07
MUPOUTP1 (OUTP VSS AVDD AVDD) pch_ulvt_mac l=1e-07 w=5e-07 nf=1 m=1 ad=4.75e-14 as=4.75e-14 pd=1.19e-06 ps=1.19e-06 nrd=0.256086 nrs=0.256086 sa=9.5e-08 sb=9.5e-08 sd=1.2e-07
MUPOUTN1 (OUTN VSS AVDD AVDD) pch_ulvt_mac l=1e-07 w=5e-07 nf=1 m=1 ad=4.75e-14 as=4.75e-14 pd=1.19e-06 ps=1.19e-06 nrd=0.256086 nrs=0.256086 sa=9.5e-08 sb=9.5e-08 sd=1.2e-07
MDNOUTP1 (OUTP OUTP VSS VSS) nch_ulvt_mac l=5e-07 w=5e-07 nf=1 m=1 ad=4.75e-14 as=4.75e-14 pd=1.19e-06 ps=1.19e-06 nrd=0.645705 nrs=0.645705 sa=9.5e-08 sb=9.5e-08 sd=1.2e-07
MDNOUTP2 (OUTP OUTP VSS VSS) nch_ulvt_mac l=5e-07 w=5e-07 nf=1 m=1 ad=4.75e-14 as=4.75e-14 pd=1.19e-06 ps=1.19e-06 nrd=0.645705 nrs=0.645705 sa=9.5e-08 sb=9.5e-08 sd=1.2e-07
MDNOUTN1 (OUTN OUTN VSS VSS) nch_ulvt_mac l=5e-07 w=5e-07 nf=1 m=1 ad=4.75e-14 as=4.75e-14 pd=1.19e-06 ps=1.19e-06 nrd=0.645705 nrs=0.645705 sa=9.5e-08 sb=9.5e-08 sd=1.2e-07
MDNOUTN2 (OUTN OUTN VSS VSS) nch_ulvt_mac l=5e-07 w=5e-07 nf=1 m=1 ad=4.75e-14 as=4.75e-14 pd=1.19e-06 ps=1.19e-06 nrd=0.645705 nrs=0.645705 sa=9.5e-08 sb=9.5e-08 sd=1.2e-07
MCKUP (CKB VSS AVDD AVDD) pch_ulvt_mac l=1e-07 w=5e-07 nf=1 m=1 ad=4.75e-14 as=4.75e-14 pd=1.19e-06 ps=1.19e-06 nrd=0.256086 nrs=0.256086 sa=9.5e-08 sb=9.5e-08 sd=1.2e-07
MBLEED (CKB AVDD VSS VSS) nch_ulvt_mac l=5e-07 w=5e-07 nf=1 m=1 ad=4.75e-14 as=4.75e-14 pd=1.19e-06 ps=1.19e-06 nrd=0.645705 nrs=0.645705 sa=9.5e-08 sb=9.5e-08 sd=1.2e-07
MUPXP (XP VSS AVDD AVDD) pch_ulvt_mac l=1e-07 w=5e-07 nf=1 m=1 ad=4.75e-14 as=4.75e-14 pd=1.19e-06 ps=1.19e-06 nrd=0.256086 nrs=0.256086 sa=9.5e-08 sb=9.5e-08 sd=1.2e-07
MUPXN (XN VSS AVDD AVDD) pch_ulvt_mac l=1e-07 w=5e-07 nf=1 m=1 ad=4.75e-14 as=4.75e-14 pd=1.19e-06 ps=1.19e-06 nrd=0.256086 nrs=0.256086 sa=9.5e-08 sb=9.5e-08 sd=1.2e-07
// @RNL(author="schematic-review") {
//  &VSS @ADD-TO $GROUND_NET_SET;
//  &AVDD @ADD-TO $SUPPLY_NET_SET;
//  # @SELECT-INSTANCE => @TEXT("", key="model");
//  # @SELECT-INSTANCE => @TEXT("", key="name");
//  $clock_wire = @DEFINE-STYLE(linecolor="#ab6c15", fillcolor="#ab6c15", textcolor="#ab6c15") {};
//  $p_wire = @DEFINE-STYLE(linecolor="#3f5597", fillcolor="#3f5597", textcolor="#3f5597") {};
//  $n_wire = @DEFINE-STYLE(linecolor="#16817a", fillcolor="#16817a", textcolor="#16817a") {};
//  $dynamic_wire = @DEFINE-STYLE(linecolor="#286e97", fillcolor="#286e97", textcolor="#286e97") {};
//  $power_wire = @DEFINE-STYLE(linecolor="#697887", fillcolor="#697887", textcolor="#697887") {};
//  $signal_wire = @DEFINE-STYLE(linecolor="#263442", fillcolor="#263442", textcolor="#263442") {};
//  @LINE(linecolor="#d3dbe4", linewidth=0.08, linestyle="dashed") {(-62, -74) (62, -74) (62, 94) (-62, 94) (-62, -74)};
//  @LINE(linecolor="#d3dbe4", linewidth=0.08, linestyle="dashed") {(-112, 16) (-70, 16) (-70, 54) (-112, 54) (-112, 16)};
//  @LINE(linecolor="#d3dbe4", linewidth=0.08, linestyle="dashed") {(70, 16) (112, 16) (112, 54) (70, 54) (70, 16)};
//  @LINE(linecolor="#d3dbe4", linewidth=0.08, linestyle="dashed") {(-180, -72) (-76, -72) (-76, 0) (-180, 0) (-180, -72)};
//  (0, 104) @TEXT("Miyahara BUFFER-V12", size=2, bold=true, halign="middle", textcolor="#273747");
//  (0, 97) @TEXT("28 nm HPC+ | ULVT MOS | device labels: W/L and nf", size=0.9, bold=false, halign="middle", textcolor="#526171");
//  (0, 91.5) @TEXT("Regenerative second stage", size=1.35, bold=true, halign="middle", textcolor="#273747");
//  (0, 7) @TEXT("Dynamic input stage", size=1.35, bold=true, halign="middle", textcolor="#273747");
//  @LINE(linecolor="#d3dbe4", linewidth=0.08, linestyle="dashed") {(-62, 10) (62, 10)};
//  (-91, 50.5) @TEXT("Output reset assist", size=1.25, bold=true, halign="middle", textcolor="#273747");
//  (91, 50.5) @TEXT("Output reset assist", size=1.25, bold=true, halign="middle", textcolor="#273747");
//  (-176, -5) @TEXT("Clock drive and damping", size=1.25, bold=true, halign="start", textcolor="#273747");
//  #M14 @PLACE(-18, 72) => @ORIENT("R0");
//  #M14 @TEXT("M14", key="name", size=1.15, bold=true, halign="start", textcolor="#273747") => @PLACE(-15.2, 73.2);
//  #M14 @TEXT("4\mu{}m/30nm  nf4", key="dims", size=1, halign="start", textcolor="#526171") => @PLACE(-15.2, 70.5);
//  #M15 @PLACE(18, 72) => @ORIENT("MY");
//  #M15 @TEXT("M15", key="name", size=1.15, bold=true, halign="end", textcolor="#273747") => @PLACE(15.2, 73.2);
//  #M15 @TEXT("4\mu{}m/30nm  nf4", key="dims", size=1, halign="end", textcolor="#526171") => @PLACE(15.2, 70.5);
//  #M10 @PLACE(-18, 52) => @ORIENT("MY");
//  #M10 @TEXT("M10", key="name", size=1.15, bold=true, halign="end", textcolor="#273747") => @PLACE(-20.8, 53.2);
//  #M10 @TEXT("4\mu{}m/30nm  nf4", key="dims", size=1, halign="end", textcolor="#526171") => @PLACE(-20.8, 50.5);
//  #M11 @PLACE(18, 52) => @ORIENT("R0");
//  #M11 @TEXT("M11", key="name", size=1.15, bold=true, halign="start", textcolor="#273747") => @PLACE(20.8, 53.2);
//  #M11 @TEXT("4\mu{}m/30nm  nf4", key="dims", size=1, halign="start", textcolor="#526171") => @PLACE(20.8, 50.5);
//  #M6 @PLACE(-18, 30) => @ORIENT("MY");
//  #M6 @TEXT("M6", key="name", size=1.15, bold=true, halign="end", textcolor="#273747") => @PLACE(-20.8, 31.2);
//  #M6 @TEXT("2\mu{}m/30nm  nf2", key="dims", size=1, halign="end", textcolor="#526171") => @PLACE(-20.8, 28.5);
//  #M7 @PLACE(18, 30) => @ORIENT("R0");
//  #M7 @TEXT("M7", key="name", size=1.15, bold=true, halign="start", textcolor="#273747") => @PLACE(20.8, 31.2);
//  #M7 @TEXT("2\mu{}m/30nm  nf2", key="dims", size=1, halign="start", textcolor="#526171") => @PLACE(20.8, 28.5);
//  #M12 @PLACE(-42, 60) => @ORIENT("R0");
//  #M12 @TEXT("M12", key="name", size=1.15, bold=true, halign="start", textcolor="#273747") => @PLACE(-39.2, 61.2);
//  #M12 @TEXT("1\mu{}m/30nm  nf2", key="dims", size=1, halign="start", textcolor="#526171") => @PLACE(-39.2, 58.5);
//  #M13 @PLACE(42, 60) => @ORIENT("MY");
//  #M13 @TEXT("M13", key="name", size=1.15, bold=true, halign="end", textcolor="#273747") => @PLACE(39.2, 61.2);
//  #M13 @TEXT("1\mu{}m/30nm  nf2", key="dims", size=1, halign="end", textcolor="#526171") => @PLACE(39.2, 58.5);
//  #M8 @PLACE(-42, 30) => @ORIENT("R0");
//  #M8 @TEXT("M8", key="name", size=1.15, bold=true, halign="start", textcolor="#273747") => @PLACE(-39.2, 31.2);
//  #M8 @TEXT("2\mu{}m/30nm  nf2", key="dims", size=1, halign="start", textcolor="#526171") => @PLACE(-39.2, 28.5);
//  #M9 @PLACE(42, 30) => @ORIENT("MY");
//  #M9 @TEXT("M9", key="name", size=1.15, bold=true, halign="end", textcolor="#273747") => @PLACE(39.2, 31.2);
//  #M9 @TEXT("2\mu{}m/30nm  nf2", key="dims", size=1, halign="end", textcolor="#526171") => @PLACE(39.2, 28.5);
//  #MAP @PLACE(-42, -8) => @ORIENT("MY");
//  #MAP @TEXT("MAP", key="name", size=1.15, bold=true, halign="end", textcolor="#273747") => @PLACE(-44.8, -6.8);
//  #MAP @TEXT("2.4\mu{}m/30nm  nf3", key="dims", size=1, halign="end", textcolor="#526171") => @PLACE(-44.8, -9.5);
//  #MAN @PLACE(42, -8) => @ORIENT("R0");
//  #MAN @TEXT("MAN", key="name", size=1.15, bold=true, halign="start", textcolor="#273747") => @PLACE(44.8, -6.8);
//  #MAN @TEXT("2.4\mu{}m/30nm  nf3", key="dims", size=1, halign="start", textcolor="#526171") => @PLACE(44.8, -9.5);
//  #MINP @PLACE(-18, -30) => @ORIENT("R0");
//  #MINP @TEXT("MINP", key="name", size=1.15, bold=true, halign="start", textcolor="#273747") => @PLACE(-15.2, -25.5);
//  #MINP @TEXT("56\mu{}m/30nm  nf56", key="dims", size=1, halign="start", textcolor="#526171") => @PLACE(-15.2, -27.8);
//  #MINN @PLACE(18, -30) => @ORIENT("MY");
//  #MINN @TEXT("MINN", key="name", size=1.15, bold=true, halign="end", textcolor="#273747") => @PLACE(15.2, -25.5);
//  #MINN @TEXT("56\mu{}m/30nm  nf56", key="dims", size=1, halign="end", textcolor="#526171") => @PLACE(15.2, -27.8);
//  #MTAIL @PLACE(0, -50) => @ORIENT("R0");
//  #MTAIL @TEXT("MTAIL", key="name", size=1.15, bold=true, halign="start", textcolor="#273747") => @PLACE(2.8, -48.8);
//  #MTAIL @TEXT("3\mu{}m/30nm  nf3", key="dims", size=1, halign="start", textcolor="#526171") => @PLACE(2.8, -51.5);
//  #MRQP @PLACE(-86, 30) => @ORIENT("MY");
//  #MRQP @TEXT("MRQP", key="name", size=1.15, bold=true, halign="end", textcolor="#273747") => @PLACE(-88.8, 31.2);
//  #MRQP @TEXT("4\mu{}m/30nm  nf4", key="dims", size=1, halign="end", textcolor="#526171") => @PLACE(-88.8, 28.5);
//  #MRQN @PLACE(86, 30) => @ORIENT("R0");
//  #MRQN @TEXT("MRQN", key="name", size=1.15, bold=true, halign="start", textcolor="#273747") => @PLACE(88.8, 31.2);
//  #MRQN @TEXT("4\mu{}m/30nm  nf4", key="dims", size=1, halign="start", textcolor="#526171") => @PLACE(88.8, 28.5);
//  %latch_vdd_0 = (-48, 84);
//  %latch_vdd_1 = (-18, 84);
//  $JUNCTION @ATTACH %latch_vdd_1 => @SET-STYLE $power_wire;
//  %latch_vdd_2 = (0.0, 84);
//  $JUNCTION @ATTACH %latch_vdd_2 => @SET-STYLE $power_wire;
//  %latch_vdd_3 = (18, 84);
//  $JUNCTION @ATTACH %latch_vdd_3 => @SET-STYLE $power_wire;
//  %latch_vdd_4 = (48, 84);
//  &AVDD @WIRE(mode="straight", linecolor="#697887", linewidth=0.11) {%latch_vdd_0 %latch_vdd_1 %latch_vdd_2 %latch_vdd_3 %latch_vdd_4};
//  %s_M14 = (-18, 75);
//  $JUNCTION @ATTACH %s_M14 => @SET-STYLE $power_wire;
//  &AVDD @WIRE(mode="straight", linecolor="#697887", linewidth=0.11) {#M14:s %s_M14};
//  &AVDD @WIRE(mode="straight", linecolor="#697887", linewidth=0.11) {#M14:b (-16, 72) (-16, 75) %s_M14};
//  &AVDD @WIRE(mode="straight", linecolor="#697887", linewidth=0.11) {%s_M14 %latch_vdd_1};
//  %s_M15 = (18, 75);
//  $JUNCTION @ATTACH %s_M15 => @SET-STYLE $power_wire;
//  &AVDD @WIRE(mode="straight", linecolor="#697887", linewidth=0.11) {#M15:s %s_M15};
//  &AVDD @WIRE(mode="straight", linecolor="#697887", linewidth=0.11) {#M15:b (16, 72) (16, 75) %s_M15};
//  &AVDD @WIRE(mode="straight", linecolor="#697887", linewidth=0.11) {%s_M15 %latch_vdd_3};
//  %latch_vdd_tag = $SUPPLY @ATTACH &AVDD => @PLACE(0.0, 86.5);
//  %latch_vdd_tag => @SET-STYLE $power_wire;
//  &AVDD @WIRE(mode="straight", linecolor="#697887", linewidth=0.11) {%latch_vdd_2 %latch_vdd_tag:p};
//  %latch_vss_0 = (-48, 20);
//  %latch_vss_1 = (-42, 20);
//  $JUNCTION @ATTACH %latch_vss_1 => @SET-STYLE $power_wire;
//  %latch_vss_2 = (-18, 20);
//  $JUNCTION @ATTACH %latch_vss_2 => @SET-STYLE $power_wire;
//  %latch_vss_3 = (0.0, 20);
//  $JUNCTION @ATTACH %latch_vss_3 => @SET-STYLE $power_wire;
//  %latch_vss_4 = (18, 20);
//  $JUNCTION @ATTACH %latch_vss_4 => @SET-STYLE $power_wire;
//  %latch_vss_5 = (42, 20);
//  $JUNCTION @ATTACH %latch_vss_5 => @SET-STYLE $power_wire;
//  %latch_vss_6 = (48, 20);
//  &VSS @WIRE(mode="straight", linecolor="#697887", linewidth=0.11) {%latch_vss_0 %latch_vss_1 %latch_vss_2 %latch_vss_3 %latch_vss_4 %latch_vss_5 %latch_vss_6};
//  %s_M8 = (-42, 27);
//  $JUNCTION @ATTACH %s_M8 => @SET-STYLE $power_wire;
//  &VSS @WIRE(mode="straight", linecolor="#697887", linewidth=0.11) {#M8:s %s_M8};
//  &VSS @WIRE(mode="straight", linecolor="#697887", linewidth=0.11) {#M8:b (-40, 30) (-40, 27) %s_M8};
//  &VSS @WIRE(mode="straight", linecolor="#697887", linewidth=0.11) {%s_M8 %latch_vss_1};
//  %s_M6 = (-18, 27);
//  $JUNCTION @ATTACH %s_M6 => @SET-STYLE $power_wire;
//  &VSS @WIRE(mode="straight", linecolor="#697887", linewidth=0.11) {#M6:s %s_M6};
//  &VSS @WIRE(mode="straight", linecolor="#697887", linewidth=0.11) {#M6:b (-20, 30) (-20, 27) %s_M6};
//  &VSS @WIRE(mode="straight", linecolor="#697887", linewidth=0.11) {%s_M6 %latch_vss_2};
//  %s_M7 = (18, 27);
//  $JUNCTION @ATTACH %s_M7 => @SET-STYLE $power_wire;
//  &VSS @WIRE(mode="straight", linecolor="#697887", linewidth=0.11) {#M7:s %s_M7};
//  &VSS @WIRE(mode="straight", linecolor="#697887", linewidth=0.11) {#M7:b (20, 30) (20, 27) %s_M7};
//  &VSS @WIRE(mode="straight", linecolor="#697887", linewidth=0.11) {%s_M7 %latch_vss_4};
//  %s_M9 = (42, 27);
//  $JUNCTION @ATTACH %s_M9 => @SET-STYLE $power_wire;
//  &VSS @WIRE(mode="straight", linecolor="#697887", linewidth=0.11) {#M9:s %s_M9};
//  &VSS @WIRE(mode="straight", linecolor="#697887", linewidth=0.11) {#M9:b (40, 30) (40, 27) %s_M9};
//  &VSS @WIRE(mode="straight", linecolor="#697887", linewidth=0.11) {%s_M9 %latch_vss_5};
//  %latch_vss_tag = $GROUND @ATTACH &VSS => @PLACE(0.0, 18.5);
//  %latch_vss_tag => @SET-STYLE $power_wire;
//  &VSS @WIRE(mode="straight", linecolor="#697887", linewidth=0.11) {%latch_vss_3 %latch_vss_tag:p};
//  %b_M10 = $SUPPLY @ATTACH &AVDD => @PLACE(-29, 56);
//  %b_M10 => @SET-STYLE $power_wire;
//  &AVDD @WIRE(mode="straight", linecolor="#697887", linewidth=0.11) {#M10:b (-29, 52) %b_M10:p};
//  %b_M11 = $SUPPLY @ATTACH &AVDD => @PLACE(29, 56);
//  %b_M11 => @SET-STYLE $power_wire;
//  &AVDD @WIRE(mode="straight", linecolor="#697887", linewidth=0.11) {#M11:b (29, 52) %b_M11:p};
//  %s_M12 = (-42, 57);
//  $JUNCTION @ATTACH %s_M12 => @SET-STYLE $power_wire;
//  &VSS @WIRE(mode="straight", linecolor="#697887", linewidth=0.11) {#M12:s %s_M12};
//  &VSS @WIRE(mode="straight", linecolor="#697887", linewidth=0.11) {#M12:b (-40, 60) (-40, 57) %s_M12};
//  %g_M12 = $GROUND @ATTACH &VSS => @PLACE(-42, 54);
//  %g_M12 => @SET-STYLE $power_wire;
//  &VSS @WIRE(mode="straight", linecolor="#697887", linewidth=0.11) {%s_M12 %g_M12:p};
//  %s_M13 = (42, 57);
//  $JUNCTION @ATTACH %s_M13 => @SET-STYLE $power_wire;
//  &VSS @WIRE(mode="straight", linecolor="#697887", linewidth=0.11) {#M13:s %s_M13};
//  &VSS @WIRE(mode="straight", linecolor="#697887", linewidth=0.11) {#M13:b (40, 60) (40, 57) %s_M13};
//  %g_M13 = $GROUND @ATTACH &VSS => @PLACE(42, 54);
//  %g_M13 => @SET-STYLE $power_wire;
//  &VSS @WIRE(mode="straight", linecolor="#697887", linewidth=0.11) {%s_M13 %g_M13:p};
//  %input_vdd_0 = (-48, 0);
//  %input_vdd_1 = (-42, 0);
//  $JUNCTION @ATTACH %input_vdd_1 => @SET-STYLE $power_wire;
//  %input_vdd_2 = (-18, 0);
//  $JUNCTION @ATTACH %input_vdd_2 => @SET-STYLE $power_wire;
//  %input_vdd_3 = (0.0, 0);
//  $JUNCTION @ATTACH %input_vdd_3 => @SET-STYLE $power_wire;
//  %input_vdd_4 = (18, 0);
//  $JUNCTION @ATTACH %input_vdd_4 => @SET-STYLE $power_wire;
//  %input_vdd_5 = (42, 0);
//  $JUNCTION @ATTACH %input_vdd_5 => @SET-STYLE $power_wire;
//  %input_vdd_6 = (48, 0);
//  &AVDD @WIRE(mode="straight", linecolor="#697887", linewidth=0.11) {%input_vdd_0 %input_vdd_1 %input_vdd_2 %input_vdd_3 %input_vdd_4 %input_vdd_5 %input_vdd_6};
//  %s_MAP = (-42, -5);
//  $JUNCTION @ATTACH %s_MAP => @SET-STYLE $power_wire;
//  &AVDD @WIRE(mode="straight", linecolor="#697887", linewidth=0.11) {#MAP:s %s_MAP};
//  &AVDD @WIRE(mode="straight", linecolor="#697887", linewidth=0.11) {#MAP:b (-44, -8) (-44, -5) %s_MAP};
//  &AVDD @WIRE(mode="straight", linecolor="#697887", linewidth=0.11) {%s_MAP %input_vdd_1};
//  %s_MAN = (42, -5);
//  $JUNCTION @ATTACH %s_MAN => @SET-STYLE $power_wire;
//  &AVDD @WIRE(mode="straight", linecolor="#697887", linewidth=0.11) {#MAN:s %s_MAN};
//  &AVDD @WIRE(mode="straight", linecolor="#697887", linewidth=0.11) {#MAN:b (44, -8) (44, -5) %s_MAN};
//  &AVDD @WIRE(mode="straight", linecolor="#697887", linewidth=0.11) {%s_MAN %input_vdd_5};
//  %input_vdd_tag = $SUPPLY @ATTACH &AVDD => @PLACE(0.0, 2.5);
//  %input_vdd_tag => @SET-STYLE $power_wire;
//  &AVDD @WIRE(mode="straight", linecolor="#697887", linewidth=0.11) {%input_vdd_3 %input_vdd_tag:p};
//  %b_MINP = $GROUND @ATTACH &VSS => @PLACE(-7, -33);
//  %b_MINP => @SET-STYLE $power_wire;
//  %b_MINP @TEXT("", key="name");
//  &VSS @WIRE(mode="straight", linecolor="#697887", linewidth=0.11) {#MINP:b (-7, -30) %b_MINP:p};
//  %b_MINN = $GROUND @ATTACH &VSS => @PLACE(7, -33);
//  %b_MINN => @SET-STYLE $power_wire;
//  %b_MINN @TEXT("", key="name");
//  &VSS @WIRE(mode="straight", linecolor="#697887", linewidth=0.11) {#MINN:b (7, -30) %b_MINN:p};
//  %s_MTAIL = (0, -53);
//  $JUNCTION @ATTACH %s_MTAIL => @SET-STYLE $power_wire;
//  &VSS @WIRE(mode="straight", linecolor="#697887", linewidth=0.11) {#MTAIL:s %s_MTAIL};
//  &VSS @WIRE(mode="straight", linecolor="#697887", linewidth=0.11) {#MTAIL:b (2, -50) (2, -53) %s_MTAIL};
//  %g_MTAIL = $GROUND @ATTACH &VSS => @PLACE(0, -58);
//  %g_MTAIL => @SET-STYLE $power_wire;
//  &VSS @WIRE(mode="straight", linecolor="#697887", linewidth=0.11) {%s_MTAIL %g_MTAIL:p};
//  %xp = (-18, 64);
//  $JUNCTION @ATTACH %xp => @SET-STYLE $dynamic_wire;
//  %xn = (18, 64);
//  $JUNCTION @ATTACH %xn => @SET-STYLE $dynamic_wire;
//  &XP @WIRE(mode="straight", linecolor="#286e97", linewidth=0.16) {#M14:d %xp #M10:s};
//  &XP @WIRE(mode="straight", linecolor="#286e97", linewidth=0.16) {#M12:d (-42, 64) %xp};
//  &XN @WIRE(mode="straight", linecolor="#286e97", linewidth=0.16) {#M15:d %xn #M11:s};
//  &XN @WIRE(mode="straight", linecolor="#286e97", linewidth=0.16) {#M13:d (42, 64) %xn};
//  %outp = (-18, 42);
//  $JUNCTION @ATTACH %outp => @SET-STYLE $p_wire;
//  %outn = (18, 37);
//  $JUNCTION @ATTACH %outn => @SET-STYLE $n_wire;
//  %outp_reset = (-42, 42);
//  $JUNCTION @ATTACH %outp_reset => @SET-STYLE $p_wire;
//  %outn_reset = (42, 37);
//  $JUNCTION @ATTACH %outn_reset => @SET-STYLE $n_wire;
//  &RP @WIRE(mode="straight", linecolor="#3f5597", linewidth=0.16) {#M10:d %outp #M6:d};
//  &RP @WIRE(mode="straight", linecolor="#3f5597", linewidth=0.16) {%outp %outp_reset #M8:d};
//  &RN @WIRE(mode="straight", linecolor="#16817a", linewidth=0.16) {#M11:d %outn #M7:d};
//  &RN @WIRE(mode="straight", linecolor="#16817a", linewidth=0.16) {%outn %outn_reset #M9:d};
//  %feedback_outp = (8, 42);
//  $JUNCTION @ATTACH %feedback_outp => @SET-STYLE $p_wire;
//  %feedback_outn = (-8, 37);
//  $JUNCTION @ATTACH %feedback_outn => @SET-STYLE $n_wire;
//  &RP @WIRE(mode="straight", linecolor="#3f5597", linewidth=0.16) {%outp %feedback_outp};
//  &RP @WIRE(mode="straight", linecolor="#3f5597", linewidth=0.16) {#M11:g (8, 52) %feedback_outp (8, 30) #M7:g};
//  &RN @WIRE(mode="straight", linecolor="#16817a", linewidth=0.16) {%outn %feedback_outn};
//  &RN @WIRE(mode="straight", linecolor="#16817a", linewidth=0.16) {#M10:g (-8, 52) %feedback_outn (-8, 30) #M6:g};
//  %dp = (-18, -18);
//  $JUNCTION @ATTACH %dp => @SET-STYLE $dynamic_wire;
//  %dn = (18, -18);
//  $JUNCTION @ATTACH %dn => @SET-STYLE $dynamic_wire;
//  &DP @WIRE(mode="straight", linecolor="#286e97", linewidth=0.16) {%dp #MINP:d};
//  &DN @WIRE(mode="straight", linecolor="#286e97", linewidth=0.16) {%dn #MINN:d};
//  %dp_cap_branch = (-42, -18);
//  $JUNCTION @ATTACH %dp_cap_branch => @SET-STYLE $dynamic_wire;
//  %dp_bottom = (-56, -18);
//  %dp_reset = (-56, 30);
//  $JUNCTION @ATTACH %dp_reset => @SET-STYLE $dynamic_wire;
//  %dp_internal_reset = (-56, 60);
//  $JUNCTION @ATTACH %dp_internal_reset => @SET-STYLE $dynamic_wire;
//  %dp_top = (-56, 72);
//  &DP @WIRE(mode="straight", linecolor="#286e97", linewidth=0.16) {%dp %dp_cap_branch %dp_bottom %dp_reset %dp_internal_reset %dp_top #M14:g};
//  &DP @WIRE(mode="straight", linecolor="#286e97", linewidth=0.16) {%dp_internal_reset #M12:g};
//  &DP @WIRE(mode="straight", linecolor="#286e97", linewidth=0.16) {%dp_reset #M8:g};
//  &DP @WIRE(mode="straight", linecolor="#286e97", linewidth=0.16) {#MAP:d %dp_cap_branch};
//  #CDP @PLACE(-42, -32) => @ORIENT("R0");
//  #CDP @TEXT("CDP", key="name", size=1.15, bold=true, halign="end", textcolor="#273747") => @PLACE(-45, -30.5);
//  #CDP @TEXT("14.06 fF nominal", key="value", size=0.95, halign="end", textcolor="#526171") => @PLACE(-45, -33.3);
//  #CDP @TEXT("nr=48, lr=1\mu{}m", key="geometry", size=0.9, halign="end", textcolor="#526171") => @PLACE(-45, -36.1);
//  &DP @WIRE(mode="straight", linecolor="#286e97", linewidth=0.16) {%dp_cap_branch #CDP:p};
//  %g_CDP = $GROUND @ATTACH &VSS => @PLACE(-42, -40);
//  %g_CDP => @SET-STYLE $power_wire;
//  &VSS @WIRE(mode="straight", linecolor="#697887", linewidth=0.11) {#CDP:n %g_CDP:p};
//  (-54, 79) @TEXT("DP", size=0.95, bold=true, halign="middle", textcolor="#286e97");
//  %dn_cap_branch = (42, -18);
//  $JUNCTION @ATTACH %dn_cap_branch => @SET-STYLE $dynamic_wire;
//  %dn_bottom = (56, -18);
//  %dn_reset = (56, 30);
//  $JUNCTION @ATTACH %dn_reset => @SET-STYLE $dynamic_wire;
//  %dn_internal_reset = (56, 60);
//  $JUNCTION @ATTACH %dn_internal_reset => @SET-STYLE $dynamic_wire;
//  %dn_top = (56, 72);
//  &DN @WIRE(mode="straight", linecolor="#286e97", linewidth=0.16) {%dn %dn_cap_branch %dn_bottom %dn_reset %dn_internal_reset %dn_top #M15:g};
//  &DN @WIRE(mode="straight", linecolor="#286e97", linewidth=0.16) {%dn_internal_reset #M13:g};
//  &DN @WIRE(mode="straight", linecolor="#286e97", linewidth=0.16) {%dn_reset #M9:g};
//  &DN @WIRE(mode="straight", linecolor="#286e97", linewidth=0.16) {#MAN:d %dn_cap_branch};
//  #CDN @PLACE(42, -32) => @ORIENT("MY");
//  #CDN @TEXT("CDN", key="name", size=1.15, bold=true, halign="start", textcolor="#273747") => @PLACE(45, -30.5);
//  #CDN @TEXT("14.06 fF nominal", key="value", size=0.95, halign="start", textcolor="#526171") => @PLACE(45, -33.3);
//  #CDN @TEXT("nr=48, lr=1\mu{}m", key="geometry", size=0.9, halign="start", textcolor="#526171") => @PLACE(45, -36.1);
//  &DN @WIRE(mode="straight", linecolor="#286e97", linewidth=0.16) {%dn_cap_branch #CDN:p};
//  %g_CDN = $GROUND @ATTACH &VSS => @PLACE(42, -40);
//  %g_CDN => @SET-STYLE $power_wire;
//  &VSS @WIRE(mode="straight", linecolor="#697887", linewidth=0.11) {#CDN:n %g_CDN:p};
//  (54, 79) @TEXT("DN", size=0.95, bold=true, halign="middle", textcolor="#286e97");
//  %tail = (0, -38);
//  $JUNCTION @ATTACH %tail => @SET-STYLE $signal_wire;
//  &TAIL @WIRE(mode="straight", linecolor="#263442", linewidth=0.16) {#MINP:s (-18, -38) %tail (18, -38) #MINN:s};
//  &TAIL @WIRE(mode="straight", linecolor="#263442", linewidth=0.16) {%tail #MTAIL:d};
//  %port_INP = $IO_PORT @ATTACH &INP => @PLACE(-31, -30) => @ORIENT("R0");
//  %port_INP @TEXT("INP", key="name", size=1, bold=true);
//  %port_INN = $IO_PORT @ATTACH &INN => @PLACE(31, -30) => @ORIENT("MY");
//  %port_INN @TEXT("INN", key="name", size=1, bold=true);
//  &INP @WIRE(mode="straight", linecolor="#263442", linewidth=0.16) {%port_INP:p #MINP:g};
//  &INN @WIRE(mode="straight", linecolor="#263442", linewidth=0.16) {%port_INN:p #MINN:g};
//  %clk_precharge_p = (-36, -78);
//  $JUNCTION @ATTACH %clk_precharge_p => @SET-STYLE $clock_wire;
//  %clk_tail = (-6, -78);
//  $JUNCTION @ATTACH %clk_tail => @SET-STYLE $clock_wire;
//  %clk_precharge_n = (36, -78);
//  &CLKC @WIRE(mode="straight", linecolor="#ab6c15", linewidth=0.16) {%clk_precharge_p %clk_tail %clk_precharge_n};
//  &CLKC @WIRE(mode="straight", linecolor="#ab6c15", linewidth=0.16) {%clk_precharge_p (-36, -8) #MAP:g};
//  &CLKC @WIRE(mode="straight", linecolor="#ab6c15", linewidth=0.16) {%clk_precharge_n (36, -8) #MAN:g};
//  &CLKC @WIRE(mode="straight", linecolor="#ab6c15", linewidth=0.16) {%clk_tail (-6, -50) #MTAIL:g};
//  (-50, -14) @TEXT("CLKC", size=0.85, bold=true, halign="middle", textcolor="#ab6c15");
//  (50, -14) @TEXT("CLKC", size=0.85, bold=true, halign="middle", textcolor="#ab6c15");
//  (-34, -74.5) @TEXT("CLKC", size=0.95, bold=true, halign="start", textcolor="#ab6c15");
//  #MCKP @PLACE(-162, -23) => @ORIENT("R0");
//  #MCKP @TEXT("MCKP", key="name", size=1.15, bold=true, halign="start", textcolor="#273747") => @PLACE(-159.2, -21.8);
//  #MCKP @TEXT("3\mu{}m/30nm  nf3", key="dims", size=1, halign="start", textcolor="#526171") => @PLACE(-159.2, -24.5);
//  #MCKN @PLACE(-162, -37) => @ORIENT("R0");
//  #MCKN @TEXT("MCKN", key="name", size=1.15, bold=true, halign="start", textcolor="#273747") => @PLACE(-159.2, -35.8);
//  #MCKN @TEXT("1\mu{}m/30nm  nf1", key="dims", size=1, halign="start", textcolor="#526171") => @PLACE(-159.2, -38.5);
//  %clock1_in = (-168, -30);
//  $JUNCTION @ATTACH %clock1_in => @SET-STYLE $clock_wire;
//  %clock1_out = (-162, -30);
//  $JUNCTION @ATTACH %clock1_out => @SET-STYLE $clock_wire;
//  &CLKC @WIRE(mode="straight", linecolor="#ab6c15", linewidth=0.16) {#MCKP:g (-168, -23) %clock1_in (-168, -37) #MCKN:g};
//  &CKB @WIRE(mode="straight", linecolor="#ab6c15", linewidth=0.16) {#MCKP:d %clock1_out #MCKN:d};
//  %ckb_fanout = (-140, -30);
//  $JUNCTION @ATTACH %ckb_fanout => @SET-STYLE $clock_wire;
//  &CKB @WIRE(mode="straight", linecolor="#ab6c15", linewidth=0.16) {%clock1_out %ckb_fanout};
//  #CCB @PLACE(-140, -56) => @ORIENT("R0");
//  #CCB @TEXT("CCB", key="name", size=1.15, bold=true, halign="end", textcolor="#273747") => @PLACE(-143, -54.5);
//  #CCB @TEXT("14.06 fF nominal", key="value", size=0.95, halign="end", textcolor="#526171") => @PLACE(-143, -57.3);
//  #CCB @TEXT("nr=48, lr=1\mu{}m", key="geometry", size=0.9, halign="end", textcolor="#526171") => @PLACE(-143, -60.1);
//  &CKB @WIRE(mode="straight", linecolor="#ab6c15", linewidth=0.16) {%ckb_fanout #CCB:p};
//  %g_CCB = $GROUND @ATTACH &VSS => @PLACE(-140, -64);
//  %g_CCB => @SET-STYLE $power_wire;
//  &VSS @WIRE(mode="straight", linecolor="#697887", linewidth=0.11) {#CCB:n %g_CCB:p};
//  %clock_vdd_p = (-162, -14);
//  $JUNCTION @ATTACH %clock_vdd_p => @SET-STYLE $power_wire;
//  %clock_vdd_n = (-118, -14);
//  $JUNCTION @ATTACH %clock_vdd_n => @SET-STYLE $power_wire;
//  &AVDD @WIRE(mode="straight", linecolor="#697887", linewidth=0.11) {%clock_vdd_p %clock_vdd_n};
//  %s_MCKP = (-162, -20);
//  $JUNCTION @ATTACH %s_MCKP => @SET-STYLE $power_wire;
//  &AVDD @WIRE(mode="straight", linecolor="#697887", linewidth=0.11) {#MCKP:s %s_MCKP};
//  &AVDD @WIRE(mode="straight", linecolor="#697887", linewidth=0.11) {#MCKP:b (-160, -23) (-160, -20) %s_MCKP};
//  &AVDD @WIRE(mode="straight", linecolor="#697887", linewidth=0.11) {%s_MCKP %clock_vdd_p};
//  %clock_vdd_tag = $SUPPLY @ATTACH &AVDD => @PLACE(-168, -11.5);
//  %clock_vdd_tag => @SET-STYLE $power_wire;
//  &AVDD @WIRE(mode="straight", linecolor="#697887", linewidth=0.11) {%clock_vdd_p (-168, -14) %clock_vdd_tag:p};
//  %s_MCKN = (-162, -40);
//  $JUNCTION @ATTACH %s_MCKN => @SET-STYLE $power_wire;
//  &VSS @WIRE(mode="straight", linecolor="#697887", linewidth=0.11) {#MCKN:s %s_MCKN};
//  &VSS @WIRE(mode="straight", linecolor="#697887", linewidth=0.11) {#MCKN:b (-160, -37) (-160, -40) %s_MCKN};
//  %g_MCKN = $GROUND @ATTACH &VSS => @PLACE(-162, -44);
//  %g_MCKN => @SET-STYLE $power_wire;
//  &VSS @WIRE(mode="straight", linecolor="#697887", linewidth=0.11) {%s_MCKN %g_MCKN:p};
//  %port_CLKC = $IO_PORT @ATTACH &CLKC => @PLACE(-198, -30) => @ORIENT("R0");
//  %port_CLKC @TEXT("CLKC", key="name", size=1, bold=true);
//  %clk_direct = (-184, -30);
//  $JUNCTION @ATTACH %clk_direct => @SET-STYLE $clock_wire;
//  &CLKC @WIRE(mode="straight", linecolor="#ab6c15", linewidth=0.16) {%port_CLKC:p %clk_direct %clock1_in};
//  &CLKC @WIRE(mode="straight", linecolor="#ab6c15", linewidth=0.16) {%clk_direct (-184, -78) %clk_precharge_p};
//  (-145, -27.5) @TEXT("CKB", size=0.95, bold=true, halign="end", textcolor="#ab6c15");
//  {#MCKP #MCKN #CCB} @GROUP;
//  %outp_assist = (-86, 42);
//  $JUNCTION @ATTACH %outp_assist => @SET-STYLE $p_wire;
//  %outn_assist = (86, 37);
//  $JUNCTION @ATTACH %outn_assist => @SET-STYLE $n_wire;
//  &RP @WIRE(mode="straight", linecolor="#3f5597", linewidth=0.16) {%outp_reset %outp_assist #MRQP:d};
//  &RN @WIRE(mode="straight", linecolor="#16817a", linewidth=0.16) {%outn_reset %outn_assist #MRQN:d};
//  %assist_vss_p = (-86, 20);
//  $JUNCTION @ATTACH %assist_vss_p => @SET-STYLE $power_wire;
//  %assist_vss_n = (86, 20);
//  $JUNCTION @ATTACH %assist_vss_n => @SET-STYLE $power_wire;
//  %s_MRQP = (-86, 27);
//  $JUNCTION @ATTACH %s_MRQP => @SET-STYLE $power_wire;
//  &VSS @WIRE(mode="straight", linecolor="#697887", linewidth=0.11) {#MRQP:s %s_MRQP};
//  &VSS @WIRE(mode="straight", linecolor="#697887", linewidth=0.11) {#MRQP:b (-88, 30) (-88, 27) %s_MRQP};
//  &VSS @WIRE(mode="straight", linecolor="#697887", linewidth=0.11) {%s_MRQP %assist_vss_p %latch_vss_0};
//  %s_MRQN = (86, 27);
//  $JUNCTION @ATTACH %s_MRQN => @SET-STYLE $power_wire;
//  &VSS @WIRE(mode="straight", linecolor="#697887", linewidth=0.11) {#MRQN:s %s_MRQN};
//  &VSS @WIRE(mode="straight", linecolor="#697887", linewidth=0.11) {#MRQN:b (88, 30) (88, 27) %s_MRQN};
//  &VSS @WIRE(mode="straight", linecolor="#697887", linewidth=0.11) {%s_MRQN %assist_vss_n %latch_vss_6};
//  %ckb_reset_p = (-76, 12);
//  $JUNCTION @ATTACH %ckb_reset_p => @SET-STYLE $clock_wire;
//  %ckb_reset_n = (76, 12);
//  $JUNCTION @ATTACH %ckb_reset_n => @SET-STYLE $clock_wire;
//  &CKB @WIRE(mode="straight", linecolor="#ab6c15", linewidth=0.16) {%ckb_fanout (-140, 12) %ckb_reset_p %ckb_reset_n};
//  &CKB @WIRE(mode="straight", linecolor="#ab6c15", linewidth=0.16) {%ckb_reset_p (-76, 30) #MRQP:g};
//  &CKB @WIRE(mode="straight", linecolor="#ab6c15", linewidth=0.16) {%ckb_reset_n (76, 30) #MRQN:g};
//  (-30, 14.5) @TEXT("CKB", size=0.95, bold=true, halign="middle", textcolor="#ab6c15");
//  (78, 15) @TEXT("CKB", size=0.95, bold=true, halign="start", textcolor="#ab6c15");
//  (-23, 65.5) @TEXT("XP", size=0.85, bold=true, halign="middle", textcolor="#286e97");
//  (23, 65.5) @TEXT("XN", size=0.85, bold=true, halign="middle", textcolor="#286e97");
//  (-27, 44) @TEXT("RP", size=0.9, bold=true, halign="middle", textcolor="#3f5597");
//  (27, 39) @TEXT("RN", size=0.9, bold=true, halign="middle", textcolor="#16817a");
//  (4, -41) @TEXT("TAIL", size=0.8, bold=false, halign="start", textcolor="#526171");
//  (0, -84) @TEXT("Dots mark connections. Crossings without dots are separate nets.", size=0.85, bold=false, halign="middle", textcolor="#526171");
//  %input_pair = #MINP(in_p) #MINN(in_n) #MTAIL(tail) @AS $DIFFERENTIAL_PAIR;
//  %core_axis = (0, 0);
//  {#MINP #MINN} @AS $MATCHED;
//  #MINP(a) #MINN(b) %core_axis(axis) @AS $MIRRORED;
//  {#MAP #MAN} @AS $MATCHED;
//  #MAP(a) #MAN(b) %core_axis(axis) @AS $MIRRORED;
//  {#M14 #M15} @AS $MATCHED;
//  #M14(a) #M15(b) %core_axis(axis) @AS $MIRRORED;
//  {#M12 #M13} @AS $MATCHED;
//  #M12(a) #M13(b) %core_axis(axis) @AS $MIRRORED;
//  {#M10 #M11} @AS $MATCHED;
//  #M10(a) #M11(b) %core_axis(axis) @AS $MIRRORED;
//  {#M6 #M7} @AS $MATCHED;
//  #M6(a) #M7(b) %core_axis(axis) @AS $MIRRORED;
//  {#M8 #M9} @AS $MATCHED;
//  #M8(a) #M9(b) %core_axis(axis) @AS $MIRRORED;
//  {#MRQP #MRQN} @AS $MATCHED;
//  #MRQP(a) #MRQN(b) %core_axis(axis) @AS $MIRRORED;
//  {#CDP #CDN} @AS $MATCHED;
//  #CDP(a) #CDN(b) %core_axis(axis) @AS $MIRRORED;
//  {#MINP #MINN #MTAIL #MAP #MAN #CDP #CDN} @GROUP;
//  {#M14 #M15 #M12 #M13 #M10 #M11 #M6 #M7 #M8 #M9} @GROUP;
//  {#MRQP #MRQN} @GROUP;
//  (-180, 87) @TEXT("OUTP: physical threshold buffer", size=1.3, bold=true, halign="middle");
//  #MBPP @PLACE(-150, 65) => @ORIENT("MY");
//  #MBPP @TEXT("MBPP", key="name", size=1.05, halign="end") => @PLACE(-153, 66.5);
//  #MBPP @TEXT("6um/30nm nf6", key="dims", size=.95, halign="end") => @PLACE(-153, 63.5);
//  %s_MBPP_new = $SUPPLY @ATTACH &AVDD => @PLACE(-150, 73);
//  &AVDD @WIRE(mode="straight", linecolor="#697887", linewidth=0.16) {#MBPP:s %s_MBPP_new:p};
//  &AVDD @WIRE(mode="straight", linecolor="#697887", linewidth=0.16) {#MBPP:b (-152, 65) (-152, 73) %s_MBPP_new:p};
//  #MBPN @PLACE(-150, 37) => @ORIENT("MY");
//  #MBPN @TEXT("MBPN", key="name", size=1.05, halign="end") => @PLACE(-153, 38.5);
//  #MBPN @TEXT("2um/30nm nf2", key="dims", size=.95, halign="end") => @PLACE(-153, 35.5);
//  %s_MBPN_new = $GROUND @ATTACH &VSS => @PLACE(-150, 29);
//  &VSS @WIRE(mode="straight", linecolor="#697887", linewidth=0.16) {#MBPN:s %s_MBPN_new:p};
//  &VSS @WIRE(mode="straight", linecolor="#697887", linewidth=0.16) {#MBPN:b (-152, 37) (-152, 29) %s_MBPN_new:p};
//  &RP @WIRE(mode="straight", linecolor="#263442", linewidth=0.16) {#MBPP:g (-144, 65) (-144, 37) #MBPN:g};
//  &BP @WIRE(mode="straight", linecolor="#263442", linewidth=0.16) {#MBPP:d (-150, 51) #MBPN:d};
//  %BP_in = (-144, 51);
//  $JUNCTION @ATTACH %BP_in;
//  %BP_out = (-150, 51);
//  $JUNCTION @ATTACH %BP_out;
//  #MOPP @PLACE(-205, 65) => @ORIENT("MY");
//  #MOPP @TEXT("MOPP", key="name", size=1.05, halign="end") => @PLACE(-208, 66.5);
//  #MOPP @TEXT("4um/30nm nf4", key="dims", size=.95, halign="end") => @PLACE(-208, 63.5);
//  %s_MOPP_new = $SUPPLY @ATTACH &AVDD => @PLACE(-205, 73);
//  &AVDD @WIRE(mode="straight", linecolor="#697887", linewidth=0.16) {#MOPP:s %s_MOPP_new:p};
//  &AVDD @WIRE(mode="straight", linecolor="#697887", linewidth=0.16) {#MOPP:b (-207, 65) (-207, 73) %s_MOPP_new:p};
//  #MOPN @PLACE(-205, 37) => @ORIENT("MY");
//  #MOPN @TEXT("MOPN", key="name", size=1.05, halign="end") => @PLACE(-208, 38.5);
//  #MOPN @TEXT("3\mu{}m/30nm  nf3", key="dims", size=.95, halign="end") => @PLACE(-208, 35.5);
//  %s_MOPN_new = $GROUND @ATTACH &VSS => @PLACE(-205, 29);
//  &VSS @WIRE(mode="straight", linecolor="#697887", linewidth=0.16) {#MOPN:s %s_MOPN_new:p};
//  &VSS @WIRE(mode="straight", linecolor="#697887", linewidth=0.16) {#MOPN:b (-207, 37) (-207, 29) %s_MOPN_new:p};
//  &BP @WIRE(mode="straight", linecolor="#263442", linewidth=0.16) {#MOPP:g (-199, 65) (-199, 37) #MOPN:g};
//  &OUTP @WIRE(mode="straight", linecolor="#263442", linewidth=0.16) {#MOPP:d (-205, 51) #MOPN:d};
//  %OP_in = (-199, 51);
//  $JUNCTION @ATTACH %OP_in;
//  %OP_out = (-205, 51);
//  $JUNCTION @ATTACH %OP_out;
//  &RP @WIRE(mode="straight", linecolor="#263442", linewidth=0.16) {#MRQP:d (-117, 51) (-144, 51)};
//  &BP @WIRE(mode="straight", linecolor="#263442", linewidth=0.16) {(-150, 51) (-199, 51)};
//  %port_OUTP = $IO_PORT @ATTACH &OUTP => @PLACE(-234, 51) => @ORIENT("R0");
//  %port_OUTP @TEXT("OUTP", key="name", size=1, bold=true);
//  &OUTP @WIRE(mode="straight", linecolor="#263442", linewidth=0.16) {(-205, 51) %port_OUTP:p};
//  (-150, 11) @TEXT("RP -> BP -> OUTP", size=1, halign="middle");
//  (180, 87) @TEXT("OUTN: physical threshold buffer", size=1.3, bold=true, halign="middle");
//  #MBNP @PLACE(150, 65) => @ORIENT("R0");
//  #MBNP @TEXT("MBNP", key="name", size=1.05, halign="start") => @PLACE(153, 66.5);
//  #MBNP @TEXT("6um/30nm nf6", key="dims", size=.95, halign="start") => @PLACE(153, 63.5);
//  %s_MBNP_new = $SUPPLY @ATTACH &AVDD => @PLACE(150, 73);
//  &AVDD @WIRE(mode="straight", linecolor="#697887", linewidth=0.16) {#MBNP:s %s_MBNP_new:p};
//  &AVDD @WIRE(mode="straight", linecolor="#697887", linewidth=0.16) {#MBNP:b (152, 65) (152, 73) %s_MBNP_new:p};
//  #MBNN @PLACE(150, 37) => @ORIENT("R0");
//  #MBNN @TEXT("MBNN", key="name", size=1.05, halign="start") => @PLACE(153, 38.5);
//  #MBNN @TEXT("2um/30nm nf2", key="dims", size=.95, halign="start") => @PLACE(153, 35.5);
//  %s_MBNN_new = $GROUND @ATTACH &VSS => @PLACE(150, 29);
//  &VSS @WIRE(mode="straight", linecolor="#697887", linewidth=0.16) {#MBNN:s %s_MBNN_new:p};
//  &VSS @WIRE(mode="straight", linecolor="#697887", linewidth=0.16) {#MBNN:b (152, 37) (152, 29) %s_MBNN_new:p};
//  &RN @WIRE(mode="straight", linecolor="#263442", linewidth=0.16) {#MBNP:g (144, 65) (144, 37) #MBNN:g};
//  &BN @WIRE(mode="straight", linecolor="#263442", linewidth=0.16) {#MBNP:d (150, 51) #MBNN:d};
//  %BN_in = (144, 51);
//  $JUNCTION @ATTACH %BN_in;
//  %BN_out = (150, 51);
//  $JUNCTION @ATTACH %BN_out;
//  #MONP @PLACE(205, 65) => @ORIENT("R0");
//  #MONP @TEXT("MONP", key="name", size=1.05, halign="start") => @PLACE(208, 66.5);
//  #MONP @TEXT("4um/30nm nf4", key="dims", size=.95, halign="start") => @PLACE(208, 63.5);
//  %s_MONP_new = $SUPPLY @ATTACH &AVDD => @PLACE(205, 73);
//  &AVDD @WIRE(mode="straight", linecolor="#697887", linewidth=0.16) {#MONP:s %s_MONP_new:p};
//  &AVDD @WIRE(mode="straight", linecolor="#697887", linewidth=0.16) {#MONP:b (207, 65) (207, 73) %s_MONP_new:p};
//  #MONN @PLACE(205, 37) => @ORIENT("R0");
//  #MONN @TEXT("MONN", key="name", size=1.05, halign="start") => @PLACE(208, 38.5);
//  #MONN @TEXT("3\mu{}m/30nm  nf3", key="dims", size=.95, halign="start") => @PLACE(208, 35.5);
//  %s_MONN_new = $GROUND @ATTACH &VSS => @PLACE(205, 29);
//  &VSS @WIRE(mode="straight", linecolor="#697887", linewidth=0.16) {#MONN:s %s_MONN_new:p};
//  &VSS @WIRE(mode="straight", linecolor="#697887", linewidth=0.16) {#MONN:b (207, 37) (207, 29) %s_MONN_new:p};
//  &BN @WIRE(mode="straight", linecolor="#263442", linewidth=0.16) {#MONP:g (199, 65) (199, 37) #MONN:g};
//  &OUTN @WIRE(mode="straight", linecolor="#263442", linewidth=0.16) {#MONP:d (205, 51) #MONN:d};
//  %ON_in = (199, 51);
//  $JUNCTION @ATTACH %ON_in;
//  %ON_out = (205, 51);
//  $JUNCTION @ATTACH %ON_out;
//  &RN @WIRE(mode="straight", linecolor="#263442", linewidth=0.16) {#MRQN:d (117, 51) (144, 51)};
//  &BN @WIRE(mode="straight", linecolor="#263442", linewidth=0.16) {(150, 51) (199, 51)};
//  %port_OUTN = $IO_PORT @ATTACH &OUTN => @PLACE(234, 51) => @ORIENT("MY");
//  %port_OUTN @TEXT("OUTN", key="name", size=1, bold=true);
//  &OUTN @WIRE(mode="straight", linecolor="#263442", linewidth=0.16) {(205, 51) %port_OUTN:p};
//  (150, 11) @TEXT("RN -> BN -> OUTN", size=1, halign="middle");
//  (0, -91) @TEXT("Direct input precharge P2.4; raw reset N4; buffer P6/N2; output P4/N3; CKB rail loads.", size=1, halign="middle");
//  (0, -104) @TEXT("Weak input-drain diode loads", size=1.3, bold=true, halign="middle");
//  #MDDP @PLACE(-45, -122) => @ORIENT("R0");
//  #MDDP @TEXT("MDDP", key="name", size=1.05, halign="start") => @PLACE(-42, -120.5);
//  #MDDP @TEXT("0.5um/500nm nf1", key="dims", size=.95, halign="start") => @PLACE(-42, -123.5);
//  %g_MDDP = $GROUND @ATTACH &VSS => @PLACE(-45, -132);
//  &VSS @WIRE(mode="straight", linewidth=.16) {#MDDP:s %g_MDDP:p};
//  &VSS @WIRE(mode="straight", linewidth=.16) {#MDDP:b (-43, -122) (-43, -132) %g_MDDP:p};
//  %d_MDDP = (-45, -112);
//  $JUNCTION @ATTACH %d_MDDP;
//  &DP @WIRE(mode="straight", linewidth=.16) {#MDDP:d %d_MDDP (-53, -112) (-53, -122) #MDDP:g};
//  (-45, -110) @TEXT("DP", size=1, bold=true, halign="middle");
//  #MDDN @PLACE(45, -122) => @ORIENT("R0");
//  #MDDN @TEXT("MDDN", key="name", size=1.05, halign="start") => @PLACE(48, -120.5);
//  #MDDN @TEXT("0.5um/500nm nf1", key="dims", size=.95, halign="start") => @PLACE(48, -123.5);
//  %g_MDDN = $GROUND @ATTACH &VSS => @PLACE(45, -132);
//  &VSS @WIRE(mode="straight", linewidth=.16) {#MDDN:s %g_MDDN:p};
//  &VSS @WIRE(mode="straight", linewidth=.16) {#MDDN:b (47, -122) (47, -132) %g_MDDN:p};
//  %d_MDDN = (45, -112);
//  $JUNCTION @ATTACH %d_MDDN;
//  &DN @WIRE(mode="straight", linewidth=.16) {#MDDN:d %d_MDDN (37, -112) (37, -122) #MDDN:g};
//  (45, -110) @TEXT("DN", size=1, bold=true, halign="middle");
//  {#MDDP #MDDN} @AS $MATCHED;
//  (0, -142) @TEXT("43 MOS + 9 MOM. Node damping, one physical clock inverter, direct input precharge.", size=1, halign="middle");
//  (0, -154) @TEXT("Physical damping at the measured XP, raw-output and buffer excursions", size=1.3, bold=true, halign="middle");
//  #CXP @PLACE(-150, -170) => @ORIENT("R0");
//  #CXP @TEXT("CXP 4.46051fF", key="name", size=.95, halign="start") => @PLACE(-147, -168.5);
//  &XP @WIRE(mode="straight", linewidth=.16) {#CXP:p (-150, -162)};
//  (-150, -160) @TEXT("XP", size=1, bold=true, halign="middle");
//  %g_CXP = $GROUND @ATTACH &VSS => @PLACE(-150, -178);
//  &VSS @WIRE(mode="straight", linewidth=.16) {#CXP:n %g_CXP:p};
//  #CXN @PLACE(-90, -170) => @ORIENT("R0");
//  #CXN @TEXT("CXN 4.46051fF", key="name", size=.95, halign="start") => @PLACE(-87, -168.5);
//  &XN @WIRE(mode="straight", linewidth=.16) {#CXN:p (-90, -162)};
//  (-90, -160) @TEXT("XN", size=1, bold=true, halign="middle");
//  %g_CXN = $GROUND @ATTACH &VSS => @PLACE(-90, -178);
//  &VSS @WIRE(mode="straight", linewidth=.16) {#CXN:n %g_CXN:p};
//  #CRP @PLACE(-30, -170) => @ORIENT("R0");
//  #CRP @TEXT("CRP 2.06055fF", key="name", size=.95, halign="start") => @PLACE(-27, -168.5);
//  &RP @WIRE(mode="straight", linewidth=.16) {#CRP:p (-30, -162)};
//  (-30, -160) @TEXT("RP", size=1, bold=true, halign="middle");
//  %g_CRP = $GROUND @ATTACH &VSS => @PLACE(-30, -178);
//  &VSS @WIRE(mode="straight", linewidth=.16) {#CRP:n %g_CRP:p};
//  #CRN @PLACE(30, -170) => @ORIENT("R0");
//  #CRN @TEXT("CRN 2.06055fF", key="name", size=.95, halign="start") => @PLACE(33, -168.5);
//  &RN @WIRE(mode="straight", linewidth=.16) {#CRN:p (30, -162)};
//  (30, -160) @TEXT("RN", size=1, bold=true, halign="middle");
//  %g_CRN = $GROUND @ATTACH &VSS => @PLACE(30, -178);
//  &VSS @WIRE(mode="straight", linewidth=.16) {#CRN:n %g_CRN:p};
//  #CBP @PLACE(90, -170) => @ORIENT("R0");
//  #CBP @TEXT("CBP 4.46051fF", key="name", size=.95, halign="start") => @PLACE(93, -168.5);
//  &BP @WIRE(mode="straight", linewidth=.16) {#CBP:p (90, -162)};
//  (90, -160) @TEXT("BP", size=1, bold=true, halign="middle");
//  %g_CBP = $GROUND @ATTACH &VSS => @PLACE(90, -178);
//  &VSS @WIRE(mode="straight", linewidth=.16) {#CBP:n %g_CBP:p};
//  #CBN @PLACE(150, -170) => @ORIENT("R0");
//  #CBN @TEXT("CBN 4.46051fF", key="name", size=.95, halign="start") => @PLACE(153, -168.5);
//  &BN @WIRE(mode="straight", linewidth=.16) {#CBN:p (150, -162)};
//  (150, -160) @TEXT("BN", size=1, bold=true, halign="middle");
//  %g_CBN = $GROUND @ATTACH &VSS => @PLACE(150, -178);
//  &VSS @WIRE(mode="straight", linewidth=.16) {#CBN:n %g_CBN:p};
//  {#CXP #CXN} @AS $MATCHED;
//  {#CRP #CRN} @AS $MATCHED;
//  {#CBP #CBN} @AS $MATCHED;
//  (0, -190) @TEXT("Physical low-level pull-ups and output diode loads; all DC current is measured", size=1.3, bold=true, halign="middle");
//  #MUPRP1 @PLACE(-189, -212) => @ORIENT("R0");
//  #MUPRP1 @TEXT("MUPRP1", key="name", size=.8, halign="start") => @PLACE(-186, -210.5);
//  #MUPRP1 @TEXT("0.5um/100nm", key="dims", size=.8, halign="start") => @PLACE(-186, -213.5);
//  %s_MUPRP1 = $SUPPLY @ATTACH &AVDD => @PLACE(-189, -204);
//  &AVDD @WIRE(mode="straight", linewidth=.16) {#MUPRP1:s %s_MUPRP1:p};
//  &AVDD @WIRE(mode="straight", linewidth=.16) {#MUPRP1:b (-187, -212) (-187, -204) %s_MUPRP1:p};
//  %g_MUPRP1 = $GROUND @ATTACH &VSS => @PLACE(-199, -218);
//  &VSS @WIRE(mode="straight", linewidth=.16) {#MUPRP1:g (-199, -212) %g_MUPRP1:p};
//  &RP @WIRE(mode="straight", linewidth=.16) {#MUPRP1:d (-189, -222)};
//  (-189, -225) @TEXT("RP", size=.9, bold=true, halign="middle");
//  (-161, -225) @TEXT("RP", size=.9, bold=true, halign="middle");
//  #MUPRN1 @PLACE(-119, -212) => @ORIENT("R0");
//  #MUPRN1 @TEXT("MUPRN1", key="name", size=.8, halign="start") => @PLACE(-116, -210.5);
//  #MUPRN1 @TEXT("0.5um/100nm", key="dims", size=.8, halign="start") => @PLACE(-116, -213.5);
//  %s_MUPRN1 = $SUPPLY @ATTACH &AVDD => @PLACE(-119, -204);
//  &AVDD @WIRE(mode="straight", linewidth=.16) {#MUPRN1:s %s_MUPRN1:p};
//  &AVDD @WIRE(mode="straight", linewidth=.16) {#MUPRN1:b (-117, -212) (-117, -204) %s_MUPRN1:p};
//  %g_MUPRN1 = $GROUND @ATTACH &VSS => @PLACE(-129, -218);
//  &VSS @WIRE(mode="straight", linewidth=.16) {#MUPRN1:g (-129, -212) %g_MUPRN1:p};
//  &RN @WIRE(mode="straight", linewidth=.16) {#MUPRN1:d (-119, -222)};
//  (-119, -225) @TEXT("RN", size=.9, bold=true, halign="middle");
//  (-91, -225) @TEXT("RN", size=.9, bold=true, halign="middle");
//  #MUPBP1 @PLACE(-49, -212) => @ORIENT("R0");
//  #MUPBP1 @TEXT("MUPBP1", key="name", size=.8, halign="start") => @PLACE(-46, -210.5);
//  #MUPBP1 @TEXT("0.5um/100nm", key="dims", size=.8, halign="start") => @PLACE(-46, -213.5);
//  %s_MUPBP1 = $SUPPLY @ATTACH &AVDD => @PLACE(-49, -204);
//  &AVDD @WIRE(mode="straight", linewidth=.16) {#MUPBP1:s %s_MUPBP1:p};
//  &AVDD @WIRE(mode="straight", linewidth=.16) {#MUPBP1:b (-47, -212) (-47, -204) %s_MUPBP1:p};
//  %g_MUPBP1 = $GROUND @ATTACH &VSS => @PLACE(-59, -218);
//  &VSS @WIRE(mode="straight", linewidth=.16) {#MUPBP1:g (-59, -212) %g_MUPBP1:p};
//  &BP @WIRE(mode="straight", linewidth=.16) {#MUPBP1:d (-49, -222)};
//  (-49, -225) @TEXT("BP", size=.9, bold=true, halign="middle");
//  (-21, -225) @TEXT("BP", size=.9, bold=true, halign="middle");
//  #MUPBN1 @PLACE(21, -212) => @ORIENT("R0");
//  #MUPBN1 @TEXT("MUPBN1", key="name", size=.8, halign="start") => @PLACE(24, -210.5);
//  #MUPBN1 @TEXT("0.5um/100nm", key="dims", size=.8, halign="start") => @PLACE(24, -213.5);
//  %s_MUPBN1 = $SUPPLY @ATTACH &AVDD => @PLACE(21, -204);
//  &AVDD @WIRE(mode="straight", linewidth=.16) {#MUPBN1:s %s_MUPBN1:p};
//  &AVDD @WIRE(mode="straight", linewidth=.16) {#MUPBN1:b (23, -212) (23, -204) %s_MUPBN1:p};
//  %g_MUPBN1 = $GROUND @ATTACH &VSS => @PLACE(11, -218);
//  &VSS @WIRE(mode="straight", linewidth=.16) {#MUPBN1:g (11, -212) %g_MUPBN1:p};
//  &BN @WIRE(mode="straight", linewidth=.16) {#MUPBN1:d (21, -222)};
//  (21, -225) @TEXT("BN", size=.9, bold=true, halign="middle");
//  (49, -225) @TEXT("BN", size=.9, bold=true, halign="middle");
//  #MUPOUTP1 @PLACE(91, -212) => @ORIENT("R0");
//  #MUPOUTP1 @TEXT("MUPOUTP1", key="name", size=.8, halign="start") => @PLACE(94, -210.5);
//  #MUPOUTP1 @TEXT("0.5um/100nm", key="dims", size=.8, halign="start") => @PLACE(94, -213.5);
//  %s_MUPOUTP1 = $SUPPLY @ATTACH &AVDD => @PLACE(91, -204);
//  &AVDD @WIRE(mode="straight", linewidth=.16) {#MUPOUTP1:s %s_MUPOUTP1:p};
//  &AVDD @WIRE(mode="straight", linewidth=.16) {#MUPOUTP1:b (93, -212) (93, -204) %s_MUPOUTP1:p};
//  %g_MUPOUTP1 = $GROUND @ATTACH &VSS => @PLACE(81, -218);
//  &VSS @WIRE(mode="straight", linewidth=.16) {#MUPOUTP1:g (81, -212) %g_MUPOUTP1:p};
//  &OUTP @WIRE(mode="straight", linewidth=.16) {#MUPOUTP1:d (91, -222)};
//  (91, -225) @TEXT("OUTP", size=.9, bold=true, halign="middle");
//  (119, -225) @TEXT("OUTP", size=.9, bold=true, halign="middle");
//  #MUPOUTN1 @PLACE(161, -212) => @ORIENT("R0");
//  #MUPOUTN1 @TEXT("MUPOUTN1", key="name", size=.8, halign="start") => @PLACE(164, -210.5);
//  #MUPOUTN1 @TEXT("0.5um/100nm", key="dims", size=.8, halign="start") => @PLACE(164, -213.5);
//  %s_MUPOUTN1 = $SUPPLY @ATTACH &AVDD => @PLACE(161, -204);
//  &AVDD @WIRE(mode="straight", linewidth=.16) {#MUPOUTN1:s %s_MUPOUTN1:p};
//  &AVDD @WIRE(mode="straight", linewidth=.16) {#MUPOUTN1:b (163, -212) (163, -204) %s_MUPOUTN1:p};
//  %g_MUPOUTN1 = $GROUND @ATTACH &VSS => @PLACE(151, -218);
//  &VSS @WIRE(mode="straight", linewidth=.16) {#MUPOUTN1:g (151, -212) %g_MUPOUTN1:p};
//  &OUTN @WIRE(mode="straight", linewidth=.16) {#MUPOUTN1:d (161, -222)};
//  (161, -225) @TEXT("OUTN", size=.9, bold=true, halign="middle");
//  (189, -225) @TEXT("OUTN", size=.9, bold=true, halign="middle");
//  #MDNOUTP1 @PLACE(-70, -252) => @ORIENT("R0");
//  #MDNOUTP1 @TEXT("MDNOUTP1", key="name", size=.8, halign="start") => @PLACE(-67, -250.5);
//  #MDNOUTP1 @TEXT("0.5um/500nm", key="dims", size=.8, halign="start") => @PLACE(-67, -253.5);
//  %s_MDNOUTP1 = $GROUND @ATTACH &VSS => @PLACE(-70, -262);
//  &VSS @WIRE(mode="straight", linewidth=.16) {#MDNOUTP1:s %s_MDNOUTP1:p};
//  &VSS @WIRE(mode="straight", linewidth=.16) {#MDNOUTP1:b (-68, -252) (-68, -262) %s_MDNOUTP1:p};
//  %d_MDNOUTP1 = (-70, -244);
//  $JUNCTION @ATTACH %d_MDNOUTP1;
//  &OUTP @WIRE(mode="straight", linewidth=.16) {#MDNOUTP1:d %d_MDNOUTP1 (-78, -244) (-78, -252) #MDNOUTP1:g};
//  (-70, -242) @TEXT("OUTP", size=.9, bold=true, halign="middle");
//  #MDNOUTP2 @PLACE(-40, -252) => @ORIENT("R0");
//  #MDNOUTP2 @TEXT("MDNOUTP2", key="name", size=.8, halign="start") => @PLACE(-37, -250.5);
//  #MDNOUTP2 @TEXT("0.5um/500nm", key="dims", size=.8, halign="start") => @PLACE(-37, -253.5);
//  %s_MDNOUTP2 = $GROUND @ATTACH &VSS => @PLACE(-40, -262);
//  &VSS @WIRE(mode="straight", linewidth=.16) {#MDNOUTP2:s %s_MDNOUTP2:p};
//  &VSS @WIRE(mode="straight", linewidth=.16) {#MDNOUTP2:b (-38, -252) (-38, -262) %s_MDNOUTP2:p};
//  %d_MDNOUTP2 = (-40, -244);
//  $JUNCTION @ATTACH %d_MDNOUTP2;
//  &OUTP @WIRE(mode="straight", linewidth=.16) {#MDNOUTP2:d %d_MDNOUTP2 (-48, -244) (-48, -252) #MDNOUTP2:g};
//  (-40, -242) @TEXT("OUTP", size=.9, bold=true, halign="middle");
//  #MDNOUTN1 @PLACE(40, -252) => @ORIENT("R0");
//  #MDNOUTN1 @TEXT("MDNOUTN1", key="name", size=.8, halign="start") => @PLACE(43, -250.5);
//  #MDNOUTN1 @TEXT("0.5um/500nm", key="dims", size=.8, halign="start") => @PLACE(43, -253.5);
//  %s_MDNOUTN1 = $GROUND @ATTACH &VSS => @PLACE(40, -262);
//  &VSS @WIRE(mode="straight", linewidth=.16) {#MDNOUTN1:s %s_MDNOUTN1:p};
//  &VSS @WIRE(mode="straight", linewidth=.16) {#MDNOUTN1:b (42, -252) (42, -262) %s_MDNOUTN1:p};
//  %d_MDNOUTN1 = (40, -244);
//  $JUNCTION @ATTACH %d_MDNOUTN1;
//  &OUTN @WIRE(mode="straight", linewidth=.16) {#MDNOUTN1:d %d_MDNOUTN1 (32, -244) (32, -252) #MDNOUTN1:g};
//  (40, -242) @TEXT("OUTN", size=.9, bold=true, halign="middle");
//  #MDNOUTN2 @PLACE(70, -252) => @ORIENT("R0");
//  #MDNOUTN2 @TEXT("MDNOUTN2", key="name", size=.8, halign="start") => @PLACE(73, -250.5);
//  #MDNOUTN2 @TEXT("0.5um/500nm", key="dims", size=.8, halign="start") => @PLACE(73, -253.5);
//  %s_MDNOUTN2 = $GROUND @ATTACH &VSS => @PLACE(70, -262);
//  &VSS @WIRE(mode="straight", linewidth=.16) {#MDNOUTN2:s %s_MDNOUTN2:p};
//  &VSS @WIRE(mode="straight", linewidth=.16) {#MDNOUTN2:b (72, -252) (72, -262) %s_MDNOUTN2:p};
//  %d_MDNOUTN2 = (70, -244);
//  $JUNCTION @ATTACH %d_MDNOUTN2;
//  &OUTN @WIRE(mode="straight", linewidth=.16) {#MDNOUTN2:d %d_MDNOUTN2 (62, -244) (62, -252) #MDNOUTN2:g};
//  (70, -242) @TEXT("OUTN", size=.9, bold=true, halign="middle");
//  {#MUPRP1 #MUPRN1} @AS $MATCHED;
//  {#MUPBP1 #MUPBN1} @AS $MATCHED;
//  {#MUPOUTP1 #MUPOUTN1} @AS $MATCHED;
//  {#MDNOUTP1 #MDNOUTN1} @AS $MATCHED;
//  {#MDNOUTP2 #MDNOUTN2} @AS $MATCHED;
//  (0, -282) @TEXT("CKB rail loads limit feedthrough; their persistent current is included", size=1.2, bold=true, halign="middle");
//  #MCKUP @PLACE(-65, -301) => @ORIENT("R0");
//  #MCKUP @TEXT("MCKUP", key="name", size=1, halign="start") => @PLACE(-62, -299.5);
//  #MCKUP @TEXT("0.5um/100nm nf1", key="dims", size=.9, halign="start") => @PLACE(-62, -302.5);
//  %s_MCKUP = $SUPPLY @ATTACH &AVDD => @PLACE(-65, -291);
//  &AVDD @WIRE(mode="straight", linewidth=.16) {#MCKUP:s %s_MCKUP:p};
//  &AVDD @WIRE(mode="straight", linewidth=.16) {#MCKUP:b (-63, -301) (-63, -291) %s_MCKUP:p};
//  %g_MCKUP = $GROUND @ATTACH &VSS => @PLACE(-77, -307);
//  &VSS @WIRE(mode="straight", linewidth=.16) {#MCKUP:g (-77, -301) %g_MCKUP:p};
//  &CKB @WIRE(mode="straight", linewidth=.16) {#MCKUP:d (-65, -311)};
//  (-65, -314) @TEXT("CKB", size=1, halign="middle");
//  #MBLEED @PLACE(65, -301) => @ORIENT("R0");
//  #MBLEED @TEXT("MBLEED", key="name", size=1, halign="start") => @PLACE(68, -299.5);
//  #MBLEED @TEXT("0.5um/500nm nf1", key="dims", size=.9, halign="start") => @PLACE(68, -302.5);
//  %s_MBLEED = $GROUND @ATTACH &VSS => @PLACE(65, -311);
//  &VSS @WIRE(mode="straight", linewidth=.16) {#MBLEED:s %s_MBLEED:p};
//  &VSS @WIRE(mode="straight", linewidth=.16) {#MBLEED:b (67, -301) (67, -311) %s_MBLEED:p};
//  %g_MBLEED = $SUPPLY @ATTACH &AVDD => @PLACE(53, -295);
//  &AVDD @WIRE(mode="straight", linewidth=.16) {#MBLEED:g (53, -301) %g_MBLEED:p};
//  &CKB @WIRE(mode="straight", linewidth=.16) {#MBLEED:d (65, -291)};
//  (65, -288) @TEXT("CKB", size=1, halign="middle");
//  (0, -329) @TEXT("XP/XN weak pull-ups limit input-stage negative feedthrough", size=1.2, bold=true, halign="middle");
//  #MUPXP @PLACE(-65, -348) => @ORIENT("R0");
//  #MUPXP @TEXT("MUPXP", key="name", size=1, halign="start") => @PLACE(-62, -346.5);
//  #MUPXP @TEXT("0.5um/100nm nf1", key="dims", size=.9, halign="start") => @PLACE(-62, -349.5);
//  %s_MUPXP = $SUPPLY @ATTACH &AVDD => @PLACE(-65, -338);
//  &AVDD @WIRE(mode="straight", linewidth=.16) {#MUPXP:s %s_MUPXP:p};
//  &AVDD @WIRE(mode="straight", linewidth=.16) {#MUPXP:b (-63, -348) (-63, -338) %s_MUPXP:p};
//  %g_MUPXP = $GROUND @ATTACH &VSS => @PLACE(-77, -354);
//  &VSS @WIRE(mode="straight", linewidth=.16) {#MUPXP:g (-77, -348) %g_MUPXP:p};
//  &XP @WIRE(mode="straight", linewidth=.16) {#MUPXP:d (-65, -358)};
//  (-65, -361) @TEXT("XP", size=1, halign="middle");
//  #MUPXN @PLACE(65, -348) => @ORIENT("R0");
//  #MUPXN @TEXT("MUPXN", key="name", size=1, halign="start") => @PLACE(68, -346.5);
//  #MUPXN @TEXT("0.5um/100nm nf1", key="dims", size=.9, halign="start") => @PLACE(68, -349.5);
//  %s_MUPXN = $SUPPLY @ATTACH &AVDD => @PLACE(65, -338);
//  &AVDD @WIRE(mode="straight", linewidth=.16) {#MUPXN:s %s_MUPXN:p};
//  &AVDD @WIRE(mode="straight", linewidth=.16) {#MUPXN:b (67, -348) (67, -338) %s_MUPXN:p};
//  %g_MUPXN = $GROUND @ATTACH &VSS => @PLACE(53, -354);
//  &VSS @WIRE(mode="straight", linewidth=.16) {#MUPXN:g (53, -348) %g_MUPXN:p};
//  &XN @WIRE(mode="straight", linewidth=.16) {#MUPXN:d (65, -358)};
//  (65, -361) @TEXT("XN", size=1, halign="middle");
//  {#MUPXP #MUPXN} @AS $MATCHED;
// }
ends adc_comp
