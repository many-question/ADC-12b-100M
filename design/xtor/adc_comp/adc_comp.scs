// adc_comp: two-stage dynamic preamplifier and complementary regenerative latch
// @RNL(type="header") {
//   @VERSION("0.3");
//   @USE-PACKAGE(name="adc28", version="0.1", path="../../rnl/adc28.rnl")
// }
simulator lang=spectre

subckt adc_comp (INP INN CLKC OUTP OUTN AVDD VSS)
// Reset: CLKC=0, CLKB=1; P=N=AVDD and UP=UN=OUTP=OUTN=VSS.
// Evaluate: INP>INN lowers P first; PMOS M2P then raises UP and OUTP.
// Stage 1 and stage 2 have independent tail devices and complementary input pairs.
// Logical MOS devices are parallel single-finger units (nf=1, integer m).
// Exploratory pre-layout design; not yet a verified reproduction of a literature circuit.
MIP (P INP T1 VSS) nch_ulvt_mac w=1u l=30n nf=1 m=40
MIN (N INN T1 VSS) nch_ulvt_mac w=1u l=30n nf=1 m=40
MT1 (T1 CLKC VSS VSS) nch_ulvt_mac w=0.75u l=30n nf=1 m=2
MRP (P CLKC AVDD AVDD) pch_ulvt_mac w=1u l=30n nf=1 m=2
MRN (N CLKC AVDD AVDD) pch_ulvt_mac w=1u l=30n nf=1 m=2
MT2 (T2 CLKB AVDD AVDD) pch_ulvt_mac w=1u l=30n nf=1 m=8
M2P (UP P T2 AVDD) pch_ulvt_mac w=1u l=30n nf=1 m=3
M2N (UN N T2 AVDD) pch_ulvt_mac w=1u l=30n nf=1 m=3
MLPP (OUTP OUTN UP AVDD) pch_ulvt_mac w=1u l=30n nf=1 m=3
MLPN (OUTN OUTP UN AVDD) pch_ulvt_mac w=1u l=30n nf=1 m=3
MLNP (OUTP OUTN VSS VSS) nch_ulvt_mac w=1u l=30n nf=1 m=2
MLNN (OUTN OUTP VSS VSS) nch_ulvt_mac w=1u l=30n nf=1 m=2
MRUP (UP CLKB VSS VSS) nch_ulvt_mac w=1u l=30n nf=1 m=2
MRUN (UN CLKB VSS VSS) nch_ulvt_mac w=1u l=30n nf=1 m=2
MROP (OUTP CLKB VSS VSS) nch_ulvt_mac w=1u l=30n nf=1 m=2
MRON (OUTN CLKB VSS VSS) nch_ulvt_mac w=1u l=30n nf=1 m=2
MCKP (CLKB CLKC AVDD AVDD) pch_ulvt_mac w=1u l=30n nf=1 m=3
MCKN (CLKB CLKC VSS VSS) nch_ulvt_mac w=0.75u l=30n nf=1 m=2
// @RNL {
//   &AVDD @ADD-TO $SUPPLY_NET_SET;
//   &VSS @ADD-TO $GROUND_NET_SET;
//   %preamp = #MIP(in_p) #MIN(in_n) #MT1(tail) @AS $DIFFERENTIAL_PAIR;
//   $PMOS_DYNAMIC_INPUT = @DEFINE(roles=["p", "n", "tail"]) { {?p ?n ?tail} @GROUP };
//   %second_input = #M2P(p) #M2N(n) #MT2(tail) @AS $PMOS_DYNAMIC_INPUT;
//   $REGENERATIVE_QUAD = @DEFINE(roles=["p1", "p2", "n1", "n2"]) { {?p1 ?p2 ?n1 ?n2} @GROUP };
//   %latch = #MLPP(p1) #MLPN(p2) #MLNP(n1) #MLNN(n2) @AS $REGENERATIVE_QUAD;
//   {#MIP #MIN} @AS $MATCHED;
//   {#MRP #MRN} @AS $MATCHED;
//   {#M2P #M2N} @AS $MATCHED;
//   {#MLPP #MLPN} @AS $MATCHED;
//   {#MLNP #MLNN} @AS $MATCHED;
//   {#MRUP #MRUN} @AS $MATCHED;
//   {#MROP #MRON} @AS $MATCHED;
//   {#MRUP #MRUN #MROP #MRON} @GROUP;
//   {#MCKP #MCKN} @GROUP;
//   #MIP @PLACE(-12, 0) => @ORIENT("R0");
//   #MIP @TEXT("40 x 1u/30n", key="model", size=0.65, dx=4, dy=-1, halign="start");
//   %b_MIP = $GROUND @ATTACH &VSS => @PLACE(-10, -4);
//   &VSS @WIRE {#MIP:b (-10, 0) %b_MIP:p};
//   #MIN @PLACE(12, 0) => @ORIENT("MY");
//   #MIN @TEXT("40 x 1u/30n", key="model", size=0.65, dx=-4, dy=-1, halign="end");
//   %b_MIN = $GROUND @ATTACH &VSS => @PLACE(10, -4);
//   &VSS @WIRE {#MIN:b (10, 0) %b_MIN:p};
//   #MT1 @PLACE(0, -12) => @ORIENT("R0");
//   #MT1 @TEXT("2 x 0.75u/30n", key="model", size=0.65, dx=4, dy=-1, halign="start");
//   %b_MT1 = $GROUND @ATTACH &VSS => @PLACE(2, -16);
//   &VSS @WIRE {#MT1:b (2, -12) %b_MT1:p};
//   %s_MT1 = $GROUND @ATTACH &VSS => @PLACE(0, -18);
//   &VSS @WIRE {#MT1:s %s_MT1:p};
//   %clk_MT1 = $IO_PORT @ATTACH &CLKC => @PLACE(-8, -12) => @ORIENT("R0");
//   &CLKC @WIRE {%clk_MT1:p #MT1:g};
//   #MRP @PLACE(-12, 12) => @ORIENT("R0");
//   #MRP @TEXT("2 x 1u/30n", key="model", size=0.65, dx=4, dy=-1, halign="start");
//   %b_MRP = $SUPPLY @ATTACH &AVDD => @PLACE(-10, 16);
//   &AVDD @WIRE {#MRP:b (-10, 12) %b_MRP:p};
//   %s_MRP = $SUPPLY @ATTACH &AVDD => @PLACE(-12, 18);
//   &AVDD @WIRE {#MRP:s %s_MRP:p};
//   %clk_MRP = $IO_PORT @ATTACH &CLKC => @PLACE(-20, 12) => @ORIENT("R0");
//   &CLKC @WIRE {%clk_MRP:p #MRP:g};
//   #MRN @PLACE(12, 12) => @ORIENT("MY");
//   #MRN @TEXT("2 x 1u/30n", key="model", size=0.65, dx=-4, dy=-1, halign="end");
//   %b_MRN = $SUPPLY @ATTACH &AVDD => @PLACE(10, 16);
//   &AVDD @WIRE {#MRN:b (10, 12) %b_MRN:p};
//   %s_MRN = $SUPPLY @ATTACH &AVDD => @PLACE(12, 18);
//   &AVDD @WIRE {#MRN:s %s_MRN:p};
//   %clk_MRN = $IO_PORT @ATTACH &CLKC => @PLACE(20, 12) => @ORIENT("MY");
//   &CLKC @WIRE {%clk_MRN:p #MRN:g};
//   #MT2 @PLACE(70, 36) => @ORIENT("R0");
//   #MT2 @TEXT("8 x 1u/30n", key="model", size=0.65, dx=4, dy=-1, halign="start");
//   %b_MT2 = $SUPPLY @ATTACH &AVDD => @PLACE(72, 40);
//   &AVDD @WIRE {#MT2:b (72, 36) %b_MT2:p};
//   %s_MT2 = $SUPPLY @ATTACH &AVDD => @PLACE(70, 42);
//   &AVDD @WIRE {#MT2:s %s_MT2:p};
//   %clk_MT2 = $IO_PORT @ATTACH &CLKB => @PLACE(62, 36) => @ORIENT("R0");
//   &CLKB @WIRE {%clk_MT2:p #MT2:g};
//   #M2P @PLACE(54, 24) => @ORIENT("R0");
//   #M2P @TEXT("3 x 1u/30n", key="model", size=0.65, dx=4, dy=-1, halign="start");
//   %b_M2P = $SUPPLY @ATTACH &AVDD => @PLACE(56, 28);
//   &AVDD @WIRE {#M2P:b (56, 24) %b_M2P:p};
//   #M2N @PLACE(86, 24) => @ORIENT("MY");
//   #M2N @TEXT("3 x 1u/30n", key="model", size=0.65, dx=-4, dy=-1, halign="end");
//   %b_M2N = $SUPPLY @ATTACH &AVDD => @PLACE(84, 28);
//   &AVDD @WIRE {#M2N:b (84, 24) %b_M2N:p};
//   #MLPP @PLACE(54, 10) => @ORIENT("R0");
//   #MLPP @TEXT("3 x 1u/30n", key="model", size=0.65, dx=4, dy=-1, halign="start");
//   %b_MLPP = $SUPPLY @ATTACH &AVDD => @PLACE(56, 14);
//   &AVDD @WIRE {#MLPP:b (56, 10) %b_MLPP:p};
//   #MLPN @PLACE(86, 10) => @ORIENT("MY");
//   #MLPN @TEXT("3 x 1u/30n", key="model", size=0.65, dx=-4, dy=-1, halign="end");
//   %b_MLPN = $SUPPLY @ATTACH &AVDD => @PLACE(84, 14);
//   &AVDD @WIRE {#MLPN:b (84, 10) %b_MLPN:p};
//   #MLNP @PLACE(54, -4) => @ORIENT("R0");
//   #MLNP @TEXT("2 x 1u/30n", key="model", size=0.65, dx=4, dy=-1, halign="start");
//   %b_MLNP = $GROUND @ATTACH &VSS => @PLACE(56, -8);
//   &VSS @WIRE {#MLNP:b (56, -4) %b_MLNP:p};
//   %s_MLNP = $GROUND @ATTACH &VSS => @PLACE(54, -10);
//   &VSS @WIRE {#MLNP:s %s_MLNP:p};
//   #MLNN @PLACE(86, -4) => @ORIENT("MY");
//   #MLNN @TEXT("2 x 1u/30n", key="model", size=0.65, dx=-4, dy=-1, halign="end");
//   %b_MLNN = $GROUND @ATTACH &VSS => @PLACE(84, -8);
//   &VSS @WIRE {#MLNN:b (84, -4) %b_MLNN:p};
//   %s_MLNN = $GROUND @ATTACH &VSS => @PLACE(86, -10);
//   &VSS @WIRE {#MLNN:s %s_MLNN:p};
//   #MRUP @PLACE(38, 10) => @ORIENT("R0");
//   #MRUP @TEXT("2 x 1u/30n", key="model", size=0.65, dx=4, dy=-1, halign="start");
//   %b_MRUP = $GROUND @ATTACH &VSS => @PLACE(40, 6);
//   &VSS @WIRE {#MRUP:b (40, 10) %b_MRUP:p};
//   %s_MRUP = $GROUND @ATTACH &VSS => @PLACE(38, 4);
//   &VSS @WIRE {#MRUP:s %s_MRUP:p};
//   %clk_MRUP = $IO_PORT @ATTACH &CLKB => @PLACE(30, 10) => @ORIENT("R0");
//   &CLKB @WIRE {%clk_MRUP:p #MRUP:g};
//   #MRUN @PLACE(102, 10) => @ORIENT("MY");
//   #MRUN @TEXT("2 x 1u/30n", key="model", size=0.65, dx=-4, dy=-1, halign="end");
//   %b_MRUN = $GROUND @ATTACH &VSS => @PLACE(100, 6);
//   &VSS @WIRE {#MRUN:b (100, 10) %b_MRUN:p};
//   %s_MRUN = $GROUND @ATTACH &VSS => @PLACE(102, 4);
//   &VSS @WIRE {#MRUN:s %s_MRUN:p};
//   %clk_MRUN = $IO_PORT @ATTACH &CLKB => @PLACE(110, 10) => @ORIENT("MY");
//   &CLKB @WIRE {%clk_MRUN:p #MRUN:g};
//   #MROP @PLACE(38, -4) => @ORIENT("R0");
//   #MROP @TEXT("2 x 1u/30n", key="model", size=0.65, dx=4, dy=-1, halign="start");
//   %b_MROP = $GROUND @ATTACH &VSS => @PLACE(40, -8);
//   &VSS @WIRE {#MROP:b (40, -4) %b_MROP:p};
//   %s_MROP = $GROUND @ATTACH &VSS => @PLACE(38, -10);
//   &VSS @WIRE {#MROP:s %s_MROP:p};
//   %clk_MROP = $IO_PORT @ATTACH &CLKB => @PLACE(30, -4) => @ORIENT("R0");
//   &CLKB @WIRE {%clk_MROP:p #MROP:g};
//   #MRON @PLACE(102, -4) => @ORIENT("MY");
//   #MRON @TEXT("2 x 1u/30n", key="model", size=0.65, dx=-4, dy=-1, halign="end");
//   %b_MRON = $GROUND @ATTACH &VSS => @PLACE(100, -8);
//   &VSS @WIRE {#MRON:b (100, -4) %b_MRON:p};
//   %s_MRON = $GROUND @ATTACH &VSS => @PLACE(102, -10);
//   &VSS @WIRE {#MRON:s %s_MRON:p};
//   %clk_MRON = $IO_PORT @ATTACH &CLKB => @PLACE(110, -4) => @ORIENT("MY");
//   &CLKB @WIRE {%clk_MRON:p #MRON:g};
//   #MCKP @PLACE(132, 12) => @ORIENT("R0");
//   #MCKP @TEXT("3 x 1u/30n", key="model", size=0.65, dx=4, dy=-1, halign="start");
//   %b_MCKP = $SUPPLY @ATTACH &AVDD => @PLACE(134, 16);
//   &AVDD @WIRE {#MCKP:b (134, 12) %b_MCKP:p};
//   %s_MCKP = $SUPPLY @ATTACH &AVDD => @PLACE(132, 18);
//   &AVDD @WIRE {#MCKP:s %s_MCKP:p};
//   #MCKN @PLACE(132, 0) => @ORIENT("R0");
//   #MCKN @TEXT("2 x 0.75u/30n", key="model", size=0.65, dx=4, dy=-1, halign="start");
//   %b_MCKN = $GROUND @ATTACH &VSS => @PLACE(134, -4);
//   &VSS @WIRE {#MCKN:b (134, 0) %b_MCKN:p};
//   %s_MCKN = $GROUND @ATTACH &VSS => @PLACE(132, -6);
//   &VSS @WIRE {#MCKN:s %s_MCKN:p};
//   %inp = $IO_PORT @ATTACH &INP => @PLACE(-24, 0) => @ORIENT("R0");
//   &INP @WIRE {%inp:p #MIP:g};
//   %inn = $IO_PORT @ATTACH &INN => @PLACE(24, 0) => @ORIENT("MY");
//   &INN @WIRE {%inn:p #MIN:g};
//   %tail1 = (0, -6);
//   $JUNCTION @ATTACH %tail1;
//   &T1 @WIRE {#MIP:s (-12, -6) %tail1 (12, -6) #MIN:s};
//   &T1 @WIRE {%tail1 #MT1:d};
//   %pa_P = (-12, 6);
//   $JUNCTION @ATTACH %pa_P;
//   &P @WIRE {#MIP:d %pa_P #MRP:d};
//   %pa_port_P = $IO_PORT @ATTACH &P => @PLACE(-4, 6) => @ORIENT("MY");
//   &P @WIRE {%pa_P %pa_port_P:p};
//   %pa_N = (12, 6);
//   $JUNCTION @ATTACH %pa_N;
//   &N @WIRE {#MIN:d %pa_N #MRN:d};
//   %pa_port_N = $IO_PORT @ATTACH &N => @PLACE(4, 6) => @ORIENT("R0");
//   &N @WIRE {%pa_N %pa_port_N:p};
//   %tail2 = (70, 30);
//   $JUNCTION @ATTACH %tail2;
//   &T2 @WIRE {#M2P:s (54, 30) %tail2 (86, 30) #M2N:s};
//   &T2 @WIRE {%tail2 #MT2:d};
//   %s2p = $IO_PORT @ATTACH &P => @PLACE(44, 24) => @ORIENT("R0");
//   &P @WIRE {%s2p:p #M2P:g};
//   %s2n = $IO_PORT @ATTACH &N => @PLACE(96, 24) => @ORIENT("MY");
//   &N @WIRE {%s2n:p #M2N:g};
//   %up = (54, 18);
//   $JUNCTION @ATTACH %up;
//   &UP @WIRE {#M2P:d %up #MLPP:s};
//   &UP @WIRE {%up (38, 18) #MRUP:d};
//   %un = (86, 18);
//   $JUNCTION @ATTACH %un;
//   &UN @WIRE {#M2N:d %un #MLPN:s};
//   &UN @WIRE {%un (102, 18) #MRUN:d};
//   %op = (54, 3);
//   $JUNCTION @ATTACH %op;
//   %on = (86, 3);
//   $JUNCTION @ATTACH %on;
//   &OUTP @WIRE {#MLPP:d %op #MLNP:d};
//   &OUTN @WIRE {#MLPN:d %on #MLNN:d};
//   &OUTP @WIRE {%op (38, 3) #MROP:d};
//   &OUTN @WIRE {%on (102, 3) #MRON:d};
//   %feedback_p = (92, 5);
//   $JUNCTION @ATTACH %feedback_p;
//   %feedback_n = (48, 1);
//   $JUNCTION @ATTACH %feedback_n;
//   &OUTP @WIRE {%op (66, 3) (66, 5) %feedback_p};
//   &OUTP @WIRE {#MLPN:g (92, 10) %feedback_p (92, -4) #MLNN:g};
//   &OUTN @WIRE {%on (74, 3) (74, 1) %feedback_n};
//   &OUTN @WIRE {#MLPP:g (48, 10) %feedback_n (48, -4) #MLNP:g};
//   %outp = $IO_PORT @ATTACH &OUTP => @PLACE(60, 3) => @ORIENT("MY");
//   &OUTP @WIRE {%op %outp:p};
//   %outn = $IO_PORT @ATTACH &OUTN => @PLACE(80, 3) => @ORIENT("R0");
//   &OUTN @WIRE {%on %outn:p};
//   %ck = (126, 6);
//   $JUNCTION @ATTACH %ck;
//   &CLKC @WIRE {#MCKP:g (126, 12) %ck (126, 0) #MCKN:g};
//   %cki = $IO_PORT @ATTACH &CLKC => @PLACE(120, 6) => @ORIENT("R0");
//   &CLKC @WIRE {%cki:p %ck};
//   %cb = (132, 6);
//   $JUNCTION @ATTACH %cb;
//   &CLKB @WIRE {#MCKP:d %cb #MCKN:d};
//   %cko = $IO_PORT @ATTACH &CLKB => @PLACE(140, 6) => @ORIENT("MY");
//   &CLKB @WIRE {%cb %cko:p};
//   (-30, 48) @TEXT("adc_comp | two-stage dynamic comparator experiment", size=1.3, bold=true, halign="start");
//   (-24, 24) @TEXT("1. Dynamic preamplifier", size=1, bold=true, halign="start");
//   (38, 44) @TEXT("2. PMOS-input regenerative stage", size=1, bold=true, halign="start");
//   (118, 26) @TEXT("Clock inversion", size=1, bold=true, halign="start");
//   (-30, -24) @TEXT("Reset: P=N=AVDD; UP=UN=OUTP=OUTN=0. Two independent tail devices.", size=0.85, halign="start");
//   (-30, -27) @TEXT("Evaluate: INP>INN -> P falls faster -> M2P sources current first -> OUTP rises.", size=0.85, halign="start");
//   (-30, -30) @TEXT("Separate dynamic gain and regeneration; all results are exploratory, pre-layout, and not signed off.", size=0.85, halign="start");
// }
ends adc_comp
