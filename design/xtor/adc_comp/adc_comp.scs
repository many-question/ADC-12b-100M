// adc_comp: Miyahara self-timed two-stage comparator core (calibration omitted)
// @RNL(type="header") {
//   @VERSION("0.3");
//   @USE-PACKAGE(name="adc28", version="0.1", path="../../rnl/adc28.rnl")
// }
simulator lang=spectre

subckt adc_comp (INP INN CLKC OUTP OUTN AVDD VSS)
// Reset: CLKC=0; P=N=AVDD resets UP, UN and both outputs via NMOS.
// Evaluate: INP>INN lowers P first; PMOS M2P then raises UP and OUTP.
// Falling P/N self-time the second stage: PMOS input devices and NMOS resets share P/N.
// Logical MOS devices are parallel single-finger units (nf=1, integer m).
// Based on M1-M15 of Miyahara et al., A-SSCC 2008, Fig. 2(b), DOI 10.1109/ASSCC.2008.4708780.
MIP (P INP T1 VSS) nch_ulvt_mac w=1u l=30n nf=1 m=160 ad=7.5e-14 as=7.5e-14 pd=2.15e-06 ps=2.15e-06 nrd=0.289519 nrs=0.289519 sa=7.5e-08 sb=7.5e-08 sd=1e-07
MIN (N INN T1 VSS) nch_ulvt_mac w=1u l=30n nf=1 m=160 ad=7.5e-14 as=7.5e-14 pd=2.15e-06 ps=2.15e-06 nrd=0.289519 nrs=0.289519 sa=7.5e-08 sb=7.5e-08 sd=1e-07
MT1 (T1 CLKC VSS VSS) nch_ulvt_mac w=1u l=30n nf=1 m=6 ad=7.5e-14 as=7.5e-14 pd=2.15e-06 ps=2.15e-06 nrd=0.289519 nrs=0.289519 sa=7.5e-08 sb=7.5e-08 sd=1e-07
MRP (P CLKC AVDD AVDD) pch_ulvt_mac w=1u l=30n nf=1 m=12 ad=7.5e-14 as=7.5e-14 pd=2.15e-06 ps=2.15e-06 nrd=0.165806 nrs=0.165806 sa=7.5e-08 sb=7.5e-08 sd=1e-07
MRN (N CLKC AVDD AVDD) pch_ulvt_mac w=1u l=30n nf=1 m=12 ad=7.5e-14 as=7.5e-14 pd=2.15e-06 ps=2.15e-06 nrd=0.165806 nrs=0.165806 sa=7.5e-08 sb=7.5e-08 sd=1e-07
M2P (UP P AVDD AVDD) pch_ulvt_mac w=1u l=30n nf=1 m=6 ad=7.5e-14 as=7.5e-14 pd=2.15e-06 ps=2.15e-06 nrd=0.165806 nrs=0.165806 sa=7.5e-08 sb=7.5e-08 sd=1e-07
M2N (UN N AVDD AVDD) pch_ulvt_mac w=1u l=30n nf=1 m=6 ad=7.5e-14 as=7.5e-14 pd=2.15e-06 ps=2.15e-06 nrd=0.165806 nrs=0.165806 sa=7.5e-08 sb=7.5e-08 sd=1e-07
MLPP (OUTP OUTN UP AVDD) pch_ulvt_mac w=1u l=30n nf=1 m=6 ad=7.5e-14 as=7.5e-14 pd=2.15e-06 ps=2.15e-06 nrd=0.165806 nrs=0.165806 sa=7.5e-08 sb=7.5e-08 sd=1e-07
MLPN (OUTN OUTP UN AVDD) pch_ulvt_mac w=1u l=30n nf=1 m=6 ad=7.5e-14 as=7.5e-14 pd=2.15e-06 ps=2.15e-06 nrd=0.165806 nrs=0.165806 sa=7.5e-08 sb=7.5e-08 sd=1e-07
MLNP (OUTP OUTN VSS VSS) nch_ulvt_mac w=1u l=30n nf=1 m=4 ad=7.5e-14 as=7.5e-14 pd=2.15e-06 ps=2.15e-06 nrd=0.289519 nrs=0.289519 sa=7.5e-08 sb=7.5e-08 sd=1e-07
MLNN (OUTN OUTP VSS VSS) nch_ulvt_mac w=1u l=30n nf=1 m=4 ad=7.5e-14 as=7.5e-14 pd=2.15e-06 ps=2.15e-06 nrd=0.289519 nrs=0.289519 sa=7.5e-08 sb=7.5e-08 sd=1e-07
MRUP (UP P VSS VSS) nch_ulvt_mac w=1u l=30n nf=1 m=6 ad=7.5e-14 as=7.5e-14 pd=2.15e-06 ps=2.15e-06 nrd=0.289519 nrs=0.289519 sa=7.5e-08 sb=7.5e-08 sd=1e-07
MRUN (UN N VSS VSS) nch_ulvt_mac w=1u l=30n nf=1 m=6 ad=7.5e-14 as=7.5e-14 pd=2.15e-06 ps=2.15e-06 nrd=0.289519 nrs=0.289519 sa=7.5e-08 sb=7.5e-08 sd=1e-07
MROP (OUTP P VSS VSS) nch_ulvt_mac w=1u l=30n nf=1 m=6 ad=7.5e-14 as=7.5e-14 pd=2.15e-06 ps=2.15e-06 nrd=0.289519 nrs=0.289519 sa=7.5e-08 sb=7.5e-08 sd=1e-07
MRON (OUTN N VSS VSS) nch_ulvt_mac w=1u l=30n nf=1 m=6 ad=7.5e-14 as=7.5e-14 pd=2.15e-06 ps=2.15e-06 nrd=0.289519 nrs=0.289519 sa=7.5e-08 sb=7.5e-08 sd=1e-07
CINTP (P VSS) cfmom_2t nr=24 lr=1u w=50n s=50n stm=1 spm=3 multi=4
CINTN (N VSS) cfmom_2t nr=24 lr=1u w=50n s=50n stm=1 spm=3 multi=4
// @RNL {
//   &AVDD @ADD-TO $SUPPLY_NET_SET;
//   &VSS @ADD-TO $GROUND_NET_SET;
//   %preamp = #MIP(in_p) #MIN(in_n) #MT1(tail) @AS $DIFFERENTIAL_PAIR;
//   $PMOS_DYNAMIC_INPUT = @DEFINE(roles=["p", "n"]) { {?p ?n} @GROUP };
//   %second_input = #M2P(p) #M2N(n) @AS $PMOS_DYNAMIC_INPUT;
//   $REGENERATIVE_QUAD = @DEFINE(roles=["p1", "p2", "n1", "n2"]) { {?p1 ?p2 ?n1 ?n2} @GROUP };
//   %latch = #MLPP(p1) #MLPN(p2) #MLNP(n1) #MLNN(n2) @AS $REGENERATIVE_QUAD;
//   {#MIP #MIN} @AS $MATCHED;
//   {#MRP #MRN} @AS $MATCHED;
//   {#M2P #M2N} @AS $MATCHED;
//   {#MLPP #MLPN} @AS $MATCHED;
//   {#MLNP #MLNN} @AS $MATCHED;
//   {#MRUP #MRUN} @AS $MATCHED;
//   {#MROP #MRON} @AS $MATCHED;
//   {#MRUP #MRUN #MROP #MRON} @GROUP;
//   #MIP @PLACE(-12, 0) => @ORIENT("R0");
//   #MIP @TEXT("160 x 1u/30n", key="model", size=0.65, dx=4, dy=-1, halign="start");
//   %b_MIP = $GROUND @ATTACH &VSS => @PLACE(-10, -4);
//   &VSS @WIRE {#MIP:b (-10, 0) %b_MIP:p};
//   #MIN @PLACE(12, 0) => @ORIENT("MY");
//   #MIN @TEXT("160 x 1u/30n", key="model", size=0.65, dx=-4, dy=-1, halign="end");
//   %b_MIN = $GROUND @ATTACH &VSS => @PLACE(10, -4);
//   &VSS @WIRE {#MIN:b (10, 0) %b_MIN:p};
//   #MT1 @PLACE(0, -12) => @ORIENT("R0");
//   #MT1 @TEXT("6 x 1u/30n", key="model", size=0.65, dx=4, dy=-1, halign="start");
//   %b_MT1 = $GROUND @ATTACH &VSS => @PLACE(2, -16);
//   &VSS @WIRE {#MT1:b (2, -12) %b_MT1:p};
//   %s_MT1 = $GROUND @ATTACH &VSS => @PLACE(0, -18);
//   &VSS @WIRE {#MT1:s %s_MT1:p};
//   %clk_MT1 = $IO_PORT @ATTACH &CLKC => @PLACE(-8, -12) => @ORIENT("R0");
//   &CLKC @WIRE {%clk_MT1:p #MT1:g};
//   #MRP @PLACE(-12, 12) => @ORIENT("R0");
//   #MRP @TEXT("12 x 1u/30n", key="model", size=0.65, dx=4, dy=-1, halign="start");
//   %b_MRP = $SUPPLY @ATTACH &AVDD => @PLACE(-10, 16);
//   &AVDD @WIRE {#MRP:b (-10, 12) %b_MRP:p};
//   %s_MRP = $SUPPLY @ATTACH &AVDD => @PLACE(-12, 18);
//   &AVDD @WIRE {#MRP:s %s_MRP:p};
//   %clk_MRP = $IO_PORT @ATTACH &CLKC => @PLACE(-20, 12) => @ORIENT("R0");
//   &CLKC @WIRE {%clk_MRP:p #MRP:g};
//   #MRN @PLACE(12, 12) => @ORIENT("MY");
//   #MRN @TEXT("12 x 1u/30n", key="model", size=0.65, dx=-4, dy=-1, halign="end");
//   %b_MRN = $SUPPLY @ATTACH &AVDD => @PLACE(10, 16);
//   &AVDD @WIRE {#MRN:b (10, 12) %b_MRN:p};
//   %s_MRN = $SUPPLY @ATTACH &AVDD => @PLACE(12, 18);
//   &AVDD @WIRE {#MRN:s %s_MRN:p};
//   %clk_MRN = $IO_PORT @ATTACH &CLKC => @PLACE(20, 12) => @ORIENT("MY");
//   &CLKC @WIRE {%clk_MRN:p #MRN:g};
//   #M2P @PLACE(54, 24) => @ORIENT("R0");
//   #M2P @TEXT("6 x 1u/30n", key="model", size=0.65, dx=4, dy=-1, halign="start");
//   %b_M2P = $SUPPLY @ATTACH &AVDD => @PLACE(56, 28);
//   &AVDD @WIRE {#M2P:b (56, 24) %b_M2P:p};
//   %s_M2P = $SUPPLY @ATTACH &AVDD => @PLACE(54, 30);
//   &AVDD @WIRE {#M2P:s %s_M2P:p};
//   #M2N @PLACE(86, 24) => @ORIENT("MY");
//   #M2N @TEXT("6 x 1u/30n", key="model", size=0.65, dx=-4, dy=-1, halign="end");
//   %b_M2N = $SUPPLY @ATTACH &AVDD => @PLACE(84, 28);
//   &AVDD @WIRE {#M2N:b (84, 24) %b_M2N:p};
//   %s_M2N = $SUPPLY @ATTACH &AVDD => @PLACE(86, 30);
//   &AVDD @WIRE {#M2N:s %s_M2N:p};
//   #MLPP @PLACE(54, 10) => @ORIENT("R0");
//   #MLPP @TEXT("6 x 1u/30n", key="model", size=0.65, dx=4, dy=-1, halign="start");
//   %b_MLPP = $SUPPLY @ATTACH &AVDD => @PLACE(56, 14);
//   &AVDD @WIRE {#MLPP:b (56, 10) %b_MLPP:p};
//   #MLPN @PLACE(86, 10) => @ORIENT("MY");
//   #MLPN @TEXT("6 x 1u/30n", key="model", size=0.65, dx=-4, dy=-1, halign="end");
//   %b_MLPN = $SUPPLY @ATTACH &AVDD => @PLACE(84, 14);
//   &AVDD @WIRE {#MLPN:b (84, 10) %b_MLPN:p};
//   #MLNP @PLACE(54, -4) => @ORIENT("R0");
//   #MLNP @TEXT("4 x 1u/30n", key="model", size=0.65, dx=4, dy=-1, halign="start");
//   %b_MLNP = $GROUND @ATTACH &VSS => @PLACE(56, -8);
//   &VSS @WIRE {#MLNP:b (56, -4) %b_MLNP:p};
//   %s_MLNP = $GROUND @ATTACH &VSS => @PLACE(54, -10);
//   &VSS @WIRE {#MLNP:s %s_MLNP:p};
//   #MLNN @PLACE(86, -4) => @ORIENT("MY");
//   #MLNN @TEXT("4 x 1u/30n", key="model", size=0.65, dx=-4, dy=-1, halign="end");
//   %b_MLNN = $GROUND @ATTACH &VSS => @PLACE(84, -8);
//   &VSS @WIRE {#MLNN:b (84, -4) %b_MLNN:p};
//   %s_MLNN = $GROUND @ATTACH &VSS => @PLACE(86, -10);
//   &VSS @WIRE {#MLNN:s %s_MLNN:p};
//   #MRUP @PLACE(38, 16) => @ORIENT("R0");
//   #MRUP @TEXT("6 x 1u/30n", key="model", size=0.65, dx=4, dy=-1, halign="start");
//   %b_MRUP = $GROUND @ATTACH &VSS => @PLACE(40, 12);
//   &VSS @WIRE {#MRUP:b (40, 16) %b_MRUP:p};
//   %s_MRUP = $GROUND @ATTACH &VSS => @PLACE(38, 10);
//   &VSS @WIRE {#MRUP:s %s_MRUP:p};
//   %clk_MRUP = $IO_PORT @ATTACH &P => @PLACE(30, 16) => @ORIENT("R0");
//   &P @WIRE {%clk_MRUP:p #MRUP:g};
//   #MRUN @PLACE(102, 16) => @ORIENT("MY");
//   #MRUN @TEXT("6 x 1u/30n", key="model", size=0.65, dx=-4, dy=-1, halign="end");
//   %b_MRUN = $GROUND @ATTACH &VSS => @PLACE(100, 12);
//   &VSS @WIRE {#MRUN:b (100, 16) %b_MRUN:p};
//   %s_MRUN = $GROUND @ATTACH &VSS => @PLACE(102, 10);
//   &VSS @WIRE {#MRUN:s %s_MRUN:p};
//   %clk_MRUN = $IO_PORT @ATTACH &N => @PLACE(110, 16) => @ORIENT("MY");
//   &N @WIRE {%clk_MRUN:p #MRUN:g};
//   #MROP @PLACE(38, -4) => @ORIENT("R0");
//   #MROP @TEXT("6 x 1u/30n", key="model", size=0.65, dx=4, dy=-1, halign="start");
//   %b_MROP = $GROUND @ATTACH &VSS => @PLACE(40, -8);
//   &VSS @WIRE {#MROP:b (40, -4) %b_MROP:p};
//   %s_MROP = $GROUND @ATTACH &VSS => @PLACE(38, -10);
//   &VSS @WIRE {#MROP:s %s_MROP:p};
//   %clk_MROP = $IO_PORT @ATTACH &P => @PLACE(30, -4) => @ORIENT("R0");
//   &P @WIRE {%clk_MROP:p #MROP:g};
//   #MRON @PLACE(102, -4) => @ORIENT("MY");
//   #MRON @TEXT("6 x 1u/30n", key="model", size=0.65, dx=-4, dy=-1, halign="end");
//   %b_MRON = $GROUND @ATTACH &VSS => @PLACE(100, -8);
//   &VSS @WIRE {#MRON:b (100, -4) %b_MRON:p};
//   %s_MRON = $GROUND @ATTACH &VSS => @PLACE(102, -10);
//   &VSS @WIRE {#MRON:s %s_MRON:p};
//   %clk_MRON = $IO_PORT @ATTACH &N => @PLACE(110, -4) => @ORIENT("MY");
//   &N @WIRE {%clk_MRON:p #MRON:g};
//   %inp = $IO_PORT @ATTACH &INP => @PLACE(-24, 0) => @ORIENT("R0");
//   &INP @WIRE {%inp:p #MIP:g};
//   %inn = $IO_PORT @ATTACH &INN => @PLACE(24, 0) => @ORIENT("MY");
//   &INN @WIRE {%inn:p #MIN:g};
//   %tail1 = (0, -6);
//   $JUNCTION @ATTACH %tail1;
//   &T1 @WIRE {#MIP:s (-12, -6) %tail1 (12, -6) #MIN:s};
//   &T1 @WIRE {%tail1 #MT1:d};
//   %pa_P = (-12, 6);
//   $JUNCTION @ATTACH %pa_P;
//   &P @WIRE {#MIP:d %pa_P #MRP:d};
//   %pa_port_P = $IO_PORT @ATTACH &P => @PLACE(-4, 6) => @ORIENT("MY");
//   &P @WIRE {%pa_P %pa_port_P:p};
//   #CINTP @PLACE(-29, 2) => @ORIENT("R0");
//   #CINTP @TEXT("4 MOM units", key="value", size=0.65);
//   &P @WIRE {%pa_P (-29, 6) #CINTP:p};
//   %cg_P = $GROUND @ATTACH &VSS => @PLACE(-29, -4);
//   &VSS @WIRE {#CINTP:n %cg_P:p};
//   %pa_N = (12, 6);
//   $JUNCTION @ATTACH %pa_N;
//   &N @WIRE {#MIN:d %pa_N #MRN:d};
//   %pa_port_N = $IO_PORT @ATTACH &N => @PLACE(4, 6) => @ORIENT("R0");
//   &N @WIRE {%pa_N %pa_port_N:p};
//   #CINTN @PLACE(29, 2) => @ORIENT("R0");
//   #CINTN @TEXT("4 MOM units", key="value", size=0.65);
//   &N @WIRE {%pa_N (29, 6) #CINTN:p};
//   %cg_N = $GROUND @ATTACH &VSS => @PLACE(29, -4);
//   &VSS @WIRE {#CINTN:n %cg_N:p};
//   {#CINTP #CINTN} @AS $MATCHED;
//   %s2p = $IO_PORT @ATTACH &P => @PLACE(44, 24) => @ORIENT("R0");
//   &P @WIRE {%s2p:p #M2P:g};
//   %s2n = $IO_PORT @ATTACH &N => @PLACE(96, 24) => @ORIENT("MY");
//   &N @WIRE {%s2n:p #M2N:g};
//   %up = (54, 18);
//   $JUNCTION @ATTACH %up;
//   &UP @WIRE {#M2P:d %up #MLPP:s};
//   &UP @WIRE {%up (38, 18) #MRUP:d};
//   %un = (86, 18);
//   $JUNCTION @ATTACH %un;
//   &UN @WIRE {#M2N:d %un #MLPN:s};
//   &UN @WIRE {%un (102, 18) #MRUN:d};
//   %op = (54, 3);
//   $JUNCTION @ATTACH %op;
//   %on = (86, 3);
//   $JUNCTION @ATTACH %on;
//   &OUTP @WIRE {#MLPP:d %op #MLNP:d};
//   &OUTN @WIRE {#MLPN:d %on #MLNN:d};
//   &OUTP @WIRE {%op (38, 3) #MROP:d};
//   &OUTN @WIRE {%on (102, 3) #MRON:d};
//   %feedback_p = (92, 5);
//   $JUNCTION @ATTACH %feedback_p;
//   %feedback_n = (48, 1);
//   $JUNCTION @ATTACH %feedback_n;
//   &OUTP @WIRE {%op (66, 3) (66, 5) %feedback_p};
//   &OUTP @WIRE {#MLPN:g (92, 10) %feedback_p (92, -4) #MLNN:g};
//   &OUTN @WIRE {%on (74, 3) (74, 1) %feedback_n};
//   &OUTN @WIRE {#MLPP:g (48, 10) %feedback_n (48, -4) #MLNP:g};
//   %outp = $IO_PORT @ATTACH &OUTP => @PLACE(60, 8) => @ORIENT("MY");
//   &OUTP @WIRE {%op (60, 3) %outp:p};
//   %outn = $IO_PORT @ATTACH &OUTN => @PLACE(80, 8) => @ORIENT("R0");
//   &OUTN @WIRE {%on (80, 3) %outn:p};
//   (-30, 48) @TEXT("adc_comp | Miyahara self-timed two-stage core", size=1.3, bold=true, halign="start");
//   (-24, 24) @TEXT("1. Dynamic preamplifier", size=1, bold=true, halign="start");
//   (38, 36) @TEXT("2. Self-timed regenerative stage", size=1, bold=true, halign="start");
//   (36, 34) @TEXT("P/N control PMOS inputs and NMOS reset devices", size=0.75, halign="start");
//   (-30, -24) @TEXT("Reset: P=N=AVDD; UP=UN=OUTP=OUTN=0. No second clock or explicit second-stage tail.", size=0.85, halign="start");
//   (-30, -27) @TEXT("Evaluate: INP>INN -> P falls faster -> M2P sources current first -> OUTP rises.", size=0.85, halign="start");
//   (-30, -30) @TEXT("Core of Miyahara et al., A-SSCC 2008, Fig. 2(b). Offset calibration is not included; pre-layout WIP.", size=0.85, halign="start");
// }
ends adc_comp
