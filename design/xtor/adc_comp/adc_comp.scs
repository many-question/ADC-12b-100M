// adc_comp: Miyahara self-timed two-stage comparator core (calibration omitted)
// @RNL(type="header") {
//   @VERSION("0.3");
//   @USE-PACKAGE(name="adc28", version="0.1", path="../../rnl/adc28.rnl")
// }
simulator lang=spectre

subckt adc_comp (INP INN CLKC OUTP OUTN AVDD VSS)
// Reset: CLKC=0; P=N=AVDD resets UP, UN and both outputs via NMOS.
// Evaluate: INP>INN lowers P first; PMOS M2P then raises UP and OUTP.
// Falling P/N self-time the second stage: PMOS input devices and NMOS resets share P/N.
// Logical MOS devices are parallel single-finger units (nf=1, integer m).
// Based on M1-M15 of Miyahara et al., A-SSCC 2008, Fig. 2(b), DOI 10.1109/ASSCC.2008.4708780.
MIP (P INP T1 VSS) nch_ulvt_mac w=1u l=30n nf=1 m=40 ad=7.5e-14 as=7.5e-14 pd=2.15e-06 ps=2.15e-06 nrd=0.289519 nrs=0.289519 sa=7.5e-08 sb=7.5e-08 sd=1e-07
MIN (N INN T1 VSS) nch_ulvt_mac w=1u l=30n nf=1 m=40 ad=7.5e-14 as=7.5e-14 pd=2.15e-06 ps=2.15e-06 nrd=0.289519 nrs=0.289519 sa=7.5e-08 sb=7.5e-08 sd=1e-07
MT1 (T1 CLKC VSS VSS) nch_ulvt_mac w=1u l=30n nf=1 m=3 ad=7.5e-14 as=7.5e-14 pd=2.15e-06 ps=2.15e-06 nrd=0.289519 nrs=0.289519 sa=7.5e-08 sb=7.5e-08 sd=1e-07
MRP (P CLKC AVDD AVDD) pch_ulvt_mac w=1u l=30n nf=1 m=6 ad=7.5e-14 as=7.5e-14 pd=2.15e-06 ps=2.15e-06 nrd=0.165806 nrs=0.165806 sa=7.5e-08 sb=7.5e-08 sd=1e-07
MRN (N CLKC AVDD AVDD) pch_ulvt_mac w=1u l=30n nf=1 m=6 ad=7.5e-14 as=7.5e-14 pd=2.15e-06 ps=2.15e-06 nrd=0.165806 nrs=0.165806 sa=7.5e-08 sb=7.5e-08 sd=1e-07
M2P (UP P AVDD AVDD) pch_ulvt_mac w=1u l=30n nf=1 m=3 ad=7.5e-14 as=7.5e-14 pd=2.15e-06 ps=2.15e-06 nrd=0.165806 nrs=0.165806 sa=7.5e-08 sb=7.5e-08 sd=1e-07
M2N (UN N AVDD AVDD) pch_ulvt_mac w=1u l=30n nf=1 m=3 ad=7.5e-14 as=7.5e-14 pd=2.15e-06 ps=2.15e-06 nrd=0.165806 nrs=0.165806 sa=7.5e-08 sb=7.5e-08 sd=1e-07
MLPP (OUTP OUTN UP AVDD) pch_ulvt_mac w=1u l=30n nf=1 m=3 ad=7.5e-14 as=7.5e-14 pd=2.15e-06 ps=2.15e-06 nrd=0.165806 nrs=0.165806 sa=7.5e-08 sb=7.5e-08 sd=1e-07
MLPN (OUTN OUTP UN AVDD) pch_ulvt_mac w=1u l=30n nf=1 m=3 ad=7.5e-14 as=7.5e-14 pd=2.15e-06 ps=2.15e-06 nrd=0.165806 nrs=0.165806 sa=7.5e-08 sb=7.5e-08 sd=1e-07
MLNP (OUTP OUTN VSS VSS) nch_ulvt_mac w=1u l=30n nf=1 m=2 ad=7.5e-14 as=7.5e-14 pd=2.15e-06 ps=2.15e-06 nrd=0.289519 nrs=0.289519 sa=7.5e-08 sb=7.5e-08 sd=1e-07
MLNN (OUTN OUTP VSS VSS) nch_ulvt_mac w=1u l=30n nf=1 m=2 ad=7.5e-14 as=7.5e-14 pd=2.15e-06 ps=2.15e-06 nrd=0.289519 nrs=0.289519 sa=7.5e-08 sb=7.5e-08 sd=1e-07
MRUP (UP P VSS VSS) nch_ulvt_mac w=1u l=30n nf=1 m=3 ad=7.5e-14 as=7.5e-14 pd=2.15e-06 ps=2.15e-06 nrd=0.289519 nrs=0.289519 sa=7.5e-08 sb=7.5e-08 sd=1e-07
MRUN (UN N VSS VSS) nch_ulvt_mac w=1u l=30n nf=1 m=3 ad=7.5e-14 as=7.5e-14 pd=2.15e-06 ps=2.15e-06 nrd=0.289519 nrs=0.289519 sa=7.5e-08 sb=7.5e-08 sd=1e-07
MROP (OUTP P VSS VSS) nch_ulvt_mac w=1u l=30n nf=1 m=3 ad=7.5e-14 as=7.5e-14 pd=2.15e-06 ps=2.15e-06 nrd=0.289519 nrs=0.289519 sa=7.5e-08 sb=7.5e-08 sd=1e-07
MRON (OUTN N VSS VSS) nch_ulvt_mac w=1u l=30n nf=1 m=3 ad=7.5e-14 as=7.5e-14 pd=2.15e-06 ps=2.15e-06 nrd=0.289519 nrs=0.289519 sa=7.5e-08 sb=7.5e-08 sd=1e-07
CINTP (P VSS) cfmom_2t nr=24 lr=1u w=50n s=50n stm=1 spm=3 multi=2
CINTN (N VSS) cfmom_2t nr=24 lr=1u w=50n s=50n stm=1 spm=3 multi=2
// @RNL {
//   /* Functional semantics: reset, dynamic integration and self-timed regeneration. */
//   &AVDD @ADD-TO $SUPPLY_NET_SET;
//   &VSS @ADD-TO $GROUND_NET_SET;
//   %preamp = #MIP(in_p) #MIN(in_n) #MT1(tail) @AS $DIFFERENTIAL_PAIR;
//   $SELF_TIMED_INPUT = @DEFINE(roles=["p", "n", "rp", "rn", "op", "on"]) { {?p ?n ?rp ?rn ?op ?on} @GROUP };
//   %self_timing = #M2P(p) #M2N(n) #MRUP(rp) #MRUN(rn) #MROP(op) #MRON(on) @AS $SELF_TIMED_INPUT;
//   $REGENERATIVE_QUAD = @DEFINE(roles=["p1", "p2", "n1", "n2"]) { {?p1 ?p2 ?n1 ?n2} @GROUP };
//   %latch = #MLPP(p1) #MLPN(p2) #MLNP(n1) #MLNN(n2) @AS $REGENERATIVE_QUAD;
//   %symmetry_axis = (0, 0);
//   {#MIP #MIN} @AS $MATCHED;
//   {#MIP #MIN} @ALIGN("y");
//   #MIP(a) #MIN(b) %symmetry_axis(axis) @AS $MIRRORED;
//   {#MRP #MRN} @AS $MATCHED;
//   {#MRP #MRN} @ALIGN("y");
//   #MRP(a) #MRN(b) %symmetry_axis(axis) @AS $MIRRORED;
//   {#M2P #M2N} @AS $MATCHED;
//   {#M2P #M2N} @ALIGN("y");
//   #M2P(a) #M2N(b) %symmetry_axis(axis) @AS $MIRRORED;
//   {#MLPP #MLPN} @AS $MATCHED;
//   {#MLPP #MLPN} @ALIGN("y");
//   #MLPP(a) #MLPN(b) %symmetry_axis(axis) @AS $MIRRORED;
//   {#MLNP #MLNN} @AS $MATCHED;
//   {#MLNP #MLNN} @ALIGN("y");
//   #MLNP(a) #MLNN(b) %symmetry_axis(axis) @AS $MIRRORED;
//   {#MRUP #MRUN} @AS $MATCHED;
//   {#MRUP #MRUN} @ALIGN("y");
//   #MRUP(a) #MRUN(b) %symmetry_axis(axis) @AS $MIRRORED;
//   {#MROP #MRON} @AS $MATCHED;
//   {#MROP #MRON} @ALIGN("y");
//   #MROP(a) #MRON(b) %symmetry_axis(axis) @AS $MIRRORED;
//   {#CINTP #CINTN} @AS $MATCHED;
//   {#CINTP #CINTN} @ALIGN("y");
//   {#MRP #MRN} @GROUP;
//   {#CINTP #CINTN} @GROUP;
//   #MT1:d @CURRENT("in");
//   #MT1:s @CURRENT("out");
//   #M2P @PLACE(-12, 32) => @ORIENT("R0");
//   #M2P @TEXT("M2P", key="name", dx=3.5, dy=1, size=1, halign="start", bold=true);
//   #M2P @TEXT("m=${m}", key="model", dx=3.5, dy=-0.8, size=0.82, halign="start");
//   #M2N @PLACE(12, 32) => @ORIENT("MY");
//   #M2N @TEXT("M2N", key="name", dx=-3.5, dy=1, size=1, halign="end", bold=true);
//   #M2N @TEXT("m=${m}", key="model", dx=-3.5, dy=-0.8, size=0.82, halign="end");
//   #MLPP @PLACE(-12, 21) => @ORIENT("MY");
//   #MLPP @TEXT("MLPP", key="name", dx=-3.5, dy=1, size=1, halign="end", bold=true);
//   #MLPP @TEXT("m=${m}", key="model", dx=-3.5, dy=-0.8, size=0.82, halign="end");
//   #MLPN @PLACE(12, 21) => @ORIENT("R0");
//   #MLPN @TEXT("MLPN", key="name", dx=3.5, dy=1, size=1, halign="start", bold=true);
//   #MLPN @TEXT("m=${m}", key="model", dx=3.5, dy=-0.8, size=0.82, halign="start");
//   #MLNP @PLACE(-12, 9) => @ORIENT("MY");
//   #MLNP @TEXT("MLNP", key="name", dx=-3.5, dy=1, size=1, halign="end", bold=true);
//   #MLNP @TEXT("m=${m}", key="model", dx=-3.5, dy=-0.8, size=0.82, halign="end");
//   #MLNN @PLACE(12, 9) => @ORIENT("R0");
//   #MLNN @TEXT("MLNN", key="name", dx=3.5, dy=1, size=1, halign="start", bold=true);
//   #MLNN @TEXT("m=${m}", key="model", dx=3.5, dy=-0.8, size=0.82, halign="start");
//   #MRUP @PLACE(-26, 25) => @ORIENT("R0");
//   #MRUP @TEXT("MRUP", key="name", dx=-6.5, dy=1.6, size=1, halign="middle", bold=true);
//   #MRUP @TEXT("m=${m}", key="model", dx=-6.5, dy=-1.6, size=0.82, halign="middle");
//   #MRUN @PLACE(26, 25) => @ORIENT("MY");
//   #MRUN @TEXT("MRUN", key="name", dx=6.5, dy=1.6, size=1, halign="middle", bold=true);
//   #MRUN @TEXT("m=${m}", key="model", dx=6.5, dy=-1.6, size=0.82, halign="middle");
//   #MROP @PLACE(-26, 9) => @ORIENT("R0");
//   #MROP @TEXT("MROP", key="name", dx=-6.5, dy=1.6, size=1, halign="middle", bold=true);
//   #MROP @TEXT("m=${m}", key="model", dx=-6.5, dy=-1.6, size=0.82, halign="middle");
//   #MRON @PLACE(26, 9) => @ORIENT("MY");
//   #MRON @TEXT("MRON", key="name", dx=6.5, dy=1.6, size=1, halign="middle", bold=true);
//   #MRON @TEXT("m=${m}", key="model", dx=6.5, dy=-1.6, size=0.82, halign="middle");
//   #MRP @PLACE(-12, -12) => @ORIENT("MY");
//   #MRP @TEXT("MRP", key="name", dx=-3.5, dy=1, size=1, halign="end", bold=true);
//   #MRP @TEXT("m=${m}", key="model", dx=-3.5, dy=-0.8, size=0.82, halign="end");
//   #MRN @PLACE(12, -12) => @ORIENT("R0");
//   #MRN @TEXT("MRN", key="name", dx=3.5, dy=1, size=1, halign="start", bold=true);
//   #MRN @TEXT("m=${m}", key="model", dx=3.5, dy=-0.8, size=0.82, halign="start");
//   #MIP @PLACE(-12, -26) => @ORIENT("R0");
//   #MIP @TEXT("MIP", key="name", dx=3.5, dy=1, size=1, halign="start", bold=true);
//   #MIP @TEXT("m=${m}", key="model", dx=3.5, dy=-0.8, size=0.82, halign="start");
//   #MIN @PLACE(12, -26) => @ORIENT("MY");
//   #MIN @TEXT("MIN", key="name", dx=-3.5, dy=1, size=1, halign="end", bold=true);
//   #MIN @TEXT("m=${m}", key="model", dx=-3.5, dy=-0.8, size=0.82, halign="end");
//   #MT1 @PLACE(0, -36) => @ORIENT("R0");
//   #MT1 @TEXT("MT1", key="name", dx=3.5, dy=1, size=1, halign="start", bold=true);
//   #MT1 @TEXT("m=${m}", key="model", dx=3.5, dy=-0.8, size=0.82, halign="start");
//   #CINTP @PLACE(-27, -21) => @ORIENT("R0");
//   #CINTP @TEXT("CINTP", key="name", dx=2.4, dy=0.8, halign="start", size=0.95, bold=true);
//   #CINTP @TEXT("${multi} x MOM", key="value", dx=2.4, dy=-1, halign="start", size=0.8);
//   #CINTN @PLACE(27, -21) => @ORIENT("R0");
//   #CINTN @TEXT("CINTN", key="name", dx=-2.4, dy=0.8, halign="end", size=0.95, bold=true);
//   #CINTN @TEXT("${multi} x MOM", key="value", dx=-2.4, dy=-1, halign="end", size=0.8);
//   /* Shared rails and local body connections; every bulk pin remains explicit. */
//   %vdd_l = (-12, 38);
//   %vdd_r = (12, 38);
//   %vdd_c = (0, 38);
//   $JUNCTION @ATTACH %vdd_c;
//   &AVDD @WIRE(mode="straight") {%vdd_l %vdd_c %vdd_r};
//   %vdd = $SUPPLY @ATTACH &AVDD => @PLACE(0, 40);
//   %vdd @TEXT("AVDD", key="name", size=0.8, textcolor="#475467");
//   &AVDD @WIRE(mode="straight") {%vdd_c %vdd:p};
//   %s_M2P = (-12, 35);
//   $JUNCTION @ATTACH %s_M2P;
//   &AVDD @WIRE(mode="straight") {#M2P:s %s_M2P};
//   &AVDD @WIRE(mode="straight") {%s_M2P %vdd_l};
//   &AVDD @WIRE(mode="straight") {#M2P:b (-10, 32) (-10, 35) %s_M2P};
//   %s_M2N = (12, 35);
//   $JUNCTION @ATTACH %s_M2N;
//   &AVDD @WIRE(mode="straight") {#M2N:s %s_M2N};
//   &AVDD @WIRE(mode="straight") {%s_M2N %vdd_r};
//   &AVDD @WIRE(mode="straight") {#M2N:b (10, 32) (10, 35) %s_M2N};
//   %bulk_MLPP = $SUPPLY @ATTACH &AVDD => @PLACE(-14, 24);
//   %bulk_MLPP @TEXT("AVDD", key="name", size=0.8, textcolor="#475467");
//   &AVDD @WIRE(mode="straight") {#MLPP:b (-14, 21) %bulk_MLPP:p};
//   %bulk_MLPN = $SUPPLY @ATTACH &AVDD => @PLACE(14, 24);
//   %bulk_MLPN @TEXT("AVDD", key="name", size=0.8, textcolor="#475467");
//   &AVDD @WIRE(mode="straight") {#MLPN:b (14, 21) %bulk_MLPN:p};
//   %gnd_l = (-26, 4);
//   %gnd_il = (-12, 4);
//   $JUNCTION @ATTACH %gnd_il;
//   %gnd_c = (0, 4);
//   $JUNCTION @ATTACH %gnd_c;
//   %gnd_ir = (12, 4);
//   $JUNCTION @ATTACH %gnd_ir;
//   %gnd_r = (26, 4);
//   &VSS @WIRE(mode="straight") {%gnd_l %gnd_il %gnd_c %gnd_ir %gnd_r};
//   %gnd = $GROUND @ATTACH &VSS => @PLACE(0, 3);
//   %gnd @TEXT("VSS", key="name", size=0.8, textcolor="#475467");
//   &VSS @WIRE(mode="straight") {%gnd_c %gnd:p};
//   %s_MLNP = (-12, 7);
//   $JUNCTION @ATTACH %s_MLNP;
//   &VSS @WIRE(mode="straight") {#MLNP:s %s_MLNP %gnd_il};
//   &VSS @WIRE(mode="straight") {#MLNP:b (-14, 9) (-14, 7) %s_MLNP};
//   %s_MLNN = (12, 7);
//   $JUNCTION @ATTACH %s_MLNN;
//   &VSS @WIRE(mode="straight") {#MLNN:s %s_MLNN %gnd_ir};
//   &VSS @WIRE(mode="straight") {#MLNN:b (14, 9) (14, 7) %s_MLNN};
//   %s_MROP = (-26, 7);
//   $JUNCTION @ATTACH %s_MROP;
//   &VSS @WIRE(mode="straight") {#MROP:s %s_MROP %gnd_l};
//   &VSS @WIRE(mode="straight") {#MROP:b (-24, 9) (-24, 7) %s_MROP};
//   %s_MRON = (26, 7);
//   $JUNCTION @ATTACH %s_MRON;
//   &VSS @WIRE(mode="straight") {#MRON:s %s_MRON %gnd_r};
//   &VSS @WIRE(mode="straight") {#MRON:b (24, 9) (24, 7) %s_MRON};
//   %s_MRUP = (-26, 22);
//   $JUNCTION @ATTACH %s_MRUP;
//   %g_MRUP = $GROUND @ATTACH &VSS => @PLACE(-26, 20);
//   %g_MRUP @TEXT("VSS", key="name", size=0.8, textcolor="#475467");
//   &VSS @WIRE(mode="straight") {#MRUP:s %s_MRUP %g_MRUP:p};
//   &VSS @WIRE(mode="straight") {#MRUP:b (-24, 25) (-24, 22) %s_MRUP};
//   %s_MRUN = (26, 22);
//   $JUNCTION @ATTACH %s_MRUN;
//   %g_MRUN = $GROUND @ATTACH &VSS => @PLACE(26, 20);
//   %g_MRUN @TEXT("VSS", key="name", size=0.8, textcolor="#475467");
//   &VSS @WIRE(mode="straight") {#MRUN:s %s_MRUN %g_MRUN:p};
//   &VSS @WIRE(mode="straight") {#MRUN:b (24, 25) (24, 22) %s_MRUN};
//   %pre_vdd_l = (-12, -7);
//   $JUNCTION @ATTACH %pre_vdd_l;
//   %pre_vdd_r = (12, -7);
//   $JUNCTION @ATTACH %pre_vdd_r;
//   %pre_vdd_c = (0, -7);
//   $JUNCTION @ATTACH %pre_vdd_c;
//   &AVDD @WIRE(mode="straight") {#MRP:s %pre_vdd_l %pre_vdd_c %pre_vdd_r #MRN:s};
//   %pre_vdd = $SUPPLY @ATTACH &AVDD => @PLACE(0, -6);
//   %pre_vdd @TEXT("AVDD", key="name", size=0.8, textcolor="#475467");
//   &AVDD @WIRE(mode="straight") {%pre_vdd_c %pre_vdd:p};
//   &AVDD @WIRE(mode="straight") {#MRP:b (-14, -12) (-14, -7) %pre_vdd_l};
//   &AVDD @WIRE(mode="straight") {#MRN:b (14, -12) (14, -7) %pre_vdd_r};
//   %b_MIP = $GROUND @ATTACH &VSS => @PLACE(-10, -28);
//   %b_MIP @TEXT("VSS", key="name", size=0.8, textcolor="#475467");
//   &VSS @WIRE(mode="straight") {#MIP:b (-10, -26) %b_MIP:p};
//   %b_MIN = $GROUND @ATTACH &VSS => @PLACE(10, -28);
//   %b_MIN @TEXT("VSS", key="name", size=0.8, textcolor="#475467");
//   &VSS @WIRE(mode="straight") {#MIN:b (10, -26) %b_MIN:p};
//   %tail_ground = (0, -39);
//   $JUNCTION @ATTACH %tail_ground;
//   %tail_gnd = $GROUND @ATTACH &VSS => @PLACE(0, -41);
//   %tail_gnd @TEXT("VSS", key="name", size=0.8, textcolor="#475467");
//   &VSS @WIRE(mode="straight") {#MT1:s %tail_ground %tail_gnd:p};
//   &VSS @WIRE(mode="straight") {#MT1:b (2, -36) (2, -39) %tail_ground};
//   /* Symmetric integration stage. */
//   %tail = (0, -32);
//   $JUNCTION @ATTACH %tail;
//   &T1 @WIRE(mode="straight") {#MIP:s (-12, -32) %tail (12, -32) #MIN:s};
//   &T1 @WIRE(mode="straight") {%tail #MT1:d};
//   %inp = $IO_PORT @ATTACH &INP => @PLACE(-22, -26) => @ORIENT("R0");
//   %inp @TEXT("INP", key="name", size=0.95, bold=true);
//   &INP @WIRE(mode="straight") {%inp:p #MIP:g};
//   %inn = $IO_PORT @ATTACH &INN => @PLACE(22, -26) => @ORIENT("MY");
//   %inn @TEXT("INN", key="name", size=0.95, bold=true);
//   &INN @WIRE(mode="straight") {%inn:p #MIN:g};
//   %clock_pair = (0, -12);
//   $JUNCTION @ATTACH %clock_pair;
//   &CLKC @WIRE(mode="straight") {#MRP:g %clock_pair #MRN:g};
//   %clk_pre = $IO_PORT @ATTACH &CLKC => @PLACE(0, -14.5) => @ORIENT("R90");
//   %clk_pre @TEXT("", key="name", size=0.95, bold=true);
//   &CLKC @WIRE(mode="straight") {%clock_pair %clk_pre:p};
//   (0, -16.7) @TEXT("CLKC", size=0.9, halign="middle", bold=true);
//   %clk_tail = $IO_PORT @ATTACH &CLKC => @PLACE(-8, -36) => @ORIENT("R0");
//   %clk_tail @TEXT("CLKC", key="name", size=0.95, bold=true);
//   &CLKC @WIRE(mode="straight") {%clk_tail:p #MT1:g};
//   /* P and N continuously wire the preamplifier to the self-timed inputs and resets. */
//   %pre_P = (-12, -17);
//   $JUNCTION @ATTACH %pre_P;
//   %cap_P = (-27, -17);
//   $JUNCTION @ATTACH %cap_P;
//   %bus_P = (-37, -17);
//   %gate_out_P = (-37, 9);
//   $JUNCTION @ATTACH %gate_out_P;
//   %gate_up_P = (-37, 25);
//   $JUNCTION @ATTACH %gate_up_P;
//   %gate_in_P = (-37, 32);
//   &P @WIRE(mode="straight") {#MRP:d %pre_P #MIP:d};
//   &P @WIRE(mode="straight") {%pre_P %cap_P %bus_P %gate_out_P %gate_up_P %gate_in_P #M2P:g};
//   &P @WIRE(mode="straight") {%gate_out_P #MROP:g};
//   &P @WIRE(mode="straight") {%gate_up_P #MRUP:g};
//   &P @WIRE(mode="straight") {%cap_P #CINTP:p};
//   %cg_P = $GROUND @ATTACH &VSS => @PLACE(-27, -26);
//   %cg_P @TEXT("VSS", key="name", size=0.8, textcolor="#475467");
//   &VSS @WIRE(mode="straight") {#CINTP:n %cg_P:p};
//   (-35.8, 28.5) @TEXT("P", size=1, halign="middle", bold=true);
//   (-10, -16.3) @TEXT("P", size=0.95, halign="start", bold=true);
//   %pre_N = (12, -17);
//   $JUNCTION @ATTACH %pre_N;
//   %cap_N = (27, -17);
//   $JUNCTION @ATTACH %cap_N;
//   %bus_N = (37, -17);
//   %gate_out_N = (37, 9);
//   $JUNCTION @ATTACH %gate_out_N;
//   %gate_up_N = (37, 25);
//   $JUNCTION @ATTACH %gate_up_N;
//   %gate_in_N = (37, 32);
//   &N @WIRE(mode="straight") {#MRN:d %pre_N #MIN:d};
//   &N @WIRE(mode="straight") {%pre_N %cap_N %bus_N %gate_out_N %gate_up_N %gate_in_N #M2N:g};
//   &N @WIRE(mode="straight") {%gate_out_N #MRON:g};
//   &N @WIRE(mode="straight") {%gate_up_N #MRUN:g};
//   &N @WIRE(mode="straight") {%cap_N #CINTN:p};
//   %cg_N = $GROUND @ATTACH &VSS => @PLACE(27, -26);
//   %cg_N @TEXT("VSS", key="name", size=0.8, textcolor="#475467");
//   &VSS @WIRE(mode="straight") {#CINTN:n %cg_N:p};
//   (35.8, 28.5) @TEXT("N", size=1, halign="middle", bold=true);
//   (10, -16.3) @TEXT("N", size=0.95, halign="end", bold=true);
//   /* Cross-coupled feedback: four straight segments; intersections without a dot do not connect. */
//   %up = (-12, 28);
//   $JUNCTION @ATTACH %up;
//   %un = (12, 28);
//   $JUNCTION @ATTACH %un;
//   &UP @WIRE(mode="straight") {#M2P:d %up #MLPP:s};
//   &UN @WIRE(mode="straight") {#M2N:d %un #MLPN:s};
//   &UP @WIRE(mode="straight") {%up (-26, 28) #MRUP:d};
//   &UN @WIRE(mode="straight") {%un (26, 28) #MRUN:d};
//   %out_p = (-12, 15);
//   $JUNCTION @ATTACH %out_p;
//   %out_n = (12, 15);
//   $JUNCTION @ATTACH %out_n;
//   &OUTP @WIRE(mode="straight") {#MLPP:d %out_p #MLNP:d};
//   &OUTN @WIRE(mode="straight") {#MLPN:d %out_n #MLNN:d};
//   %out_reset_p = (-26, 15);
//   $JUNCTION @ATTACH %out_reset_p;
//   %out_reset_n = (26, 15);
//   $JUNCTION @ATTACH %out_reset_n;
//   %outp = $IO_PORT @ATTACH &OUTP => @PLACE(-32, 15) => @ORIENT("R0");
//   %outp @TEXT("OUTP", key="name", size=0.95, bold=true);
//   &OUTP @WIRE(mode="straight") {%out_p %out_reset_p %outp:p};
//   %outn = $IO_PORT @ATTACH &OUTN => @PLACE(32, 15) => @ORIENT("MY");
//   %outn @TEXT("OUTN", key="name", size=0.95, bold=true);
//   &OUTN @WIRE(mode="straight") {%out_n %out_reset_n %outn:p};
//   &OUTP @WIRE(mode="straight") {%out_reset_p #MROP:d};
//   &OUTN @WIRE(mode="straight") {%out_reset_n #MRON:d};
//   &OUTP @WIRE(mode="straight") {%out_p #MLPN:g};
//   &OUTN @WIRE(mode="straight") {%out_n #MLPP:g};
//   &OUTP @WIRE(mode="straight") {%out_p #MLNN:g};
//   &OUTN @WIRE(mode="straight") {%out_n #MLNP:g};
//   (0, 26.5) @TEXT("2  REGENERATION", size=1, halign="middle", bold=true);
//   (0, -22) @TEXT("1  INTEGRATION", size=1, halign="middle", bold=true);
//   (0, 49) @TEXT("adc_comp  |  Miyahara self-timed core", size=1.5, halign="middle", bold=true);
//   (0, 46) @TEXT("mc12  /  pre-layout  /  offset calibration omitted", size=0.95, halign="middle", bold=false);
//   (0, -47) @TEXT("MOS unit W/L = 1um/30nm; m is the parallel multiplier.", size=0.9, halign="middle", bold=false);
//   (0, -50) @TEXT("MOM unit: nr=24, lr=1um, w=s=50nm, metals 1-3.", size=0.85, halign="middle", bold=false);
//   (0, -53) @TEXT("CLKC = 0: reset   |   CLKC = 1: evaluate   |   INP > INN: OUTP rises", size=0.85, halign="middle", bold=false);
// }
ends adc_comp
