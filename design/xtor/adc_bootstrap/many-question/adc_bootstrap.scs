// adc_bootstrap: protected control with a local clock buffer and reset-gate limiter.
// @RNL(type="header") {
//   @VERSION("0.3");
//   @USE-PACKAGE(name="adc28", version="0.1", path="../../../rnl/adc28.rnl")
// }
simulator lang=spectre

subckt adc_bootstrap (VIN PHI_B PHI_BB VG AVDD VSS)
// Precharge the MOM capacitor bank, then reference it to VIN while tracking.
MPRE (CBP VG AVDD CBP) pch_ulvt_mac w=8u l=100n nf=4
CB (CBP CBN) cfmom_2t w=50n s=50n nr=200 lr=40u stm=1 spm=6
MRST (CBN PHI_R VSS VSS) nch_ulvt_mac w=24u l=100n nf=12
MTRK (CBN VG VIN VSS) nch_ulvt_mac w=48u l=30n nf=24
MXFER (VG GCTL CBP CBP) pch_ulvt_mac w=4u l=30n nf=2
// Protect the boosted pull-up control and its startup path.
MCP (PCP PHI_B AVDD AVDD) pch_ulvt_mac w=1.5u l=30n nf=1
MCSTART (GCTL PHI_N CBN VSS) nch_ulvt_mac w=500n l=30n nf=1
MCF (GCTL VG CBN VSS) nch_ulvt_mac w=8u l=30n nf=4
MDHI (VG AVDD DU VSS) nch_ulvt_mac w=24u l=30n nf=12
MDUP (VG VG DU VSS) nch_ulvt_mac w=24u l=30n nf=12
MDMID (DU AVDD DN VSS) nch_mac w=48u l=30n nf=24
MDLO (DN PHI_BBF VSS VSS) nch_mac w=32u l=30n nf=16

// Local buffer output drives discharge and the separate MRST gate limiter.
MNFB (PHI_BBF PHI_BBI VSS VSS) nch_ulvt_mac w=2u l=30n nf=1
MPFB (PHI_BBF PHI_BBI AVDD AVDD) pch_ulvt_mac w=8u l=30n nf=4
MPCAS (GCTL VSS PCP AVDD) pch_ulvt_mac w=2u l=30n nf=1
MNCL (PHI_B AVDD PHI_N VSS) nch_lvt_mac w=8u l=30n nf=4
CB2 (CBP CBN) cfmom_2t w=50n s=50n nr=200 lr=40u stm=1 spm=6
// The small first stage isolates PHI_BB from internal reset/discharge load.
MBN (PHI_BBI PHI_BB VSS VSS) nch_ulvt_mac w=4u l=30n nf=2
MBP (PHI_BBI PHI_BB AVDD AVDD) pch_ulvt_mac w=4u l=30n nf=2
CBG (PHI_BBI VSS) cfmom_2t w=50n s=50n nr=12 lr=5u stm=1 spm=6
MNRC (PHI_BBF AVDD PHI_R VSS) nch_ulvt_mac w=8u l=30n nf=4
// Keep the startup gate loaded so its limiter can settle below the rail.
MBLEED (PHI_N AVDD VSS VSS) nch_mac w=120n l=1u nf=1
// Share the fast discharge-stack transient while limiting the lower-node excursion.
CMD (DU DN) cfmom_2t w=50n s=50n nr=12 lr=5u stm=1 spm=6
CDN (DN VSS) cfmom_2t w=50n s=50n nr=20 lr=5u stm=1 spm=6
// The limited startup control connects CBN to VIN before the boosted switch fully turns on.
MAUX (CBN PHI_N VIN VSS) nch_ulvt_mac w=800n l=30n nf=1
// Couple the same-polarity external clock edge to counter buffer-output feedthrough.
CFF (PHI_BBF PHI_BB) cfmom_2t w=50n s=50n nr=6 lr=1u stm=1 spm=6
// Couple the complementary clock edge to the internal pull-up control.
CCONT (PCP PHI_BB) cfmom_2t w=50n s=50n nr=6 lr=1u stm=1 spm=3
// Counter first-stage Miller feedthrough with the complementary input edge.
CBI (PHI_BBI PHI_B) cfmom_2t w=50n s=50n nr=6 lr=1u stm=1 spm=3
// @RNL {
//   &AVDD @ADD-TO $SUPPLY_NET_SET; &VSS @ADD-TO $GROUND_NET_SET;
//   {#MPRE #CB #CB2 #MRST} @GROUP;
//   {#MCP #MPCAS #MCSTART} @AS $BRANCH;
//   {#MCP #MPCAS #MCSTART #MCF #MNCL #MBLEED #CCONT} @GROUP;
//   {#MBN #MBP #CBG #MNFB #MPFB #MNRC #CFF #CBI} @GROUP; {#MXFER #MTRK #MAUX} @GROUP;
//   {#MDHI #MDMID #MDLO} @AS $BRANCH;
//   {#MDHI #MDUP #MDMID #MDLO #CMD #CDN} @GROUP;
//   #MPRE @PLACE(0, 20) => @ORIENT("R0");
//   #CB @PLACE(0, 4) => @ORIENT("R0");
//   #CB2 @PLACE(12, 4) => @ORIENT("R0");
//   #MRST @PLACE(0, -18) => @ORIENT("R0");
//   #MXFER @PLACE(32, 20) => @ORIENT("R0");
//   #MAUX @PLACE(12, -30) => @ORIENT("R0");
//   #MTRK @PLACE(32, -4) => @ORIENT("R0");
//   #MCP @PLACE(-48, 20) => @ORIENT("R0");
//   #CCONT @PLACE(-72, 34) => @ORIENT("R0");
//   #MPCAS @PLACE(-48, 4) => @ORIENT("R0");
//   #MCSTART @PLACE(-48, -18) => @ORIENT("R0");
//   #MCF @PLACE(-30, -18) => @ORIENT("R0");
//   #MNCL @PLACE(-76, -18) => @ORIENT("R0");
//   #MNFB @PLACE(-100, -36) => @ORIENT("R0");
//   #MPFB @PLACE(-100, -12) => @ORIENT("R0");
//   #MBN @PLACE(-144, -36) => @ORIENT("R0");
//   #MBP @PLACE(-144, -12) => @ORIENT("R0");
//   #CBI @PLACE(-126, -12) => @ORIENT("MX");
//   #CBG @PLACE(-126, -36) => @ORIENT("R0");
//   #MBLEED @PLACE(-62, -36) => @ORIENT("R0");
//   #CFF @PLACE(-84, -34) => @ORIENT("R0");
//   #MNRC @PLACE(-16, -34) => @ORIENT("R0");
//   #MDHI @PLACE(60, 4) => @ORIENT("R0");
//   #MDUP @PLACE(78, 4) => @ORIENT("R0");
//   #CMD @PLACE(100, -12) => @ORIENT("R0");
//   #CDN @PLACE(100, -32) => @ORIENT("R0");
//   #MDMID @PLACE(60, -12) => @ORIENT("R0");
//   #MDLO @PLACE(60, -28) => @ORIENT("R0");
//   %p_in = $IO_PORT @ATTACH &VIN => @PLACE(-170, -62) => @ORIENT("R0");
//   %p_clk = $IO_PORT @ATTACH &PHI_B => @PLACE(-170, 20) => @ORIENT("R0");
//   %p_clkb = $IO_PORT @ATTACH &PHI_BB => @PLACE(-170, -24) => @ORIENT("R0");
//   %p_out = $IO_PORT @ATTACH &VG => @PLACE(100, 18) => @ORIENT("MY");
//   %vdd = $SUPPLY @ATTACH &AVDD => @PLACE(0, 54) => @ORIENT("R0");
//   %gnd = $GROUND @ATTACH &VSS => @PLACE(36, -56) => @ORIENT("R0");
//   %jcp = (0, 12); %jcp2 = (12, 12); %jcph = (32, 26);
//   %jbn = (-66, -26); %jgbs = (-62, -50); %jgbb = (-58, -50);
//   %vb = $SUPPLY @ATTACH &AVDD => @PLACE(-70, -30) => @ORIENT("R0");
//   %jgaux = (16, -50); %jvinaux = (12, -62);
//   %jcbip = (-126, 20);
//   %jpc = (-48, 12);
//   %jcn = (0, -2); %jcn2 = (12, -2); %jcnl = (-30, -26);
//   %jctl = (-48, -8); %jvg = (44, 18); %jvgf = (-18, 20);
//   %jdncomp = (60, -20); %jcd = (100, -20); %jgcd = (100, -50);
//   %jdu = (60, -2); %javcas = (50, 4); %jclk = (-92, 20);
//   %jcbf = (-84, -24);
//   %jff = (-162, -24);
//   %jbbin = (-156, -24); %jbi = (-144, -24); %jbic = (-126, -24); %jbig = (-112, -24);
//   %jbbout = (-100, -24); %jbb2 = (-80, -44); %jbbr = (-20, -44);
//   %jsb0 = (-144, 48); %jsb1 = (-136, 48); %jsb2 = (-100, 48); %jsb3 = (-96, 48);
//   %jgb0 = (-144, -50); %jgb1 = (-140, -50); %jgb2 = (-126, -50); %jgb3 = (-100, -50); %jgb4 = (-96, -50); %jgb5 = (-12, -50);
//   %vrc = $SUPPLY @ATTACH &AVDD => @PLACE(-32, -30) => @ORIENT("R0");
//   %js0 = (0, 48); %js1 = (-48, 48); %js2 = (-40, 48); %js3 = (50, 48);
//   %js4 = (-88, 48);
//   %jg0 = (0, -50); %jg1 = (4, -50); %jg2 = (-44, -50); %jg3 = (-26, -50);
//   %jg4 = (36, -50); %jg5 = (60, -50); %jg6 = (64, -50); %jg7 = (70, -50);
//   %jg8 = (86, -50); %jg9 = (66, -50); %jg10 = (-60, -50);
//   %jg11 = (-72, -50);
//   {$JUNCTION} @ATTACH {%jpc %jcbip %jff %jcbf %jgaux %jvinaux %jdncomp %jcd %jgcd %jbn %jgbs %jgbb %jcp %jcp2 %jcph %jcn %jcn2 %jcnl %jctl %jvg %jvgf %jdu %javcas %jclk %jbbin %jbi %jbic %jbig %jsb0 %jsb1 %jsb2 %jsb3 %jgb0 %jgb1 %jgb2 %jgb3 %jgb4 %jgb5 %jbbout %jbb2 %jbbr %js0 %js1 %js2 %js3 %js4 %jg0 %jg1 %jg2 %jg3 %jg4 %jg5 %jg6 %jg7 %jg8 %jg9 %jg10 %jg11};
//   &CBP @WIRE {#MPRE:d %jcp #CB:p};
//   &CBP @WIRE {#MPRE:b (4, 20) (4, 12) %jcp};
//   &CBP @WIRE {%jcp %jcp2 #CB2:p};
//   &CBP @WIRE {%jcp2 (18, 12) (18, 26) %jcph #MXFER:s};
//   &CBP @WIRE {%jcph (36, 26) (36, 20) #MXFER:b};
//   &CBN @WIRE {#CB:n %jcn #MRST:d};
//   &CBN @WIRE {%jcn %jcn2 #CB2:n};
//   &CBN @WIRE {%jcn2 (32, -2) #MTRK:d};
//   &CBN @WIRE {%jcn (-8, -2) (-8, -26) %jcnl (-48, -26) #MCSTART:s};
//   &CBN @WIRE {%jcnl #MCF:s};
//   &PCP @WIRE {#MCP:d %jpc #MPCAS:s};
//   &PCP @WIRE {%jpc (-52, 12) (-52, 40) (-72, 40) #CCONT:p};
//   &GCTL @WIRE {#MPCAS:d %jctl #MCSTART:d};
//   &GCTL @WIRE {%jctl (-30, -8) #MCF:d};
//   &GCTL @WIRE {%jctl (-56, -8) (-56, 32) (24, 32) (24, 20) #MXFER:g};
//   &PHI_N @WIRE {#MNCL:s (-76, -26) %jbn (-66, -18) #MCSTART:g};
//   &PHI_N @WIRE {%jbn (-62, -26) #MBLEED:d};
//   &AVDD @WIRE {%vb:p (-70, -36) #MBLEED:g};
//   &VSS @WIRE {#MBLEED:s %jgbs};
//   &VSS @WIRE {#MBLEED:b (-58, -36) %jgbb};
//   &VG @WIRE {#MXFER:d %jvg (60, 18) %p_out:p};
//   &VG @WIRE {%jvg (44, 38) (-18, 38) %jvgf #MPRE:g};
//   &VG @WIRE {%jvgf (-18, -4) (-38, -4) (-38, -18) #MCF:g};
//   &VG @WIRE {%jvg (44, 10) (22, 10) (22, -4) #MTRK:g};
//   &VG @WIRE {%jvg (60, 18) #MDHI:d};
//   &VG @WIRE {#MDUP:d (78, 18) %jvg};
//   &VG @WIRE {#MDUP:g (72, 4) (72, 16) (78, 16) #MDUP:d};
//   &DU @WIRE {#MDHI:s %jdu #MDMID:d};
//   &DU @WIRE {%jdu (78, -2) #MDUP:s};
//   &DU @WIRE {%jdu (100, -2) #CMD:p};
//   &DN @WIRE {#MDMID:s %jdncomp #MDLO:d};
//   &DN @WIRE {%jdncomp %jcd #CMD:n};
//   &DN @WIRE {%jcd #CDN:p};
//   &VSS @WIRE {#CDN:n %jgcd};
//   &VIN @WIRE {%p_in:p %jvinaux (32, -62) #MTRK:s};
//   &VIN @WIRE {%jvinaux #MAUX:s};
//   &CBN @WIRE {%jcn2 #MAUX:d};
//   &PHI_N @WIRE {%jbn (-66, -54) (6, -54) (6, -30) #MAUX:g};
//   &VSS @WIRE {#MAUX:b (16, -30) %jgaux};
//   &PHI_B @WIRE {%p_clk:p %jcbip %jclk #MCP:g};
//   &PHI_B @WIRE {%jcbip #CBI:n};
//   &PHI_BBI @WIRE {%jbic #CBI:p};
//   &PHI_B @WIRE {%jclk (-92, -8) (-76, -8) #MNCL:d};
//   &PHI_BB @WIRE {%p_clkb:p %jff %jbbin};
//   &PHI_BB @WIRE {%jbbin (-156, -12) #MBP:g};
//   &PHI_BB @WIRE {%jbbin (-156, -36) #MBN:g};
//   &PHI_BBI @WIRE {#MBP:d %jbi #MBN:d};
//   &PHI_BBI @WIRE {%jbi %jbic %jbig};
//   &PHI_BBI @WIRE {%jbic #CBG:p};
//   &PHI_BBI @WIRE {%jbig (-112, -12) #MPFB:g};
//   &PHI_BBI @WIRE {%jbig (-112, -36) #MNFB:g};
//   &PHI_BBF @WIRE {#MPFB:d %jbbout #MNFB:d};
//   &PHI_BBF @WIRE {%jbbout %jcbf (-80, -24) %jbb2 %jbbr (54, -44) (54, -28) #MDLO:g};
//   &PHI_BBF @WIRE {%jbbr (-20, -28) (-16, -28) #MNRC:d};
//   &PHI_BBF @WIRE {%jcbf #CFF:p};
//   &PHI_BB @WIRE {%jff (-162, -52) (-84, -52) #CFF:n};
//   &PHI_BB @WIRE {%jff (-166, -24) (-166, 28) (-72, 28) #CCONT:n};
//   &PHI_R @WIRE {#MNRC:s (-16, -40) (-6, -40) (-6, -18) #MRST:g};
//   &AVDD @WIRE {%vrc:p (-32, -34) #MNRC:g};
//   &AVDD @WIRE {%jsb0 %jsb1 %jsb2 %jsb3 %js4};
//   &AVDD @WIRE {%jsb0 #MBP:s};
//   &AVDD @WIRE {%jsb1 (-136, -12) #MBP:b};
//   &AVDD @WIRE {%jsb2 #MPFB:s};
//   &AVDD @WIRE {%jsb3 (-96, -12) #MPFB:b};
//   &VSS @WIRE {%jgb0 %jgb1 %jgb2 %jgb3 %jgb4 %jg11};
//   &VSS @WIRE {%jgb0 #MBN:s};
//   &VSS @WIRE {%jgb1 (-140, -36) #MBN:b};
//   &VSS @WIRE {%jgb2 #CBG:n};
//   &VSS @WIRE {%jgb3 #MNFB:s};
//   &VSS @WIRE {%jgb4 (-96, -36) #MNFB:b};
//   &VSS @WIRE {%jg3 %jgb5 %jg0};
//   &VSS @WIRE {%jgb5 (-12, -34) #MNRC:b};
//   &AVDD @WIRE {%js4 %js1 %js2 %js0 %js3};
//   &AVDD @WIRE {%js0 %vdd:p}; &AVDD @WIRE {%js0 #MPRE:s};
//   &AVDD @WIRE {%js1 #MCP:s};
//   &AVDD @WIRE {%js2 (-40, 20) #MCP:b};
//   &AVDD @WIRE {%js2 (-40, 4) #MPCAS:b};
//   &AVDD @WIRE {%js4 (-88, -18) #MNCL:g};
//   &AVDD @WIRE {%js3 %javcas #MDHI:g};
//   &AVDD @WIRE {%javcas (50, -12) #MDMID:g};
//   &VSS @WIRE {%jg11 %jgbs %jg10 %jgbb %jg2 %jg3 %jg0 %jg1 %jgaux %jg4 %jg5 %jg6 %jg9 %jg7 %jg8 %jgcd};
//   &VSS @WIRE {%jg4 %gnd:p};
//   &VSS @WIRE {#MCSTART:b (-44, -18) %jg2};
//   &VSS @WIRE {#MCF:b (-26, -18) %jg3};
//   &VSS @WIRE {#MPCAS:g (-60, 4) %jg10};
//   &VSS @WIRE {#MNCL:b (-72, -18) %jg11};
//   &VSS @WIRE {#MRST:s %jg0};
//   &VSS @WIRE {#MRST:b (4, -18) %jg1};
//   &VSS @WIRE {#MTRK:b (36, -4) %jg4};
//   &VSS @WIRE {#MDLO:s %jg5};
//   &VSS @WIRE {#MDLO:b (64, -28) %jg6};
//   &VSS @WIRE {#MDHI:b (70, 4) %jg7};
//   &VSS @WIRE {#MDUP:b (86, 4) %jg8};
//   &VSS @WIRE {#MDMID:b (66, -12) %jg9};
//   (-170, 70) @TEXT("adc_bootstrap: protected control, local clock buffer and reset limiter", halign="start") => @SET-STYLE $title_style;
//   (-170, 67) @TEXT("MPCAS protects control; the two-stage buffer drives PHI_BBF; MNRC limits the MRST gate", halign="start") => @SET-STYLE $note_style;
//   (-170, 65) @TEXT("CB: w=50n s=50n nr=200 lr=40u stm=1 spm=6", halign="start") => @SET-STYLE $param_style;
//   (-170, 63) @TEXT("CB2: w=50n s=50n nr=200 lr=40u stm=1 spm=6", halign="start") => @SET-STYLE $param_style;
//   (-170, 61) @TEXT("CBG: w=50n s=50n nr=12 lr=5u stm=1 spm=6", halign="start") => @SET-STYLE $param_style;
//   (-170, 59) @TEXT("CMD: w=50n s=50n nr=12 lr=5u stm=1 spm=6", halign="start") => @SET-STYLE $param_style;
//   (-170, 57) @TEXT("CDN: w=50n s=50n nr=20 lr=5u stm=1 spm=6", halign="start") => @SET-STYLE $param_style;
//   (-170, 55) @TEXT("CFF: w=50n s=50n nr=6 lr=1u stm=1 spm=6", halign="start") => @SET-STYLE $param_style;
//   (-170, 53) @TEXT("CCONT: w=50n s=50n nr=6 lr=1u stm=1 spm=3", halign="start") => @SET-STYLE $param_style;
//   (-170, 51) @TEXT("CBI: w=50n s=50n nr=6 lr=1u stm=1 spm=3", halign="start") => @SET-STYLE $param_style;
//   (-56, 36) @TEXT("Protected control", halign="start") => @SET-STYLE $note_style;
//   (-162, 0) @TEXT("Local clock buffer", halign="start") => @SET-STYLE $note_style;
//   (48, 30) @TEXT("Gate output / capacitive voltage sharing", halign="start") => @SET-STYLE $note_style;
//   (4, -5) @TEXT("CBN", halign="start") => @SET-STYLE $param_style;
//   (-54, -10) @TEXT("GCTL", halign="start") => @SET-STYLE $param_style;
//   (-44, 12) @TEXT("PCP", halign="start") => @SET-STYLE $param_style;
//   (62, -4) @TEXT("DU", halign="start") => @SET-STYLE $param_style;
//   (62, -20) @TEXT("DN", halign="start") => @SET-STYLE $param_style;
//   {#MPRE #MRST #MTRK #MAUX #MXFER #MCP #MPCAS #MCSTART #MCF #MDHI #MDUP #MDMID #MDLO #MNFB #MPFB #MNCL #MBN #MBP #MNRC #MBLEED} @TEXT("W=${w} L=${l} nf=${nf}", key="dims", dy=-4, size=0.6);
//   (-170, -69) @TEXT("Work in progress: review the measurements and remaining verification in the draft PR", halign="start") => @SET-STYLE $note_style;
// }
ends adc_bootstrap
