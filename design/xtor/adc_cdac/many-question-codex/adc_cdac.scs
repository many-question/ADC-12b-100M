// CDAC: physical unit MOM banks, MOS switches, and user-specified parasitic estimates.
// @RNL(type="header") {
//   @VERSION("0.3");
//   @USE-PACKAGE(name="adc28", version="0.1", path="../../../rnl/adc28.rnl")
// }
simulator lang=spectre
// @RNL {
//   $S_mq_cdac_ctl_l = @DEFINE-SYMBOL(box=[-7, -4, 7, 4]) {
//     @LINE(linewidth=0.24) {(-6, -3) (6, -3) (6, 3) (-6, 3) (-6, -3)};
//     (-7, 0) @PIN(terminal=1, direction="left");
//     @LINE {(-7, 0) (-6, 0)};
//     (-5.65, 0) @TEXT("IN", size=0.55, halign="start", valign="middle");
//     (7, 0) @PIN(terminal=2, direction="right");
//     @LINE {(7, 0) (6, 0)};
//     (5.65, 0) @TEXT("HIB", size=0.55, halign="end", valign="middle");
//     (0, 4) @PIN(terminal=3, direction="up");
//     @LINE {(0, 4) (0, 3)};
//     (-2, -4) @PIN(terminal=4, direction="down");
//     @LINE {(-2, -4) (-2, -3)};
//     (2, -4) @PIN(terminal=5, direction="down");
//     @LINE {(2, -4) (2, -3)};
//     (0, 0.3) @TEXT("DVDD command buffer L", size=0.7, bold=true, halign="middle", valign="bottom");
//     ? @TEXT("${name}", key="name", size=0.8, valign="bottom") => @PLACE(-6, 3.5);
//     ? @TEXT("${model}", key="model", size=0.5, halign="middle", valign="top") => @PLACE(0, -0.3)
//   };
//   # @SELECT-INSTANCE(model="mq_cdac_ctl_l") => @SET-SYMBOL $S_mq_cdac_ctl_l;
//   $S_mq_cdac_ctl_h = @DEFINE-SYMBOL(box=[-7, -4, 7, 4]) {
//     @LINE(linewidth=0.24) {(-6, -3) (6, -3) (6, 3) (-6, 3) (-6, -3)};
//     (-7, 0) @PIN(terminal=1, direction="left");
//     @LINE {(-7, 0) (-6, 0)};
//     (-5.65, 0) @TEXT("IN", size=0.55, halign="start", valign="middle");
//     (7, 0) @PIN(terminal=2, direction="right");
//     @LINE {(7, 0) (6, 0)};
//     (5.65, 0) @TEXT("HIB", size=0.55, halign="end", valign="middle");
//     (0, 4) @PIN(terminal=3, direction="up");
//     @LINE {(0, 4) (0, 3)};
//     (-2, -4) @PIN(terminal=4, direction="down");
//     @LINE {(-2, -4) (-2, -3)};
//     (2, -4) @PIN(terminal=5, direction="down");
//     @LINE {(2, -4) (2, -3)};
//     (0, 0.3) @TEXT("DVDD command buffer H", size=0.7, bold=true, halign="middle", valign="bottom");
//     ? @TEXT("${name}", key="name", size=0.8, valign="bottom") => @PLACE(-6, 3.5);
//     ? @TEXT("${model}", key="model", size=0.5, halign="middle", valign="top") => @PLACE(0, -0.3)
//   };
//   # @SELECT-INSTANCE(model="mq_cdac_ctl_h") => @SET-SYMBOL $S_mq_cdac_ctl_h;
//   $S_mq_cdac_enable = @DEFINE-SYMBOL(box=[-7, -4, 7, 4]) {
//     @LINE(linewidth=0.24) {(-6, -3) (6, -3) (6, 3) (-6, 3) (-6, -3)};
//     (-7, 0) @PIN(terminal=1, direction="left");
//     @LINE {(-7, 0) (-6, 0)};
//     (-5.65, 0) @TEXT("IN", size=0.55, halign="start", valign="middle");
//     (7, 1) @PIN(terminal=2, direction="right");
//     @LINE {(7, 1) (6, 1)};
//     (5.65, 1) @TEXT("EN", size=0.55, halign="end", valign="middle");
//     (7, -1) @PIN(terminal=3, direction="right");
//     @LINE {(7, -1) (6, -1)};
//     (5.65, -1) @TEXT("ENB", size=0.55, halign="end", valign="middle");
//     (0, 4) @PIN(terminal=4, direction="up");
//     @LINE {(0, 4) (0, 3)};
//     (-2, -4) @PIN(terminal=5, direction="down");
//     @LINE {(-2, -4) (-2, -3)};
//     (2, -4) @PIN(terminal=6, direction="down");
//     @LINE {(2, -4) (2, -3)};
//     (0, 0.3) @TEXT("DVDD conversion-enable buffer", size=0.7, bold=true, halign="middle", valign="bottom");
//     ? @TEXT("${name}", key="name", size=0.8, valign="bottom") => @PLACE(-6, 3.5);
//     ? @TEXT("${model}", key="model", size=0.5, halign="middle", valign="top") => @PLACE(0, -0.3)
//   };
//   # @SELECT-INSTANCE(model="mq_cdac_enable") => @SET-SYMBOL $S_mq_cdac_enable;
//   $S_mq_cdac_drv12 = @DEFINE-SYMBOL(box=[-7, -5, 7, 5]) {
//     @LINE(linewidth=0.24) {(-6, -4) (6, -4) (6, 4) (-6, 4) (-6, -4)};
//     (-7, 2) @PIN(terminal=1, direction="left");
//     @LINE {(-7, 2) (-6, 2)};
//     (-5.65, 2) @TEXT("HIB", size=0.55, halign="start", valign="middle");
//     (-7, 0) @PIN(terminal=2, direction="left");
//     @LINE {(-7, 0) (-6, 0)};
//     (-5.65, 0) @TEXT("EN", size=0.55, halign="start", valign="middle");
//     (-7, -2) @PIN(terminal=3, direction="left");
//     @LINE {(-7, -2) (-6, -2)};
//     (-5.65, -2) @TEXT("ENB", size=0.55, halign="start", valign="middle");
//     (7, 0) @PIN(terminal=4, direction="right");
//     @LINE {(7, 0) (6, 0)};
//     (5.65, 0) @TEXT("BP", size=0.55, halign="end", valign="middle");
//     (-2, 5) @PIN(terminal=5, direction="up");
//     @LINE {(-2, 5) (-2, 4)};
//     (2, 5) @PIN(terminal=8, direction="up");
//     @LINE {(2, 5) (2, 4)};
//     (-2, -5) @PIN(terminal=6, direction="down");
//     @LINE {(-2, -5) (-2, -4)};
//     (2, -5) @PIN(terminal=7, direction="down");
//     @LINE {(2, -5) (2, -4)};
//     (0, 0.3) @TEXT("Reference-rail output driver j=12", size=0.7, bold=true, halign="middle", valign="bottom");
//     ? @TEXT("${name}", key="name", size=0.8, valign="bottom") => @PLACE(-6, 4.5);
//     ? @TEXT("${model}", key="model", size=0.5, halign="middle", valign="top") => @PLACE(0, -0.3)
//   };
//   # @SELECT-INSTANCE(model="mq_cdac_drv12") => @SET-SYMBOL $S_mq_cdac_drv12;
//   $S_mq_cdac_bit12 = @DEFINE-SYMBOL(box=[-7, -10, 7, 10]) {
//     @LINE(linewidth=0.24) {(-6, -9) (6, -9) (6, 9) (-6, 9) (-6, -9)};
//     (-7, 7) @PIN(terminal=1, direction="left");
//     @LINE {(-7, 7) (-6, 7)};
//     (-5.65, 7) @TEXT("VIN", size=0.55, halign="start", valign="middle");
//     (-7, 5) @PIN(terminal=2, direction="left");
//     @LINE {(-7, 5) (-6, 5)};
//     (-5.65, 5) @TEXT("VG", size=0.55, halign="start", valign="middle");
//     (-7, 3) @PIN(terminal=3, direction="left");
//     @LINE {(-7, 3) (-6, 3)};
//     (-5.65, 3) @TEXT("DH", size=0.55, halign="start", valign="middle");
//     (-7, 1) @PIN(terminal=4, direction="left");
//     @LINE {(-7, 1) (-6, 1)};
//     (-5.65, 1) @TEXT("RL", size=0.55, halign="start", valign="middle");
//     (-7, -1) @PIN(terminal=5, direction="left");
//     @LINE {(-7, -1) (-6, -1)};
//     (-5.65, -1) @TEXT("EN", size=0.55, halign="start", valign="middle");
//     (-7, -3) @PIN(terminal=6, direction="left");
//     @LINE {(-7, -3) (-6, -3)};
//     (-5.65, -3) @TEXT("ENB", size=0.55, halign="start", valign="middle");
//     (-7, -5) @PIN(terminal=12, direction="left");
//     @LINE {(-7, -5) (-6, -5)};
//     (-5.65, -5) @TEXT("EQBUS", size=0.55, halign="start", valign="middle");
//     (-7, -7) @PIN(terminal=13, direction="left");
//     @LINE {(-7, -7) (-6, -7)};
//     (-5.65, -7) @TEXT("APGATE", size=0.55, halign="start", valign="middle");
//     (7, 0) @PIN(terminal=7, direction="right");
//     @LINE {(7, 0) (6, 0)};
//     (5.65, 0) @TEXT("TOP", size=0.55, halign="end", valign="middle");
//     (-2, 10) @PIN(terminal=8, direction="up");
//     @LINE {(-2, 10) (-2, 9)};
//     (2, 10) @PIN(terminal=11, direction="up");
//     @LINE {(2, 10) (2, 9)};
//     (-2, -10) @PIN(terminal=9, direction="down");
//     @LINE {(-2, -10) (-2, -9)};
//     (2, -10) @PIN(terminal=10, direction="down");
//     @LINE {(2, -10) (2, -9)};
//     (0, 0.3) @TEXT("Matched half-capacitor pair j=12", size=0.7, bold=true, halign="middle", valign="bottom");
//     ? @TEXT("${name}", key="name", size=0.8, valign="bottom") => @PLACE(-6, 9.5);
//     ? @TEXT("${model}", key="model", size=0.5, halign="middle", valign="top") => @PLACE(0, -0.3)
//   };
//   # @SELECT-INSTANCE(model="mq_cdac_bit12") => @SET-SYMBOL $S_mq_cdac_bit12;
//   $S_mq_cdac_drv11 = @DEFINE-SYMBOL(box=[-7, -5, 7, 5]) {
//     @LINE(linewidth=0.24) {(-6, -4) (6, -4) (6, 4) (-6, 4) (-6, -4)};
//     (-7, 2) @PIN(terminal=1, direction="left");
//     @LINE {(-7, 2) (-6, 2)};
//     (-5.65, 2) @TEXT("HIB", size=0.55, halign="start", valign="middle");
//     (-7, 0) @PIN(terminal=2, direction="left");
//     @LINE {(-7, 0) (-6, 0)};
//     (-5.65, 0) @TEXT("EN", size=0.55, halign="start", valign="middle");
//     (-7, -2) @PIN(terminal=3, direction="left");
//     @LINE {(-7, -2) (-6, -2)};
//     (-5.65, -2) @TEXT("ENB", size=0.55, halign="start", valign="middle");
//     (7, 0) @PIN(terminal=4, direction="right");
//     @LINE {(7, 0) (6, 0)};
//     (5.65, 0) @TEXT("BP", size=0.55, halign="end", valign="middle");
//     (-2, 5) @PIN(terminal=5, direction="up");
//     @LINE {(-2, 5) (-2, 4)};
//     (2, 5) @PIN(terminal=8, direction="up");
//     @LINE {(2, 5) (2, 4)};
//     (-2, -5) @PIN(terminal=6, direction="down");
//     @LINE {(-2, -5) (-2, -4)};
//     (2, -5) @PIN(terminal=7, direction="down");
//     @LINE {(2, -5) (2, -4)};
//     (0, 0.3) @TEXT("Reference-rail output driver j=11", size=0.7, bold=true, halign="middle", valign="bottom");
//     ? @TEXT("${name}", key="name", size=0.8, valign="bottom") => @PLACE(-6, 4.5);
//     ? @TEXT("${model}", key="model", size=0.5, halign="middle", valign="top") => @PLACE(0, -0.3)
//   };
//   # @SELECT-INSTANCE(model="mq_cdac_drv11") => @SET-SYMBOL $S_mq_cdac_drv11;
//   $S_mq_cdac_bit11 = @DEFINE-SYMBOL(box=[-7, -10, 7, 10]) {
//     @LINE(linewidth=0.24) {(-6, -9) (6, -9) (6, 9) (-6, 9) (-6, -9)};
//     (-7, 7) @PIN(terminal=1, direction="left");
//     @LINE {(-7, 7) (-6, 7)};
//     (-5.65, 7) @TEXT("VIN", size=0.55, halign="start", valign="middle");
//     (-7, 5) @PIN(terminal=2, direction="left");
//     @LINE {(-7, 5) (-6, 5)};
//     (-5.65, 5) @TEXT("VG", size=0.55, halign="start", valign="middle");
//     (-7, 3) @PIN(terminal=3, direction="left");
//     @LINE {(-7, 3) (-6, 3)};
//     (-5.65, 3) @TEXT("DH", size=0.55, halign="start", valign="middle");
//     (-7, 1) @PIN(terminal=4, direction="left");
//     @LINE {(-7, 1) (-6, 1)};
//     (-5.65, 1) @TEXT("RL", size=0.55, halign="start", valign="middle");
//     (-7, -1) @PIN(terminal=5, direction="left");
//     @LINE {(-7, -1) (-6, -1)};
//     (-5.65, -1) @TEXT("EN", size=0.55, halign="start", valign="middle");
//     (-7, -3) @PIN(terminal=6, direction="left");
//     @LINE {(-7, -3) (-6, -3)};
//     (-5.65, -3) @TEXT("ENB", size=0.55, halign="start", valign="middle");
//     (-7, -5) @PIN(terminal=12, direction="left");
//     @LINE {(-7, -5) (-6, -5)};
//     (-5.65, -5) @TEXT("EQBUS", size=0.55, halign="start", valign="middle");
//     (-7, -7) @PIN(terminal=13, direction="left");
//     @LINE {(-7, -7) (-6, -7)};
//     (-5.65, -7) @TEXT("APGATE", size=0.55, halign="start", valign="middle");
//     (7, 0) @PIN(terminal=7, direction="right");
//     @LINE {(7, 0) (6, 0)};
//     (5.65, 0) @TEXT("TOP", size=0.55, halign="end", valign="middle");
//     (-2, 10) @PIN(terminal=8, direction="up");
//     @LINE {(-2, 10) (-2, 9)};
//     (2, 10) @PIN(terminal=11, direction="up");
//     @LINE {(2, 10) (2, 9)};
//     (-2, -10) @PIN(terminal=9, direction="down");
//     @LINE {(-2, -10) (-2, -9)};
//     (2, -10) @PIN(terminal=10, direction="down");
//     @LINE {(2, -10) (2, -9)};
//     (0, 0.3) @TEXT("Matched half-capacitor pair j=11", size=0.7, bold=true, halign="middle", valign="bottom");
//     ? @TEXT("${name}", key="name", size=0.8, valign="bottom") => @PLACE(-6, 9.5);
//     ? @TEXT("${model}", key="model", size=0.5, halign="middle", valign="top") => @PLACE(0, -0.3)
//   };
//   # @SELECT-INSTANCE(model="mq_cdac_bit11") => @SET-SYMBOL $S_mq_cdac_bit11;
//   $S_mq_cdac_drv10 = @DEFINE-SYMBOL(box=[-7, -5, 7, 5]) {
//     @LINE(linewidth=0.24) {(-6, -4) (6, -4) (6, 4) (-6, 4) (-6, -4)};
//     (-7, 2) @PIN(terminal=1, direction="left");
//     @LINE {(-7, 2) (-6, 2)};
//     (-5.65, 2) @TEXT("HIB", size=0.55, halign="start", valign="middle");
//     (-7, 0) @PIN(terminal=2, direction="left");
//     @LINE {(-7, 0) (-6, 0)};
//     (-5.65, 0) @TEXT("EN", size=0.55, halign="start", valign="middle");
//     (-7, -2) @PIN(terminal=3, direction="left");
//     @LINE {(-7, -2) (-6, -2)};
//     (-5.65, -2) @TEXT("ENB", size=0.55, halign="start", valign="middle");
//     (7, 0) @PIN(terminal=4, direction="right");
//     @LINE {(7, 0) (6, 0)};
//     (5.65, 0) @TEXT("BP", size=0.55, halign="end", valign="middle");
//     (-2, 5) @PIN(terminal=5, direction="up");
//     @LINE {(-2, 5) (-2, 4)};
//     (2, 5) @PIN(terminal=8, direction="up");
//     @LINE {(2, 5) (2, 4)};
//     (-2, -5) @PIN(terminal=6, direction="down");
//     @LINE {(-2, -5) (-2, -4)};
//     (2, -5) @PIN(terminal=7, direction="down");
//     @LINE {(2, -5) (2, -4)};
//     (0, 0.3) @TEXT("Reference-rail output driver j=10", size=0.7, bold=true, halign="middle", valign="bottom");
//     ? @TEXT("${name}", key="name", size=0.8, valign="bottom") => @PLACE(-6, 4.5);
//     ? @TEXT("${model}", key="model", size=0.5, halign="middle", valign="top") => @PLACE(0, -0.3)
//   };
//   # @SELECT-INSTANCE(model="mq_cdac_drv10") => @SET-SYMBOL $S_mq_cdac_drv10;
//   $S_mq_cdac_bit10 = @DEFINE-SYMBOL(box=[-7, -10, 7, 10]) {
//     @LINE(linewidth=0.24) {(-6, -9) (6, -9) (6, 9) (-6, 9) (-6, -9)};
//     (-7, 7) @PIN(terminal=1, direction="left");
//     @LINE {(-7, 7) (-6, 7)};
//     (-5.65, 7) @TEXT("VIN", size=0.55, halign="start", valign="middle");
//     (-7, 5) @PIN(terminal=2, direction="left");
//     @LINE {(-7, 5) (-6, 5)};
//     (-5.65, 5) @TEXT("VG", size=0.55, halign="start", valign="middle");
//     (-7, 3) @PIN(terminal=3, direction="left");
//     @LINE {(-7, 3) (-6, 3)};
//     (-5.65, 3) @TEXT("DH", size=0.55, halign="start", valign="middle");
//     (-7, 1) @PIN(terminal=4, direction="left");
//     @LINE {(-7, 1) (-6, 1)};
//     (-5.65, 1) @TEXT("RL", size=0.55, halign="start", valign="middle");
//     (-7, -1) @PIN(terminal=5, direction="left");
//     @LINE {(-7, -1) (-6, -1)};
//     (-5.65, -1) @TEXT("EN", size=0.55, halign="start", valign="middle");
//     (-7, -3) @PIN(terminal=6, direction="left");
//     @LINE {(-7, -3) (-6, -3)};
//     (-5.65, -3) @TEXT("ENB", size=0.55, halign="start", valign="middle");
//     (-7, -5) @PIN(terminal=12, direction="left");
//     @LINE {(-7, -5) (-6, -5)};
//     (-5.65, -5) @TEXT("EQBUS", size=0.55, halign="start", valign="middle");
//     (-7, -7) @PIN(terminal=13, direction="left");
//     @LINE {(-7, -7) (-6, -7)};
//     (-5.65, -7) @TEXT("APGATE", size=0.55, halign="start", valign="middle");
//     (7, 0) @PIN(terminal=7, direction="right");
//     @LINE {(7, 0) (6, 0)};
//     (5.65, 0) @TEXT("TOP", size=0.55, halign="end", valign="middle");
//     (-2, 10) @PIN(terminal=8, direction="up");
//     @LINE {(-2, 10) (-2, 9)};
//     (2, 10) @PIN(terminal=11, direction="up");
//     @LINE {(2, 10) (2, 9)};
//     (-2, -10) @PIN(terminal=9, direction="down");
//     @LINE {(-2, -10) (-2, -9)};
//     (2, -10) @PIN(terminal=10, direction="down");
//     @LINE {(2, -10) (2, -9)};
//     (0, 0.3) @TEXT("Matched half-capacitor pair j=10", size=0.7, bold=true, halign="middle", valign="bottom");
//     ? @TEXT("${name}", key="name", size=0.8, valign="bottom") => @PLACE(-6, 9.5);
//     ? @TEXT("${model}", key="model", size=0.5, halign="middle", valign="top") => @PLACE(0, -0.3)
//   };
//   # @SELECT-INSTANCE(model="mq_cdac_bit10") => @SET-SYMBOL $S_mq_cdac_bit10;
//   $S_mq_cdac_drv9 = @DEFINE-SYMBOL(box=[-7, -5, 7, 5]) {
//     @LINE(linewidth=0.24) {(-6, -4) (6, -4) (6, 4) (-6, 4) (-6, -4)};
//     (-7, 2) @PIN(terminal=1, direction="left");
//     @LINE {(-7, 2) (-6, 2)};
//     (-5.65, 2) @TEXT("HIB", size=0.55, halign="start", valign="middle");
//     (-7, 0) @PIN(terminal=2, direction="left");
//     @LINE {(-7, 0) (-6, 0)};
//     (-5.65, 0) @TEXT("EN", size=0.55, halign="start", valign="middle");
//     (-7, -2) @PIN(terminal=3, direction="left");
//     @LINE {(-7, -2) (-6, -2)};
//     (-5.65, -2) @TEXT("ENB", size=0.55, halign="start", valign="middle");
//     (7, 0) @PIN(terminal=4, direction="right");
//     @LINE {(7, 0) (6, 0)};
//     (5.65, 0) @TEXT("BP", size=0.55, halign="end", valign="middle");
//     (-2, 5) @PIN(terminal=5, direction="up");
//     @LINE {(-2, 5) (-2, 4)};
//     (2, 5) @PIN(terminal=8, direction="up");
//     @LINE {(2, 5) (2, 4)};
//     (-2, -5) @PIN(terminal=6, direction="down");
//     @LINE {(-2, -5) (-2, -4)};
//     (2, -5) @PIN(terminal=7, direction="down");
//     @LINE {(2, -5) (2, -4)};
//     (0, 0.3) @TEXT("Reference-rail output driver j=9", size=0.7, bold=true, halign="middle", valign="bottom");
//     ? @TEXT("${name}", key="name", size=0.8, valign="bottom") => @PLACE(-6, 4.5);
//     ? @TEXT("${model}", key="model", size=0.5, halign="middle", valign="top") => @PLACE(0, -0.3)
//   };
//   # @SELECT-INSTANCE(model="mq_cdac_drv9") => @SET-SYMBOL $S_mq_cdac_drv9;
//   $S_mq_cdac_bit9 = @DEFINE-SYMBOL(box=[-7, -6, 7, 6]) {
//     @LINE(linewidth=0.24) {(-6, -5) (6, -5) (6, 5) (-6, 5) (-6, -5)};
//     (-7, 3) @PIN(terminal=1, direction="left");
//     @LINE {(-7, 3) (-6, 3)};
//     (-5.65, 3) @TEXT("DH", size=0.55, halign="start", valign="middle");
//     (-7, 1) @PIN(terminal=2, direction="left");
//     @LINE {(-7, 1) (-6, 1)};
//     (-5.65, 1) @TEXT("RL", size=0.55, halign="start", valign="middle");
//     (-7, -1) @PIN(terminal=3, direction="left");
//     @LINE {(-7, -1) (-6, -1)};
//     (-5.65, -1) @TEXT("EN", size=0.55, halign="start", valign="middle");
//     (-7, -3) @PIN(terminal=4, direction="left");
//     @LINE {(-7, -3) (-6, -3)};
//     (-5.65, -3) @TEXT("ENB", size=0.55, halign="start", valign="middle");
//     (7, 0) @PIN(terminal=5, direction="right");
//     @LINE {(7, 0) (6, 0)};
//     (5.65, 0) @TEXT("TOP", size=0.55, halign="end", valign="middle");
//     (-2, 6) @PIN(terminal=6, direction="up");
//     @LINE {(-2, 6) (-2, 5)};
//     (2, 6) @PIN(terminal=9, direction="up");
//     @LINE {(2, 6) (2, 5)};
//     (-2, -6) @PIN(terminal=7, direction="down");
//     @LINE {(-2, -6) (-2, -5)};
//     (2, -6) @PIN(terminal=8, direction="down");
//     @LINE {(2, -6) (2, -5)};
//     (0, 0.3) @TEXT("Matched half-capacitor pair j=9", size=0.7, bold=true, halign="middle", valign="bottom");
//     ? @TEXT("${name}", key="name", size=0.8, valign="bottom") => @PLACE(-6, 5.5);
//     ? @TEXT("${model}", key="model", size=0.5, halign="middle", valign="top") => @PLACE(0, -0.3)
//   };
//   # @SELECT-INSTANCE(model="mq_cdac_bit9") => @SET-SYMBOL $S_mq_cdac_bit9;
//   $S_mq_cdac_drv8 = @DEFINE-SYMBOL(box=[-7, -5, 7, 5]) {
//     @LINE(linewidth=0.24) {(-6, -4) (6, -4) (6, 4) (-6, 4) (-6, -4)};
//     (-7, 2) @PIN(terminal=1, direction="left");
//     @LINE {(-7, 2) (-6, 2)};
//     (-5.65, 2) @TEXT("HIB", size=0.55, halign="start", valign="middle");
//     (-7, 0) @PIN(terminal=2, direction="left");
//     @LINE {(-7, 0) (-6, 0)};
//     (-5.65, 0) @TEXT("EN", size=0.55, halign="start", valign="middle");
//     (-7, -2) @PIN(terminal=3, direction="left");
//     @LINE {(-7, -2) (-6, -2)};
//     (-5.65, -2) @TEXT("ENB", size=0.55, halign="start", valign="middle");
//     (7, 0) @PIN(terminal=4, direction="right");
//     @LINE {(7, 0) (6, 0)};
//     (5.65, 0) @TEXT("BP", size=0.55, halign="end", valign="middle");
//     (-2, 5) @PIN(terminal=5, direction="up");
//     @LINE {(-2, 5) (-2, 4)};
//     (2, 5) @PIN(terminal=8, direction="up");
//     @LINE {(2, 5) (2, 4)};
//     (-2, -5) @PIN(terminal=6, direction="down");
//     @LINE {(-2, -5) (-2, -4)};
//     (2, -5) @PIN(terminal=7, direction="down");
//     @LINE {(2, -5) (2, -4)};
//     (0, 0.3) @TEXT("Reference-rail output driver j=8", size=0.7, bold=true, halign="middle", valign="bottom");
//     ? @TEXT("${name}", key="name", size=0.8, valign="bottom") => @PLACE(-6, 4.5);
//     ? @TEXT("${model}", key="model", size=0.5, halign="middle", valign="top") => @PLACE(0, -0.3)
//   };
//   # @SELECT-INSTANCE(model="mq_cdac_drv8") => @SET-SYMBOL $S_mq_cdac_drv8;
//   $S_mq_cdac_bit8 = @DEFINE-SYMBOL(box=[-7, -10, 7, 10]) {
//     @LINE(linewidth=0.24) {(-6, -9) (6, -9) (6, 9) (-6, 9) (-6, -9)};
//     (-7, 7) @PIN(terminal=1, direction="left");
//     @LINE {(-7, 7) (-6, 7)};
//     (-5.65, 7) @TEXT("VIN", size=0.55, halign="start", valign="middle");
//     (-7, 5) @PIN(terminal=2, direction="left");
//     @LINE {(-7, 5) (-6, 5)};
//     (-5.65, 5) @TEXT("VG", size=0.55, halign="start", valign="middle");
//     (-7, 3) @PIN(terminal=3, direction="left");
//     @LINE {(-7, 3) (-6, 3)};
//     (-5.65, 3) @TEXT("DH", size=0.55, halign="start", valign="middle");
//     (-7, 1) @PIN(terminal=4, direction="left");
//     @LINE {(-7, 1) (-6, 1)};
//     (-5.65, 1) @TEXT("RL", size=0.55, halign="start", valign="middle");
//     (-7, -1) @PIN(terminal=5, direction="left");
//     @LINE {(-7, -1) (-6, -1)};
//     (-5.65, -1) @TEXT("EN", size=0.55, halign="start", valign="middle");
//     (-7, -3) @PIN(terminal=6, direction="left");
//     @LINE {(-7, -3) (-6, -3)};
//     (-5.65, -3) @TEXT("ENB", size=0.55, halign="start", valign="middle");
//     (-7, -5) @PIN(terminal=12, direction="left");
//     @LINE {(-7, -5) (-6, -5)};
//     (-5.65, -5) @TEXT("EQBUS", size=0.55, halign="start", valign="middle");
//     (-7, -7) @PIN(terminal=13, direction="left");
//     @LINE {(-7, -7) (-6, -7)};
//     (-5.65, -7) @TEXT("APGATE", size=0.55, halign="start", valign="middle");
//     (7, 0) @PIN(terminal=7, direction="right");
//     @LINE {(7, 0) (6, 0)};
//     (5.65, 0) @TEXT("TOP", size=0.55, halign="end", valign="middle");
//     (-2, 10) @PIN(terminal=8, direction="up");
//     @LINE {(-2, 10) (-2, 9)};
//     (2, 10) @PIN(terminal=11, direction="up");
//     @LINE {(2, 10) (2, 9)};
//     (-2, -10) @PIN(terminal=9, direction="down");
//     @LINE {(-2, -10) (-2, -9)};
//     (2, -10) @PIN(terminal=10, direction="down");
//     @LINE {(2, -10) (2, -9)};
//     (0, 0.3) @TEXT("Matched half-capacitor pair j=8", size=0.7, bold=true, halign="middle", valign="bottom");
//     ? @TEXT("${name}", key="name", size=0.8, valign="bottom") => @PLACE(-6, 9.5);
//     ? @TEXT("${model}", key="model", size=0.5, halign="middle", valign="top") => @PLACE(0, -0.3)
//   };
//   # @SELECT-INSTANCE(model="mq_cdac_bit8") => @SET-SYMBOL $S_mq_cdac_bit8;
//   $S_mq_cdac_drv7 = @DEFINE-SYMBOL(box=[-7, -5, 7, 5]) {
//     @LINE(linewidth=0.24) {(-6, -4) (6, -4) (6, 4) (-6, 4) (-6, -4)};
//     (-7, 2) @PIN(terminal=1, direction="left");
//     @LINE {(-7, 2) (-6, 2)};
//     (-5.65, 2) @TEXT("HIB", size=0.55, halign="start", valign="middle");
//     (-7, 0) @PIN(terminal=2, direction="left");
//     @LINE {(-7, 0) (-6, 0)};
//     (-5.65, 0) @TEXT("EN", size=0.55, halign="start", valign="middle");
//     (-7, -2) @PIN(terminal=3, direction="left");
//     @LINE {(-7, -2) (-6, -2)};
//     (-5.65, -2) @TEXT("ENB", size=0.55, halign="start", valign="middle");
//     (7, 0) @PIN(terminal=4, direction="right");
//     @LINE {(7, 0) (6, 0)};
//     (5.65, 0) @TEXT("BP", size=0.55, halign="end", valign="middle");
//     (-2, 5) @PIN(terminal=5, direction="up");
//     @LINE {(-2, 5) (-2, 4)};
//     (2, 5) @PIN(terminal=8, direction="up");
//     @LINE {(2, 5) (2, 4)};
//     (-2, -5) @PIN(terminal=6, direction="down");
//     @LINE {(-2, -5) (-2, -4)};
//     (2, -5) @PIN(terminal=7, direction="down");
//     @LINE {(2, -5) (2, -4)};
//     (0, 0.3) @TEXT("Reference-rail output driver j=7", size=0.7, bold=true, halign="middle", valign="bottom");
//     ? @TEXT("${name}", key="name", size=0.8, valign="bottom") => @PLACE(-6, 4.5);
//     ? @TEXT("${model}", key="model", size=0.5, halign="middle", valign="top") => @PLACE(0, -0.3)
//   };
//   # @SELECT-INSTANCE(model="mq_cdac_drv7") => @SET-SYMBOL $S_mq_cdac_drv7;
//   $S_mq_cdac_bit7 = @DEFINE-SYMBOL(box=[-7, -12, 7, 12]) {
//     @LINE(linewidth=0.24) {(-6, -11) (6, -11) (6, 11) (-6, 11) (-6, -11)};
//     (-7, 9) @PIN(terminal=1, direction="left");
//     @LINE {(-7, 9) (-6, 9)};
//     (-5.65, 9) @TEXT("VIN", size=0.55, halign="start", valign="middle");
//     (-7, 7) @PIN(terminal=2, direction="left");
//     @LINE {(-7, 7) (-6, 7)};
//     (-5.65, 7) @TEXT("VG", size=0.55, halign="start", valign="middle");
//     (-7, 5) @PIN(terminal=3, direction="left");
//     @LINE {(-7, 5) (-6, 5)};
//     (-5.65, 5) @TEXT("DH", size=0.55, halign="start", valign="middle");
//     (-7, 3) @PIN(terminal=4, direction="left");
//     @LINE {(-7, 3) (-6, 3)};
//     (-5.65, 3) @TEXT("RL", size=0.55, halign="start", valign="middle");
//     (-7, 1) @PIN(terminal=5, direction="left");
//     @LINE {(-7, 1) (-6, 1)};
//     (-5.65, 1) @TEXT("EN", size=0.55, halign="start", valign="middle");
//     (-7, -1) @PIN(terminal=6, direction="left");
//     @LINE {(-7, -1) (-6, -1)};
//     (-5.65, -1) @TEXT("ENB", size=0.55, halign="start", valign="middle");
//     (-7, -3) @PIN(terminal=11, direction="left");
//     @LINE {(-7, -3) (-6, -3)};
//     (-5.65, -3) @TEXT("PHI_S", size=0.55, halign="start", valign="middle");
//     (-7, -5) @PIN(terminal=13, direction="left");
//     @LINE {(-7, -5) (-6, -5)};
//     (-5.65, -5) @TEXT("PHI_SB", size=0.55, halign="start", valign="middle");
//     (-7, -7) @PIN(terminal=14, direction="left");
//     @LINE {(-7, -7) (-6, -7)};
//     (-5.65, -7) @TEXT("EQBUS", size=0.55, halign="start", valign="middle");
//     (-7, -9) @PIN(terminal=15, direction="left");
//     @LINE {(-7, -9) (-6, -9)};
//     (-5.65, -9) @TEXT("APGATE", size=0.55, halign="start", valign="middle");
//     (7, 0) @PIN(terminal=7, direction="right");
//     @LINE {(7, 0) (6, 0)};
//     (5.65, 0) @TEXT("TOP", size=0.55, halign="end", valign="middle");
//     (-2, 12) @PIN(terminal=8, direction="up");
//     @LINE {(-2, 12) (-2, 11)};
//     (2, 12) @PIN(terminal=12, direction="up");
//     @LINE {(2, 12) (2, 11)};
//     (-2, -12) @PIN(terminal=9, direction="down");
//     @LINE {(-2, -12) (-2, -11)};
//     (2, -12) @PIN(terminal=10, direction="down");
//     @LINE {(2, -12) (2, -11)};
//     (0, 0.3) @TEXT("Matched half-capacitor pair j=7", size=0.7, bold=true, halign="middle", valign="bottom");
//     ? @TEXT("${name}", key="name", size=0.8, valign="bottom") => @PLACE(-6, 11.5);
//     ? @TEXT("${model}", key="model", size=0.5, halign="middle", valign="top") => @PLACE(0, -0.3)
//   };
//   # @SELECT-INSTANCE(model="mq_cdac_bit7") => @SET-SYMBOL $S_mq_cdac_bit7;
//   $S_mq_cdac_drv6 = @DEFINE-SYMBOL(box=[-7, -5, 7, 5]) {
//     @LINE(linewidth=0.24) {(-6, -4) (6, -4) (6, 4) (-6, 4) (-6, -4)};
//     (-7, 2) @PIN(terminal=1, direction="left");
//     @LINE {(-7, 2) (-6, 2)};
//     (-5.65, 2) @TEXT("HIB", size=0.55, halign="start", valign="middle");
//     (-7, 0) @PIN(terminal=2, direction="left");
//     @LINE {(-7, 0) (-6, 0)};
//     (-5.65, 0) @TEXT("EN", size=0.55, halign="start", valign="middle");
//     (-7, -2) @PIN(terminal=3, direction="left");
//     @LINE {(-7, -2) (-6, -2)};
//     (-5.65, -2) @TEXT("ENB", size=0.55, halign="start", valign="middle");
//     (7, 0) @PIN(terminal=4, direction="right");
//     @LINE {(7, 0) (6, 0)};
//     (5.65, 0) @TEXT("BP", size=0.55, halign="end", valign="middle");
//     (-2, 5) @PIN(terminal=5, direction="up");
//     @LINE {(-2, 5) (-2, 4)};
//     (2, 5) @PIN(terminal=8, direction="up");
//     @LINE {(2, 5) (2, 4)};
//     (-2, -5) @PIN(terminal=6, direction="down");
//     @LINE {(-2, -5) (-2, -4)};
//     (2, -5) @PIN(terminal=7, direction="down");
//     @LINE {(2, -5) (2, -4)};
//     (0, 0.3) @TEXT("Reference-rail output driver j=6", size=0.7, bold=true, halign="middle", valign="bottom");
//     ? @TEXT("${name}", key="name", size=0.8, valign="bottom") => @PLACE(-6, 4.5);
//     ? @TEXT("${model}", key="model", size=0.5, halign="middle", valign="top") => @PLACE(0, -0.3)
//   };
//   # @SELECT-INSTANCE(model="mq_cdac_drv6") => @SET-SYMBOL $S_mq_cdac_drv6;
//   $S_mq_cdac_bit6 = @DEFINE-SYMBOL(box=[-7, -6, 7, 6]) {
//     @LINE(linewidth=0.24) {(-6, -5) (6, -5) (6, 5) (-6, 5) (-6, -5)};
//     (-7, 3) @PIN(terminal=1, direction="left");
//     @LINE {(-7, 3) (-6, 3)};
//     (-5.65, 3) @TEXT("DH", size=0.55, halign="start", valign="middle");
//     (-7, 1) @PIN(terminal=2, direction="left");
//     @LINE {(-7, 1) (-6, 1)};
//     (-5.65, 1) @TEXT("RL", size=0.55, halign="start", valign="middle");
//     (-7, -1) @PIN(terminal=3, direction="left");
//     @LINE {(-7, -1) (-6, -1)};
//     (-5.65, -1) @TEXT("EN", size=0.55, halign="start", valign="middle");
//     (-7, -3) @PIN(terminal=4, direction="left");
//     @LINE {(-7, -3) (-6, -3)};
//     (-5.65, -3) @TEXT("ENB", size=0.55, halign="start", valign="middle");
//     (7, 0) @PIN(terminal=5, direction="right");
//     @LINE {(7, 0) (6, 0)};
//     (5.65, 0) @TEXT("TOP", size=0.55, halign="end", valign="middle");
//     (-2, 6) @PIN(terminal=6, direction="up");
//     @LINE {(-2, 6) (-2, 5)};
//     (2, 6) @PIN(terminal=9, direction="up");
//     @LINE {(2, 6) (2, 5)};
//     (-2, -6) @PIN(terminal=7, direction="down");
//     @LINE {(-2, -6) (-2, -5)};
//     (2, -6) @PIN(terminal=8, direction="down");
//     @LINE {(2, -6) (2, -5)};
//     (0, 0.3) @TEXT("Matched half-capacitor pair j=6", size=0.7, bold=true, halign="middle", valign="bottom");
//     ? @TEXT("${name}", key="name", size=0.8, valign="bottom") => @PLACE(-6, 5.5);
//     ? @TEXT("${model}", key="model", size=0.5, halign="middle", valign="top") => @PLACE(0, -0.3)
//   };
//   # @SELECT-INSTANCE(model="mq_cdac_bit6") => @SET-SYMBOL $S_mq_cdac_bit6;
//   $S_mq_cdac_drv5 = @DEFINE-SYMBOL(box=[-7, -5, 7, 5]) {
//     @LINE(linewidth=0.24) {(-6, -4) (6, -4) (6, 4) (-6, 4) (-6, -4)};
//     (-7, 2) @PIN(terminal=1, direction="left");
//     @LINE {(-7, 2) (-6, 2)};
//     (-5.65, 2) @TEXT("HIB", size=0.55, halign="start", valign="middle");
//     (-7, 0) @PIN(terminal=2, direction="left");
//     @LINE {(-7, 0) (-6, 0)};
//     (-5.65, 0) @TEXT("EN", size=0.55, halign="start", valign="middle");
//     (-7, -2) @PIN(terminal=3, direction="left");
//     @LINE {(-7, -2) (-6, -2)};
//     (-5.65, -2) @TEXT("ENB", size=0.55, halign="start", valign="middle");
//     (7, 0) @PIN(terminal=4, direction="right");
//     @LINE {(7, 0) (6, 0)};
//     (5.65, 0) @TEXT("BP", size=0.55, halign="end", valign="middle");
//     (-2, 5) @PIN(terminal=5, direction="up");
//     @LINE {(-2, 5) (-2, 4)};
//     (2, 5) @PIN(terminal=8, direction="up");
//     @LINE {(2, 5) (2, 4)};
//     (-2, -5) @PIN(terminal=6, direction="down");
//     @LINE {(-2, -5) (-2, -4)};
//     (2, -5) @PIN(terminal=7, direction="down");
//     @LINE {(2, -5) (2, -4)};
//     (0, 0.3) @TEXT("Reference-rail output driver j=5", size=0.7, bold=true, halign="middle", valign="bottom");
//     ? @TEXT("${name}", key="name", size=0.8, valign="bottom") => @PLACE(-6, 4.5);
//     ? @TEXT("${model}", key="model", size=0.5, halign="middle", valign="top") => @PLACE(0, -0.3)
//   };
//   # @SELECT-INSTANCE(model="mq_cdac_drv5") => @SET-SYMBOL $S_mq_cdac_drv5;
//   $S_mq_cdac_bit5 = @DEFINE-SYMBOL(box=[-7, -10, 7, 10]) {
//     @LINE(linewidth=0.24) {(-6, -9) (6, -9) (6, 9) (-6, 9) (-6, -9)};
//     (-7, 7) @PIN(terminal=1, direction="left");
//     @LINE {(-7, 7) (-6, 7)};
//     (-5.65, 7) @TEXT("VIN", size=0.55, halign="start", valign="middle");
//     (-7, 5) @PIN(terminal=2, direction="left");
//     @LINE {(-7, 5) (-6, 5)};
//     (-5.65, 5) @TEXT("VG", size=0.55, halign="start", valign="middle");
//     (-7, 3) @PIN(terminal=3, direction="left");
//     @LINE {(-7, 3) (-6, 3)};
//     (-5.65, 3) @TEXT("DH", size=0.55, halign="start", valign="middle");
//     (-7, 1) @PIN(terminal=4, direction="left");
//     @LINE {(-7, 1) (-6, 1)};
//     (-5.65, 1) @TEXT("RL", size=0.55, halign="start", valign="middle");
//     (-7, -1) @PIN(terminal=5, direction="left");
//     @LINE {(-7, -1) (-6, -1)};
//     (-5.65, -1) @TEXT("EN", size=0.55, halign="start", valign="middle");
//     (-7, -3) @PIN(terminal=6, direction="left");
//     @LINE {(-7, -3) (-6, -3)};
//     (-5.65, -3) @TEXT("ENB", size=0.55, halign="start", valign="middle");
//     (-7, -5) @PIN(terminal=12, direction="left");
//     @LINE {(-7, -5) (-6, -5)};
//     (-5.65, -5) @TEXT("EQBUS", size=0.55, halign="start", valign="middle");
//     (-7, -7) @PIN(terminal=13, direction="left");
//     @LINE {(-7, -7) (-6, -7)};
//     (-5.65, -7) @TEXT("APGATE", size=0.55, halign="start", valign="middle");
//     (7, 0) @PIN(terminal=7, direction="right");
//     @LINE {(7, 0) (6, 0)};
//     (5.65, 0) @TEXT("TOP", size=0.55, halign="end", valign="middle");
//     (-2, 10) @PIN(terminal=8, direction="up");
//     @LINE {(-2, 10) (-2, 9)};
//     (2, 10) @PIN(terminal=11, direction="up");
//     @LINE {(2, 10) (2, 9)};
//     (-2, -10) @PIN(terminal=9, direction="down");
//     @LINE {(-2, -10) (-2, -9)};
//     (2, -10) @PIN(terminal=10, direction="down");
//     @LINE {(2, -10) (2, -9)};
//     (0, 0.3) @TEXT("Matched half-capacitor pair j=5", size=0.7, bold=true, halign="middle", valign="bottom");
//     ? @TEXT("${name}", key="name", size=0.8, valign="bottom") => @PLACE(-6, 9.5);
//     ? @TEXT("${model}", key="model", size=0.5, halign="middle", valign="top") => @PLACE(0, -0.3)
//   };
//   # @SELECT-INSTANCE(model="mq_cdac_bit5") => @SET-SYMBOL $S_mq_cdac_bit5;
//   $S_mq_cdac_drv4 = @DEFINE-SYMBOL(box=[-7, -5, 7, 5]) {
//     @LINE(linewidth=0.24) {(-6, -4) (6, -4) (6, 4) (-6, 4) (-6, -4)};
//     (-7, 2) @PIN(terminal=1, direction="left");
//     @LINE {(-7, 2) (-6, 2)};
//     (-5.65, 2) @TEXT("HIB", size=0.55, halign="start", valign="middle");
//     (-7, 0) @PIN(terminal=2, direction="left");
//     @LINE {(-7, 0) (-6, 0)};
//     (-5.65, 0) @TEXT("EN", size=0.55, halign="start", valign="middle");
//     (-7, -2) @PIN(terminal=3, direction="left");
//     @LINE {(-7, -2) (-6, -2)};
//     (-5.65, -2) @TEXT("ENB", size=0.55, halign="start", valign="middle");
//     (7, 0) @PIN(terminal=4, direction="right");
//     @LINE {(7, 0) (6, 0)};
//     (5.65, 0) @TEXT("BP", size=0.55, halign="end", valign="middle");
//     (-2, 5) @PIN(terminal=5, direction="up");
//     @LINE {(-2, 5) (-2, 4)};
//     (2, 5) @PIN(terminal=8, direction="up");
//     @LINE {(2, 5) (2, 4)};
//     (-2, -5) @PIN(terminal=6, direction="down");
//     @LINE {(-2, -5) (-2, -4)};
//     (2, -5) @PIN(terminal=7, direction="down");
//     @LINE {(2, -5) (2, -4)};
//     (0, 0.3) @TEXT("Reference-rail output driver j=4", size=0.7, bold=true, halign="middle", valign="bottom");
//     ? @TEXT("${name}", key="name", size=0.8, valign="bottom") => @PLACE(-6, 4.5);
//     ? @TEXT("${model}", key="model", size=0.5, halign="middle", valign="top") => @PLACE(0, -0.3)
//   };
//   # @SELECT-INSTANCE(model="mq_cdac_drv4") => @SET-SYMBOL $S_mq_cdac_drv4;
//   $S_mq_cdac_bit4 = @DEFINE-SYMBOL(box=[-7, -10, 7, 10]) {
//     @LINE(linewidth=0.24) {(-6, -9) (6, -9) (6, 9) (-6, 9) (-6, -9)};
//     (-7, 7) @PIN(terminal=1, direction="left");
//     @LINE {(-7, 7) (-6, 7)};
//     (-5.65, 7) @TEXT("VIN", size=0.55, halign="start", valign="middle");
//     (-7, 5) @PIN(terminal=2, direction="left");
//     @LINE {(-7, 5) (-6, 5)};
//     (-5.65, 5) @TEXT("VG", size=0.55, halign="start", valign="middle");
//     (-7, 3) @PIN(terminal=3, direction="left");
//     @LINE {(-7, 3) (-6, 3)};
//     (-5.65, 3) @TEXT("DH", size=0.55, halign="start", valign="middle");
//     (-7, 1) @PIN(terminal=4, direction="left");
//     @LINE {(-7, 1) (-6, 1)};
//     (-5.65, 1) @TEXT("RL", size=0.55, halign="start", valign="middle");
//     (-7, -1) @PIN(terminal=5, direction="left");
//     @LINE {(-7, -1) (-6, -1)};
//     (-5.65, -1) @TEXT("EN", size=0.55, halign="start", valign="middle");
//     (-7, -3) @PIN(terminal=6, direction="left");
//     @LINE {(-7, -3) (-6, -3)};
//     (-5.65, -3) @TEXT("ENB", size=0.55, halign="start", valign="middle");
//     (-7, -5) @PIN(terminal=12, direction="left");
//     @LINE {(-7, -5) (-6, -5)};
//     (-5.65, -5) @TEXT("EQBUS", size=0.55, halign="start", valign="middle");
//     (-7, -7) @PIN(terminal=13, direction="left");
//     @LINE {(-7, -7) (-6, -7)};
//     (-5.65, -7) @TEXT("APGATE", size=0.55, halign="start", valign="middle");
//     (7, 0) @PIN(terminal=7, direction="right");
//     @LINE {(7, 0) (6, 0)};
//     (5.65, 0) @TEXT("TOP", size=0.55, halign="end", valign="middle");
//     (-2, 10) @PIN(terminal=8, direction="up");
//     @LINE {(-2, 10) (-2, 9)};
//     (2, 10) @PIN(terminal=11, direction="up");
//     @LINE {(2, 10) (2, 9)};
//     (-2, -10) @PIN(terminal=9, direction="down");
//     @LINE {(-2, -10) (-2, -9)};
//     (2, -10) @PIN(terminal=10, direction="down");
//     @LINE {(2, -10) (2, -9)};
//     (0, 0.3) @TEXT("Matched half-capacitor pair j=4", size=0.7, bold=true, halign="middle", valign="bottom");
//     ? @TEXT("${name}", key="name", size=0.8, valign="bottom") => @PLACE(-6, 9.5);
//     ? @TEXT("${model}", key="model", size=0.5, halign="middle", valign="top") => @PLACE(0, -0.3)
//   };
//   # @SELECT-INSTANCE(model="mq_cdac_bit4") => @SET-SYMBOL $S_mq_cdac_bit4;
//   $S_mq_cdac_drv3 = @DEFINE-SYMBOL(box=[-7, -5, 7, 5]) {
//     @LINE(linewidth=0.24) {(-6, -4) (6, -4) (6, 4) (-6, 4) (-6, -4)};
//     (-7, 2) @PIN(terminal=1, direction="left");
//     @LINE {(-7, 2) (-6, 2)};
//     (-5.65, 2) @TEXT("HIB", size=0.55, halign="start", valign="middle");
//     (-7, 0) @PIN(terminal=2, direction="left");
//     @LINE {(-7, 0) (-6, 0)};
//     (-5.65, 0) @TEXT("EN", size=0.55, halign="start", valign="middle");
//     (-7, -2) @PIN(terminal=3, direction="left");
//     @LINE {(-7, -2) (-6, -2)};
//     (-5.65, -2) @TEXT("ENB", size=0.55, halign="start", valign="middle");
//     (7, 0) @PIN(terminal=4, direction="right");
//     @LINE {(7, 0) (6, 0)};
//     (5.65, 0) @TEXT("BP", size=0.55, halign="end", valign="middle");
//     (-2, 5) @PIN(terminal=5, direction="up");
//     @LINE {(-2, 5) (-2, 4)};
//     (2, 5) @PIN(terminal=8, direction="up");
//     @LINE {(2, 5) (2, 4)};
//     (-2, -5) @PIN(terminal=6, direction="down");
//     @LINE {(-2, -5) (-2, -4)};
//     (2, -5) @PIN(terminal=7, direction="down");
//     @LINE {(2, -5) (2, -4)};
//     (0, 0.3) @TEXT("Reference-rail output driver j=3", size=0.7, bold=true, halign="middle", valign="bottom");
//     ? @TEXT("${name}", key="name", size=0.8, valign="bottom") => @PLACE(-6, 4.5);
//     ? @TEXT("${model}", key="model", size=0.5, halign="middle", valign="top") => @PLACE(0, -0.3)
//   };
//   # @SELECT-INSTANCE(model="mq_cdac_drv3") => @SET-SYMBOL $S_mq_cdac_drv3;
//   $S_mq_cdac_bit3 = @DEFINE-SYMBOL(box=[-7, -10, 7, 10]) {
//     @LINE(linewidth=0.24) {(-6, -9) (6, -9) (6, 9) (-6, 9) (-6, -9)};
//     (-7, 7) @PIN(terminal=1, direction="left");
//     @LINE {(-7, 7) (-6, 7)};
//     (-5.65, 7) @TEXT("VIN", size=0.55, halign="start", valign="middle");
//     (-7, 5) @PIN(terminal=2, direction="left");
//     @LINE {(-7, 5) (-6, 5)};
//     (-5.65, 5) @TEXT("VG", size=0.55, halign="start", valign="middle");
//     (-7, 3) @PIN(terminal=3, direction="left");
//     @LINE {(-7, 3) (-6, 3)};
//     (-5.65, 3) @TEXT("DH", size=0.55, halign="start", valign="middle");
//     (-7, 1) @PIN(terminal=4, direction="left");
//     @LINE {(-7, 1) (-6, 1)};
//     (-5.65, 1) @TEXT("RL", size=0.55, halign="start", valign="middle");
//     (-7, -1) @PIN(terminal=5, direction="left");
//     @LINE {(-7, -1) (-6, -1)};
//     (-5.65, -1) @TEXT("EN", size=0.55, halign="start", valign="middle");
//     (-7, -3) @PIN(terminal=6, direction="left");
//     @LINE {(-7, -3) (-6, -3)};
//     (-5.65, -3) @TEXT("ENB", size=0.55, halign="start", valign="middle");
//     (-7, -5) @PIN(terminal=12, direction="left");
//     @LINE {(-7, -5) (-6, -5)};
//     (-5.65, -5) @TEXT("EQBUS", size=0.55, halign="start", valign="middle");
//     (-7, -7) @PIN(terminal=13, direction="left");
//     @LINE {(-7, -7) (-6, -7)};
//     (-5.65, -7) @TEXT("APGATE", size=0.55, halign="start", valign="middle");
//     (7, 0) @PIN(terminal=7, direction="right");
//     @LINE {(7, 0) (6, 0)};
//     (5.65, 0) @TEXT("TOP", size=0.55, halign="end", valign="middle");
//     (-2, 10) @PIN(terminal=8, direction="up");
//     @LINE {(-2, 10) (-2, 9)};
//     (2, 10) @PIN(terminal=11, direction="up");
//     @LINE {(2, 10) (2, 9)};
//     (-2, -10) @PIN(terminal=9, direction="down");
//     @LINE {(-2, -10) (-2, -9)};
//     (2, -10) @PIN(terminal=10, direction="down");
//     @LINE {(2, -10) (2, -9)};
//     (0, 0.3) @TEXT("Matched half-capacitor pair j=3", size=0.7, bold=true, halign="middle", valign="bottom");
//     ? @TEXT("${name}", key="name", size=0.8, valign="bottom") => @PLACE(-6, 9.5);
//     ? @TEXT("${model}", key="model", size=0.5, halign="middle", valign="top") => @PLACE(0, -0.3)
//   };
//   # @SELECT-INSTANCE(model="mq_cdac_bit3") => @SET-SYMBOL $S_mq_cdac_bit3;
//   $S_mq_cdac_drv2 = @DEFINE-SYMBOL(box=[-7, -5, 7, 5]) {
//     @LINE(linewidth=0.24) {(-6, -4) (6, -4) (6, 4) (-6, 4) (-6, -4)};
//     (-7, 2) @PIN(terminal=1, direction="left");
//     @LINE {(-7, 2) (-6, 2)};
//     (-5.65, 2) @TEXT("HIB", size=0.55, halign="start", valign="middle");
//     (-7, 0) @PIN(terminal=2, direction="left");
//     @LINE {(-7, 0) (-6, 0)};
//     (-5.65, 0) @TEXT("EN", size=0.55, halign="start", valign="middle");
//     (-7, -2) @PIN(terminal=3, direction="left");
//     @LINE {(-7, -2) (-6, -2)};
//     (-5.65, -2) @TEXT("ENB", size=0.55, halign="start", valign="middle");
//     (7, 0) @PIN(terminal=4, direction="right");
//     @LINE {(7, 0) (6, 0)};
//     (5.65, 0) @TEXT("BP", size=0.55, halign="end", valign="middle");
//     (-2, 5) @PIN(terminal=5, direction="up");
//     @LINE {(-2, 5) (-2, 4)};
//     (2, 5) @PIN(terminal=8, direction="up");
//     @LINE {(2, 5) (2, 4)};
//     (-2, -5) @PIN(terminal=6, direction="down");
//     @LINE {(-2, -5) (-2, -4)};
//     (2, -5) @PIN(terminal=7, direction="down");
//     @LINE {(2, -5) (2, -4)};
//     (0, 0.3) @TEXT("Reference-rail output driver j=2", size=0.7, bold=true, halign="middle", valign="bottom");
//     ? @TEXT("${name}", key="name", size=0.8, valign="bottom") => @PLACE(-6, 4.5);
//     ? @TEXT("${model}", key="model", size=0.5, halign="middle", valign="top") => @PLACE(0, -0.3)
//   };
//   # @SELECT-INSTANCE(model="mq_cdac_drv2") => @SET-SYMBOL $S_mq_cdac_drv2;
//   $S_mq_cdac_bit2 = @DEFINE-SYMBOL(box=[-7, -12, 7, 12]) {
//     @LINE(linewidth=0.24) {(-6, -11) (6, -11) (6, 11) (-6, 11) (-6, -11)};
//     (-7, 9) @PIN(terminal=1, direction="left");
//     @LINE {(-7, 9) (-6, 9)};
//     (-5.65, 9) @TEXT("VIN", size=0.55, halign="start", valign="middle");
//     (-7, 7) @PIN(terminal=2, direction="left");
//     @LINE {(-7, 7) (-6, 7)};
//     (-5.65, 7) @TEXT("VG", size=0.55, halign="start", valign="middle");
//     (-7, 5) @PIN(terminal=3, direction="left");
//     @LINE {(-7, 5) (-6, 5)};
//     (-5.65, 5) @TEXT("DH", size=0.55, halign="start", valign="middle");
//     (-7, 3) @PIN(terminal=4, direction="left");
//     @LINE {(-7, 3) (-6, 3)};
//     (-5.65, 3) @TEXT("RL", size=0.55, halign="start", valign="middle");
//     (-7, 1) @PIN(terminal=5, direction="left");
//     @LINE {(-7, 1) (-6, 1)};
//     (-5.65, 1) @TEXT("EN", size=0.55, halign="start", valign="middle");
//     (-7, -1) @PIN(terminal=6, direction="left");
//     @LINE {(-7, -1) (-6, -1)};
//     (-5.65, -1) @TEXT("ENB", size=0.55, halign="start", valign="middle");
//     (-7, -3) @PIN(terminal=11, direction="left");
//     @LINE {(-7, -3) (-6, -3)};
//     (-5.65, -3) @TEXT("PHI_S", size=0.55, halign="start", valign="middle");
//     (-7, -5) @PIN(terminal=13, direction="left");
//     @LINE {(-7, -5) (-6, -5)};
//     (-5.65, -5) @TEXT("PHI_SB", size=0.55, halign="start", valign="middle");
//     (-7, -7) @PIN(terminal=14, direction="left");
//     @LINE {(-7, -7) (-6, -7)};
//     (-5.65, -7) @TEXT("EQBUS", size=0.55, halign="start", valign="middle");
//     (-7, -9) @PIN(terminal=15, direction="left");
//     @LINE {(-7, -9) (-6, -9)};
//     (-5.65, -9) @TEXT("APGATE", size=0.55, halign="start", valign="middle");
//     (7, 0) @PIN(terminal=7, direction="right");
//     @LINE {(7, 0) (6, 0)};
//     (5.65, 0) @TEXT("TOP", size=0.55, halign="end", valign="middle");
//     (-2, 12) @PIN(terminal=8, direction="up");
//     @LINE {(-2, 12) (-2, 11)};
//     (2, 12) @PIN(terminal=12, direction="up");
//     @LINE {(2, 12) (2, 11)};
//     (-2, -12) @PIN(terminal=9, direction="down");
//     @LINE {(-2, -12) (-2, -11)};
//     (2, -12) @PIN(terminal=10, direction="down");
//     @LINE {(2, -12) (2, -11)};
//     (0, 0.3) @TEXT("Matched half-capacitor pair j=2", size=0.7, bold=true, halign="middle", valign="bottom");
//     ? @TEXT("${name}", key="name", size=0.8, valign="bottom") => @PLACE(-6, 11.5);
//     ? @TEXT("${model}", key="model", size=0.5, halign="middle", valign="top") => @PLACE(0, -0.3)
//   };
//   # @SELECT-INSTANCE(model="mq_cdac_bit2") => @SET-SYMBOL $S_mq_cdac_bit2;
//   $S_mq_cdac_drv1 = @DEFINE-SYMBOL(box=[-7, -5, 7, 5]) {
//     @LINE(linewidth=0.24) {(-6, -4) (6, -4) (6, 4) (-6, 4) (-6, -4)};
//     (-7, 2) @PIN(terminal=1, direction="left");
//     @LINE {(-7, 2) (-6, 2)};
//     (-5.65, 2) @TEXT("HIB", size=0.55, halign="start", valign="middle");
//     (-7, 0) @PIN(terminal=2, direction="left");
//     @LINE {(-7, 0) (-6, 0)};
//     (-5.65, 0) @TEXT("EN", size=0.55, halign="start", valign="middle");
//     (-7, -2) @PIN(terminal=3, direction="left");
//     @LINE {(-7, -2) (-6, -2)};
//     (-5.65, -2) @TEXT("ENB", size=0.55, halign="start", valign="middle");
//     (7, 0) @PIN(terminal=4, direction="right");
//     @LINE {(7, 0) (6, 0)};
//     (5.65, 0) @TEXT("BP", size=0.55, halign="end", valign="middle");
//     (-2, 5) @PIN(terminal=5, direction="up");
//     @LINE {(-2, 5) (-2, 4)};
//     (2, 5) @PIN(terminal=8, direction="up");
//     @LINE {(2, 5) (2, 4)};
//     (-2, -5) @PIN(terminal=6, direction="down");
//     @LINE {(-2, -5) (-2, -4)};
//     (2, -5) @PIN(terminal=7, direction="down");
//     @LINE {(2, -5) (2, -4)};
//     (0, 0.3) @TEXT("Reference-rail output driver j=1", size=0.7, bold=true, halign="middle", valign="bottom");
//     ? @TEXT("${name}", key="name", size=0.8, valign="bottom") => @PLACE(-6, 4.5);
//     ? @TEXT("${model}", key="model", size=0.5, halign="middle", valign="top") => @PLACE(0, -0.3)
//   };
//   # @SELECT-INSTANCE(model="mq_cdac_drv1") => @SET-SYMBOL $S_mq_cdac_drv1;
//   $S_mq_cdac_bit1 = @DEFINE-SYMBOL(box=[-7, -10, 7, 10]) {
//     @LINE(linewidth=0.24) {(-6, -9) (6, -9) (6, 9) (-6, 9) (-6, -9)};
//     (-7, 7) @PIN(terminal=1, direction="left");
//     @LINE {(-7, 7) (-6, 7)};
//     (-5.65, 7) @TEXT("VIN", size=0.55, halign="start", valign="middle");
//     (-7, 5) @PIN(terminal=2, direction="left");
//     @LINE {(-7, 5) (-6, 5)};
//     (-5.65, 5) @TEXT("VG", size=0.55, halign="start", valign="middle");
//     (-7, 3) @PIN(terminal=3, direction="left");
//     @LINE {(-7, 3) (-6, 3)};
//     (-5.65, 3) @TEXT("DH", size=0.55, halign="start", valign="middle");
//     (-7, 1) @PIN(terminal=4, direction="left");
//     @LINE {(-7, 1) (-6, 1)};
//     (-5.65, 1) @TEXT("RL", size=0.55, halign="start", valign="middle");
//     (-7, -1) @PIN(terminal=5, direction="left");
//     @LINE {(-7, -1) (-6, -1)};
//     (-5.65, -1) @TEXT("EN", size=0.55, halign="start", valign="middle");
//     (-7, -3) @PIN(terminal=6, direction="left");
//     @LINE {(-7, -3) (-6, -3)};
//     (-5.65, -3) @TEXT("ENB", size=0.55, halign="start", valign="middle");
//     (-7, -5) @PIN(terminal=12, direction="left");
//     @LINE {(-7, -5) (-6, -5)};
//     (-5.65, -5) @TEXT("EQBUS", size=0.55, halign="start", valign="middle");
//     (-7, -7) @PIN(terminal=13, direction="left");
//     @LINE {(-7, -7) (-6, -7)};
//     (-5.65, -7) @TEXT("APGATE", size=0.55, halign="start", valign="middle");
//     (7, 0) @PIN(terminal=7, direction="right");
//     @LINE {(7, 0) (6, 0)};
//     (5.65, 0) @TEXT("TOP", size=0.55, halign="end", valign="middle");
//     (-2, 10) @PIN(terminal=8, direction="up");
//     @LINE {(-2, 10) (-2, 9)};
//     (2, 10) @PIN(terminal=11, direction="up");
//     @LINE {(2, 10) (2, 9)};
//     (-2, -10) @PIN(terminal=9, direction="down");
//     @LINE {(-2, -10) (-2, -9)};
//     (2, -10) @PIN(terminal=10, direction="down");
//     @LINE {(2, -10) (2, -9)};
//     (0, 0.3) @TEXT("Matched half-capacitor pair j=1", size=0.7, bold=true, halign="middle", valign="bottom");
//     ? @TEXT("${name}", key="name", size=0.8, valign="bottom") => @PLACE(-6, 9.5);
//     ? @TEXT("${model}", key="model", size=0.5, halign="middle", valign="top") => @PLACE(0, -0.3)
//   };
//   # @SELECT-INSTANCE(model="mq_cdac_bit1") => @SET-SYMBOL $S_mq_cdac_bit1;
//   $S_mq_cdac_drv0 = @DEFINE-SYMBOL(box=[-7, -5, 7, 5]) {
//     @LINE(linewidth=0.24) {(-6, -4) (6, -4) (6, 4) (-6, 4) (-6, -4)};
//     (-7, 2) @PIN(terminal=1, direction="left");
//     @LINE {(-7, 2) (-6, 2)};
//     (-5.65, 2) @TEXT("HIB", size=0.55, halign="start", valign="middle");
//     (-7, 0) @PIN(terminal=2, direction="left");
//     @LINE {(-7, 0) (-6, 0)};
//     (-5.65, 0) @TEXT("EN", size=0.55, halign="start", valign="middle");
//     (-7, -2) @PIN(terminal=3, direction="left");
//     @LINE {(-7, -2) (-6, -2)};
//     (-5.65, -2) @TEXT("ENB", size=0.55, halign="start", valign="middle");
//     (7, 0) @PIN(terminal=4, direction="right");
//     @LINE {(7, 0) (6, 0)};
//     (5.65, 0) @TEXT("BP", size=0.55, halign="end", valign="middle");
//     (-2, 5) @PIN(terminal=5, direction="up");
//     @LINE {(-2, 5) (-2, 4)};
//     (2, 5) @PIN(terminal=8, direction="up");
//     @LINE {(2, 5) (2, 4)};
//     (-2, -5) @PIN(terminal=6, direction="down");
//     @LINE {(-2, -5) (-2, -4)};
//     (2, -5) @PIN(terminal=7, direction="down");
//     @LINE {(2, -5) (2, -4)};
//     (0, 0.3) @TEXT("Reference-rail output driver j=0", size=0.7, bold=true, halign="middle", valign="bottom");
//     ? @TEXT("${name}", key="name", size=0.8, valign="bottom") => @PLACE(-6, 4.5);
//     ? @TEXT("${model}", key="model", size=0.5, halign="middle", valign="top") => @PLACE(0, -0.3)
//   };
//   # @SELECT-INSTANCE(model="mq_cdac_drv0") => @SET-SYMBOL $S_mq_cdac_drv0;
//   $S_mq_cdac_bit0 = @DEFINE-SYMBOL(box=[-7, -12, 7, 12]) {
//     @LINE(linewidth=0.24) {(-6, -11) (6, -11) (6, 11) (-6, 11) (-6, -11)};
//     (-7, 9) @PIN(terminal=1, direction="left");
//     @LINE {(-7, 9) (-6, 9)};
//     (-5.65, 9) @TEXT("VIN", size=0.55, halign="start", valign="middle");
//     (-7, 7) @PIN(terminal=2, direction="left");
//     @LINE {(-7, 7) (-6, 7)};
//     (-5.65, 7) @TEXT("VG", size=0.55, halign="start", valign="middle");
//     (-7, 5) @PIN(terminal=3, direction="left");
//     @LINE {(-7, 5) (-6, 5)};
//     (-5.65, 5) @TEXT("DH", size=0.55, halign="start", valign="middle");
//     (-7, 3) @PIN(terminal=4, direction="left");
//     @LINE {(-7, 3) (-6, 3)};
//     (-5.65, 3) @TEXT("RL", size=0.55, halign="start", valign="middle");
//     (-7, 1) @PIN(terminal=5, direction="left");
//     @LINE {(-7, 1) (-6, 1)};
//     (-5.65, 1) @TEXT("EN", size=0.55, halign="start", valign="middle");
//     (-7, -1) @PIN(terminal=6, direction="left");
//     @LINE {(-7, -1) (-6, -1)};
//     (-5.65, -1) @TEXT("ENB", size=0.55, halign="start", valign="middle");
//     (-7, -3) @PIN(terminal=11, direction="left");
//     @LINE {(-7, -3) (-6, -3)};
//     (-5.65, -3) @TEXT("PHI_S", size=0.55, halign="start", valign="middle");
//     (-7, -5) @PIN(terminal=13, direction="left");
//     @LINE {(-7, -5) (-6, -5)};
//     (-5.65, -5) @TEXT("PHI_SB", size=0.55, halign="start", valign="middle");
//     (-7, -7) @PIN(terminal=14, direction="left");
//     @LINE {(-7, -7) (-6, -7)};
//     (-5.65, -7) @TEXT("EQBUS", size=0.55, halign="start", valign="middle");
//     (-7, -9) @PIN(terminal=15, direction="left");
//     @LINE {(-7, -9) (-6, -9)};
//     (-5.65, -9) @TEXT("APGATE", size=0.55, halign="start", valign="middle");
//     (7, 0) @PIN(terminal=7, direction="right");
//     @LINE {(7, 0) (6, 0)};
//     (5.65, 0) @TEXT("TOP", size=0.55, halign="end", valign="middle");
//     (-2, 12) @PIN(terminal=8, direction="up");
//     @LINE {(-2, 12) (-2, 11)};
//     (2, 12) @PIN(terminal=12, direction="up");
//     @LINE {(2, 12) (2, 11)};
//     (-2, -12) @PIN(terminal=9, direction="down");
//     @LINE {(-2, -12) (-2, -11)};
//     (2, -12) @PIN(terminal=10, direction="down");
//     @LINE {(2, -12) (2, -11)};
//     (0, 0.3) @TEXT("Matched half-capacitor pair j=0", size=0.7, bold=true, halign="middle", valign="bottom");
//     ? @TEXT("${name}", key="name", size=0.8, valign="bottom") => @PLACE(-6, 11.5);
//     ? @TEXT("${model}", key="model", size=0.5, halign="middle", valign="top") => @PLACE(0, -0.3)
//   };
//   # @SELECT-INSTANCE(model="mq_cdac_bit0") => @SET-SYMBOL $S_mq_cdac_bit0;
//   $S_mq_cdac_assist_pulse = @DEFINE-SYMBOL(box=[-7, -5, 6, 5]) {
//     @LINE(linewidth=0.24) {(-6, -4) (6, -4) (6, 4) (-6, 4) (-6, -4)};
//     (-7, 2) @PIN(terminal=1, direction="left");
//     @LINE {(-7, 2) (-6, 2)};
//     (-5.65, 2) @TEXT("PHI_S", size=0.55, halign="start", valign="middle");
//     (-7, 0) @PIN(terminal=2, direction="left");
//     @LINE {(-7, 0) (-6, 0)};
//     (-5.65, 0) @TEXT("PHI_SB", size=0.55, halign="start", valign="middle");
//     (-7, -2) @PIN(terminal=3, direction="left");
//     @LINE {(-7, -2) (-6, -2)};
//     (-5.65, -2) @TEXT("AGATE", size=0.55, halign="start", valign="middle");
//     (0, 5) @PIN(terminal=4, direction="up");
//     @LINE {(0, 5) (0, 4)};
//     (-2, -5) @PIN(terminal=5, direction="down");
//     @LINE {(-2, -5) (-2, -4)};
//     (2, -5) @PIN(terminal=6, direction="down");
//     @LINE {(2, -5) (2, -4)};
//     (0, 0.3) @TEXT("Physical sampling-entry assistance pulse", size=0.7, bold=true, halign="middle", valign="bottom");
//     ? @TEXT("${name}", key="name", size=0.8, valign="bottom") => @PLACE(-6, 4.5);
//     ? @TEXT("${model}", key="model", size=0.5, halign="middle", valign="top") => @PLACE(0, -0.3)
//   };
//   # @SELECT-INSTANCE(model="mq_cdac_assist_pulse") => @SET-SYMBOL $S_mq_cdac_assist_pulse
// }

// DVDD command buffer L
subckt mq_cdac_ctl_l (IN HIB DVDD VREFN VSS)
M0N (HIB IN VREFN VSS) nch_ulvt_mac w=2e-06 l=3e-08 nf=1
M0P (HIB IN DVDD DVDD) pch_ulvt_mac w=4e-06 l=3e-08 nf=2
// @RNL {
//   /* pins connected by net name: the net-name label of rnl-std-fill on every unwired pin, placed below by its key netname */
//   $LABEL_TERMINAL_SET @TEXT("${net}", key="netname", size=0.6);
//   &VSS @ADD-TO $GROUND_NET_SET; &VREFN @ADD-TO $GROUND_NET_SET;
//   &DVDD @ADD-TO $SUPPLY_NET_SET;
//   #M0N @PLACE(0, 0);
//   #M0N @ORIENT("R0");
//   #M0N:1 @TEXT("${net}", key="netname", size=0.6, halign="start", valign="middle", rotate=90, dx=0, dy=0.4);
//   #M0N:2 @TEXT("${net}", key="netname", size=0.6, halign="end", valign="middle", dx=-0.4, dy=0);
//   %g1 = $GROUND @ATTACH &VREFN => @PLACE(0, -5.2);
//   &VREFN @WIRE {#M0N:3 (0, -2) %g1:p};
//   %g2 = $GROUND @ATTACH &VSS => @PLACE(3, -3.2);
//   &VSS @WIRE {#M0N:4 (3, 0) %g2:p};
//   #M0P @PLACE(0, 10);
//   #M0P @ORIENT("R0");
//   #M0P:1 @TEXT("${net}", key="netname", size=0.6, halign="end", valign="middle", rotate=90, dx=0, dy=-0.4);
//   #M0P:2 @TEXT("${net}", key="netname", size=0.6, halign="end", valign="middle", dx=-0.4, dy=0);
//   %v3 = $SUPPLY @ATTACH &DVDD => @PLACE(0, 15.2);
//   &DVDD @WIRE {#M0P:3 (0, 12) %v3:p};
//   %v4 = $SUPPLY @ATTACH &DVDD => @PLACE(3, 13.2);
//   &DVDD @WIRE {#M0P:4 (3, 10) %v4:p};
//   &HIB @WIRE {#M0N:1 #M0P:1};
//   &IN @WIRE {#M0N:2 (-5, 0) (-5, 10) #M0P:2};
//   %p_in = $IO_PORT @ATTACH &IN => @PLACE(-7, 0) => @ORIENT("R0");
//   &IN @WIRE {%p_in:p #M0N:2};
//   %p_hib = $IO_PORT @ATTACH &HIB => @PLACE(0, 6) => @ORIENT("R270");
//   &HIB @WIRE {%p_hib:p #M0N:1};
//   (-10, 32) @TEXT("DVDD command buffer L") => @SET-STYLE $title_style
// }
ends mq_cdac_ctl_l

// DVDD command buffer H
subckt mq_cdac_ctl_h (IN HIB DVDD VREFN VSS)
M0N (I0 IN VREFN VSS) nch_ulvt_mac w=4e-07 l=3e-08 nf=1
M0P (I0 IN DVDD DVDD) pch_mac w=8e-07 l=3e-08 nf=1
M1N (HIB I0 VREFN VSS) nch_ulvt_mac w=2e-06 l=3e-08 nf=1
M1P (HIB I0 DVDD DVDD) pch_ulvt_mac w=4e-06 l=3e-08 nf=2
// @RNL {
//   /* pins connected by net name: the net-name label of rnl-std-fill on every unwired pin, placed below by its key netname */
//   $LABEL_TERMINAL_SET @TEXT("${net}", key="netname", size=0.6);
//   &VSS @ADD-TO $GROUND_NET_SET; &VREFN @ADD-TO $GROUND_NET_SET;
//   &DVDD @ADD-TO $SUPPLY_NET_SET;
//   #M0N @PLACE(0, 0);
//   #M0N @ORIENT("R0");
//   #M0N:1 @TEXT("${net}", key="netname", size=0.6, halign="start", valign="middle", rotate=90, dx=0, dy=0.4);
//   #M0N:2 @TEXT("${net}", key="netname", size=0.6, halign="end", valign="middle", dx=-0.4, dy=0);
//   %g1 = $GROUND @ATTACH &VREFN => @PLACE(0, -5.2);
//   &VREFN @WIRE {#M0N:3 (0, -2) %g1:p};
//   %g2 = $GROUND @ATTACH &VSS => @PLACE(3, -3.2);
//   &VSS @WIRE {#M0N:4 (3, 0) %g2:p};
//   #M0P @PLACE(0, 10);
//   #M0P @ORIENT("R0");
//   #M0P:1 @TEXT("${net}", key="netname", size=0.6, halign="end", valign="middle", rotate=90, dx=0, dy=-0.4);
//   #M0P:2 @TEXT("${net}", key="netname", size=0.6, halign="end", valign="middle", dx=-0.4, dy=0);
//   %v3 = $SUPPLY @ATTACH &DVDD => @PLACE(0, 15.2);
//   &DVDD @WIRE {#M0P:3 (0, 12) %v3:p};
//   %v4 = $SUPPLY @ATTACH &DVDD => @PLACE(3, 13.2);
//   &DVDD @WIRE {#M0P:4 (3, 10) %v4:p};
//   #M1N @PLACE(26, 0);
//   #M1N @ORIENT("R0");
//   #M1N:1 @TEXT("${net}", key="netname", size=0.6, halign="start", valign="middle", rotate=90, dx=0, dy=0.4);
//   #M1N:2 @TEXT("${net}", key="netname", size=0.6, halign="end", valign="middle", dx=-0.4, dy=0);
//   %g5 = $GROUND @ATTACH &VREFN => @PLACE(26, -5.2);
//   &VREFN @WIRE {#M1N:3 (26, -2) %g5:p};
//   %g6 = $GROUND @ATTACH &VSS => @PLACE(29, -3.2);
//   &VSS @WIRE {#M1N:4 (29, 0) %g6:p};
//   #M1P @PLACE(26, 10);
//   #M1P @ORIENT("R0");
//   #M1P:1 @TEXT("${net}", key="netname", size=0.6, halign="end", valign="middle", rotate=90, dx=0, dy=-0.4);
//   #M1P:2 @TEXT("${net}", key="netname", size=0.6, halign="end", valign="middle", dx=-0.4, dy=0);
//   %v7 = $SUPPLY @ATTACH &DVDD => @PLACE(26, 15.2);
//   &DVDD @WIRE {#M1P:3 (26, 12) %v7:p};
//   %v8 = $SUPPLY @ATTACH &DVDD => @PLACE(29, 13.2);
//   &DVDD @WIRE {#M1P:4 (29, 10) %v8:p};
//   &I0 @WIRE {#M0N:1 #M0P:1};
//   &IN @WIRE {#M0N:2 (-5, 0) (-5, 10) #M0P:2};
//   &HIB @WIRE {#M1N:1 #M1P:1};
//   &I0 @WIRE {#M1N:2 (21, 0) (21, 10) #M1P:2};
//   %p_in = $IO_PORT @ATTACH &IN => @PLACE(-7, 0) => @ORIENT("R0");
//   &IN @WIRE {%p_in:p #M0N:2};
//   %p_hib = $IO_PORT @ATTACH &HIB => @PLACE(26, 6) => @ORIENT("R270");
//   &HIB @WIRE {%p_hib:p #M1N:1};
//   (-10, 32) @TEXT("DVDD command buffer H") => @SET-STYLE $title_style
// }
ends mq_cdac_ctl_h

// DVDD conversion-enable buffer
subckt mq_cdac_enable (IN EN ENB DVDD VREFN VSS)
M0N (ENB IN VREFN VSS) nch_ulvt_mac w=4e-06 l=3e-08 nf=2
M0P (ENB IN DVDD DVDD) pch_mac w=8e-06 l=3e-08 nf=4
M1N (EN ENB VREFN VSS) nch_ulvt_mac w=2.4e-05 l=3e-08 nf=12
M1P (EN ENB DVDD DVDD) pch_ulvt_mac w=4.8e-05 l=3e-08 nf=24
// @RNL {
//   /* pins connected by net name: the net-name label of rnl-std-fill on every unwired pin, placed below by its key netname */
//   $LABEL_TERMINAL_SET @TEXT("${net}", key="netname", size=0.6);
//   &VSS @ADD-TO $GROUND_NET_SET; &VREFN @ADD-TO $GROUND_NET_SET;
//   &DVDD @ADD-TO $SUPPLY_NET_SET;
//   #M0N @PLACE(0, 0);
//   #M0N @ORIENT("R0");
//   #M0N:1 @TEXT("${net}", key="netname", size=0.6, halign="start", valign="middle", rotate=90, dx=0, dy=0.4);
//   #M0N:2 @TEXT("${net}", key="netname", size=0.6, halign="end", valign="middle", dx=-0.4, dy=0);
//   %g1 = $GROUND @ATTACH &VREFN => @PLACE(0, -5.2);
//   &VREFN @WIRE {#M0N:3 (0, -2) %g1:p};
//   %g2 = $GROUND @ATTACH &VSS => @PLACE(3, -3.2);
//   &VSS @WIRE {#M0N:4 (3, 0) %g2:p};
//   #M0P @PLACE(0, 10);
//   #M0P @ORIENT("R0");
//   #M0P:1 @TEXT("${net}", key="netname", size=0.6, halign="end", valign="middle", rotate=90, dx=0, dy=-0.4);
//   #M0P:2 @TEXT("${net}", key="netname", size=0.6, halign="end", valign="middle", dx=-0.4, dy=0);
//   %v3 = $SUPPLY @ATTACH &DVDD => @PLACE(0, 15.2);
//   &DVDD @WIRE {#M0P:3 (0, 12) %v3:p};
//   %v4 = $SUPPLY @ATTACH &DVDD => @PLACE(3, 13.2);
//   &DVDD @WIRE {#M0P:4 (3, 10) %v4:p};
//   #M1N @PLACE(26, 0);
//   #M1N @ORIENT("R0");
//   #M1N:1 @TEXT("${net}", key="netname", size=0.6, halign="start", valign="middle", rotate=90, dx=0, dy=0.4);
//   #M1N:2 @TEXT("${net}", key="netname", size=0.6, halign="end", valign="middle", dx=-0.4, dy=0);
//   %g5 = $GROUND @ATTACH &VREFN => @PLACE(26, -5.2);
//   &VREFN @WIRE {#M1N:3 (26, -2) %g5:p};
//   %g6 = $GROUND @ATTACH &VSS => @PLACE(29, -3.2);
//   &VSS @WIRE {#M1N:4 (29, 0) %g6:p};
//   #M1P @PLACE(26, 10);
//   #M1P @ORIENT("R0");
//   #M1P:1 @TEXT("${net}", key="netname", size=0.6, halign="end", valign="middle", rotate=90, dx=0, dy=-0.4);
//   #M1P:2 @TEXT("${net}", key="netname", size=0.6, halign="end", valign="middle", dx=-0.4, dy=0);
//   %v7 = $SUPPLY @ATTACH &DVDD => @PLACE(26, 15.2);
//   &DVDD @WIRE {#M1P:3 (26, 12) %v7:p};
//   %v8 = $SUPPLY @ATTACH &DVDD => @PLACE(29, 13.2);
//   &DVDD @WIRE {#M1P:4 (29, 10) %v8:p};
//   &ENB @WIRE {#M0N:1 #M0P:1};
//   &IN @WIRE {#M0N:2 (-5, 0) (-5, 10) #M0P:2};
//   &EN @WIRE {#M1N:1 #M1P:1};
//   &ENB @WIRE {#M1N:2 (21, 0) (21, 10) #M1P:2};
//   %p_in = $IO_PORT @ATTACH &IN => @PLACE(-7, 0) => @ORIENT("R0");
//   &IN @WIRE {%p_in:p #M0N:2};
//   %p_en = $IO_PORT @ATTACH &EN => @PLACE(26, 6) => @ORIENT("R270");
//   &EN @WIRE {%p_en:p #M1N:1};
//   %p_enb = $IO_PORT @ATTACH &ENB => @PLACE(0, 6) => @ORIENT("R270");
//   &ENB @WIRE {%p_enb:p #M0N:1};
//   (-10, 32) @TEXT("DVDD conversion-enable buffer") => @SET-STYLE $title_style
// }
ends mq_cdac_enable

// Reference-rail output driver j=12
subckt mq_cdac_drv12 (HIB EN ENB BP VREFP VREFN VSS DVDD)
// DVDD prelogic: PCOND = NOR(ENB,HIB); NOFF = NAND(EN,HIB).
// Reference-powered final inverters restore GP and GN to VREFP/VREFN.
// Actual current overlap, settling and device stress require measurement.
MPA0 (AP ENB DVDD DVDD) pch_ulvt_mac w=8e-06 l=3e-08 nf=4
MPA1 (PCOND HIB AP DVDD) pch_ulvt_mac w=8e-06 l=3e-08 nf=4
MNA0 (PCOND ENB VREFN VSS) nch_ulvt_mac w=4e-06 l=3e-08 nf=2
MNA1 (PCOND HIB VREFN VSS) nch_ulvt_mac w=4e-06 l=3e-08 nf=2
MPB0 (NOFF EN DVDD DVDD) pch_ulvt_mac w=4e-06 l=3e-08 nf=2
MPB1 (NOFF HIB DVDD DVDD) pch_ulvt_mac w=4e-06 l=3e-08 nf=2
MNB0 (NOFF EN BN VSS) nch_ulvt_mac w=4e-06 l=3e-08 nf=2
MNB1 (BN HIB VREFN VSS) nch_ulvt_mac w=4e-06 l=3e-08 nf=2
MGPN (GP PCOND VREFN VSS) nch_mac w=8e-06 l=3e-08 nf=4
MGPP (GP PCOND VREFP VREFP) pch_mac w=1.2e-05 l=3e-08 nf=6
MGNN (GN NOFF VREFN VSS) nch_mac w=8e-06 l=3e-08 nf=4
MGNP (GN NOFF VREFP VREFP) pch_mac w=4e-06 l=3e-08 nf=2
MNOUT (BP GN VREFN VSS) nch_mac w=1.5e-05 l=3e-08 nf=10
MPOUT (BP GP VREFP VREFP) pch_mac w=3e-05 l=3e-08 nf=20
// @RNL {
//   /* pins connected by net name: the net-name label of rnl-std-fill on every unwired pin, placed below by its key netname */
//   $LABEL_TERMINAL_SET @TEXT("${net}", key="netname", size=0.6);
//   &VSS @ADD-TO $GROUND_NET_SET; &VREFN @ADD-TO $GROUND_NET_SET;
//   &VREFP @ADD-TO $SUPPLY_NET_SET;
//   &DVDD @ADD-TO $SUPPLY_NET_SET;
//   {#MPA0 #MPA1 #MNA0 #MNA1} @GROUP;
//   {#MPB0 #MPB1 #MNB0 #MNB1} @GROUP;
//   {#MGPN #MGPP} @GROUP;
//   {#MGNN #MGNP} @GROUP;
//   {#MNOUT #MPOUT} @GROUP;
//   #MPA0 @PLACE(12, 40);
//   #MPA0 @ORIENT("R0");
//   #MPA0:1 @TEXT("${net}", key="netname", size=0.6, halign="end", valign="middle", rotate=90, dx=0, dy=-0.4);
//   #MPA0:2 @TEXT("${net}", key="netname", size=0.6, halign="end", valign="middle", dx=-0.4, dy=0);
//   %v1 = $SUPPLY @ATTACH &DVDD => @PLACE(12, 45.2);
//   &DVDD @WIRE {#MPA0:3 (12, 42) %v1:p};
//   %v2 = $SUPPLY @ATTACH &DVDD => @PLACE(15, 43.2);
//   &DVDD @WIRE {#MPA0:4 (15, 40) %v2:p};
//   #MPA1 @PLACE(12, 26);
//   #MPA1 @ORIENT("R0");
//   #MPA1:1 @TEXT("${net}", key="netname", size=0.6, halign="end", valign="middle", rotate=90, dx=0, dy=-0.4);
//   #MPA1:2 @TEXT("${net}", key="netname", size=0.6, halign="end", valign="middle", dx=-0.4, dy=0);
//   #MPA1:3 @TEXT("${net}", key="netname", size=0.6, halign="start", valign="middle", rotate=90, dx=0, dy=0.4);
//   %v3 = $SUPPLY @ATTACH &DVDD => @PLACE(15, 29.2);
//   &DVDD @WIRE {#MPA1:4 (15, 26) %v3:p};
//   #MNA0 @PLACE(0, 2);
//   #MNA0 @ORIENT("R0");
//   #MNA0:1 @TEXT("${net}", key="netname", size=0.6, halign="start", valign="middle", rotate=90, dx=0, dy=0.4);
//   #MNA0:2 @TEXT("${net}", key="netname", size=0.6, halign="end", valign="middle", dx=-0.4, dy=0);
//   %g4 = $GROUND @ATTACH &VREFN => @PLACE(0, -3.2);
//   &VREFN @WIRE {#MNA0:3 (0, 0) %g4:p};
//   %g5 = $GROUND @ATTACH &VSS => @PLACE(3, -1.2);
//   &VSS @WIRE {#MNA0:4 (3, 2) %g5:p};
//   #MNA1 @PLACE(24, 2);
//   #MNA1 @ORIENT("R0");
//   #MNA1:1 @TEXT("${net}", key="netname", size=0.6, halign="start", valign="middle", rotate=90, dx=0, dy=0.4);
//   #MNA1:2 @TEXT("${net}", key="netname", size=0.6, halign="end", valign="middle", dx=-0.4, dy=0);
//   %g6 = $GROUND @ATTACH &VREFN => @PLACE(24, -3.2);
//   &VREFN @WIRE {#MNA1:3 (24, 0) %g6:p};
//   %g7 = $GROUND @ATTACH &VSS => @PLACE(27, -1.2);
//   &VSS @WIRE {#MNA1:4 (27, 2) %g7:p};
//   #MPB0 @PLACE(96, 30);
//   #MPB0 @ORIENT("R0");
//   #MPB0:1 @TEXT("${net}", key="netname", size=0.6, halign="end", valign="middle", rotate=90, dx=0, dy=-0.4);
//   #MPB0:2 @TEXT("${net}", key="netname", size=0.6, halign="end", valign="middle", dx=-0.4, dy=0);
//   %v8 = $SUPPLY @ATTACH &DVDD => @PLACE(96, 35.2);
//   &DVDD @WIRE {#MPB0:3 (96, 32) %v8:p};
//   %v9 = $SUPPLY @ATTACH &DVDD => @PLACE(99, 33.2);
//   &DVDD @WIRE {#MPB0:4 (99, 30) %v9:p};
//   #MPB1 @PLACE(120, 30);
//   #MPB1 @ORIENT("R0");
//   #MPB1:1 @TEXT("${net}", key="netname", size=0.6, halign="end", valign="middle", rotate=90, dx=0, dy=-0.4);
//   #MPB1:2 @TEXT("${net}", key="netname", size=0.6, halign="end", valign="middle", dx=-0.4, dy=0);
//   %v10 = $SUPPLY @ATTACH &DVDD => @PLACE(120, 35.2);
//   &DVDD @WIRE {#MPB1:3 (120, 32) %v10:p};
//   %v11 = $SUPPLY @ATTACH &DVDD => @PLACE(123, 33.2);
//   &DVDD @WIRE {#MPB1:4 (123, 30) %v11:p};
//   #MNB0 @PLACE(108, 12);
//   #MNB0 @ORIENT("R0");
//   #MNB0:1 @TEXT("${net}", key="netname", size=0.6, halign="start", valign="middle", rotate=90, dx=0, dy=0.4);
//   #MNB0:2 @TEXT("${net}", key="netname", size=0.6, halign="end", valign="middle", dx=-0.4, dy=0);
//   #MNB0:3 @TEXT("${net}", key="netname", size=0.6, halign="end", valign="middle", rotate=90, dx=0, dy=-0.4);
//   %g12 = $GROUND @ATTACH &VSS => @PLACE(111, 8.8);
//   &VSS @WIRE {#MNB0:4 (111, 12) %g12:p};
//   #MNB1 @PLACE(108, -2);
//   #MNB1 @ORIENT("R0");
//   #MNB1:1 @TEXT("${net}", key="netname", size=0.6, halign="start", valign="middle", rotate=90, dx=0, dy=0.4);
//   #MNB1:2 @TEXT("${net}", key="netname", size=0.6, halign="end", valign="middle", dx=-0.4, dy=0);
//   %g13 = $GROUND @ATTACH &VREFN => @PLACE(108, -7.2);
//   &VREFN @WIRE {#MNB1:3 (108, -4) %g13:p};
//   %g14 = $GROUND @ATTACH &VSS => @PLACE(111, -5.2);
//   &VSS @WIRE {#MNB1:4 (111, -2) %g14:p};
//   #MGPN @PLACE(64, 2);
//   #MGPN @ORIENT("R0");
//   #MGPN:1 @TEXT("${net}", key="netname", size=0.6, halign="start", valign="middle", rotate=90, dx=0, dy=0.4);
//   #MGPN:2 @TEXT("${net}", key="netname", size=0.6, halign="end", valign="middle", dx=-0.4, dy=0);
//   %g15 = $GROUND @ATTACH &VREFN => @PLACE(64, -3.2);
//   &VREFN @WIRE {#MGPN:3 (64, 0) %g15:p};
//   %g16 = $GROUND @ATTACH &VSS => @PLACE(67, -1.2);
//   &VSS @WIRE {#MGPN:4 (67, 2) %g16:p};
//   #MGPP @PLACE(64, 12);
//   #MGPP @ORIENT("R0");
//   #MGPP:1 @TEXT("${net}", key="netname", size=0.6, halign="end", valign="middle", rotate=90, dx=0, dy=-0.4);
//   #MGPP:2 @TEXT("${net}", key="netname", size=0.6, halign="end", valign="middle", dx=-0.4, dy=0);
//   %v17 = $SUPPLY @ATTACH &VREFP => @PLACE(64, 17.2);
//   &VREFP @WIRE {#MGPP:3 (64, 14) %v17:p};
//   %v18 = $SUPPLY @ATTACH &VREFP => @PLACE(67, 15.2);
//   &VREFP @WIRE {#MGPP:4 (67, 12) %v18:p};
//   #MGNN @PLACE(160, 2);
//   #MGNN @ORIENT("R0");
//   #MGNN:1 @TEXT("${net}", key="netname", size=0.6, halign="start", valign="middle", rotate=90, dx=0, dy=0.4);
//   #MGNN:2 @TEXT("${net}", key="netname", size=0.6, halign="end", valign="middle", dx=-0.4, dy=0);
//   %g19 = $GROUND @ATTACH &VREFN => @PLACE(160, -3.2);
//   &VREFN @WIRE {#MGNN:3 (160, 0) %g19:p};
//   %g20 = $GROUND @ATTACH &VSS => @PLACE(163, -1.2);
//   &VSS @WIRE {#MGNN:4 (163, 2) %g20:p};
//   #MGNP @PLACE(160, 12);
//   #MGNP @ORIENT("R0");
//   #MGNP:1 @TEXT("${net}", key="netname", size=0.6, halign="end", valign="middle", rotate=90, dx=0, dy=-0.4);
//   #MGNP:2 @TEXT("${net}", key="netname", size=0.6, halign="end", valign="middle", dx=-0.4, dy=0);
//   %v21 = $SUPPLY @ATTACH &VREFP => @PLACE(160, 17.2);
//   &VREFP @WIRE {#MGNP:3 (160, 14) %v21:p};
//   %v22 = $SUPPLY @ATTACH &VREFP => @PLACE(163, 15.2);
//   &VREFP @WIRE {#MGNP:4 (163, 12) %v22:p};
//   #MNOUT @PLACE(200, 0);
//   #MNOUT @ORIENT("R0");
//   #MNOUT:1 @TEXT("${net}", key="netname", size=0.6, halign="start", valign="middle", rotate=90, dx=0, dy=0.4);
//   #MNOUT:2 @TEXT("${net}", key="netname", size=0.6, halign="end", valign="middle", dx=-0.4, dy=0);
//   %g23 = $GROUND @ATTACH &VREFN => @PLACE(200, -5.2);
//   &VREFN @WIRE {#MNOUT:3 (200, -2) %g23:p};
//   %g24 = $GROUND @ATTACH &VSS => @PLACE(203, -3.2);
//   &VSS @WIRE {#MNOUT:4 (203, 0) %g24:p};
//   #MPOUT @PLACE(200, 22);
//   #MPOUT @ORIENT("R0");
//   #MPOUT:1 @TEXT("${net}", key="netname", size=0.6, halign="end", valign="middle", rotate=90, dx=0, dy=-0.4);
//   #MPOUT:2 @TEXT("${net}", key="netname", size=0.6, halign="end", valign="middle", dx=-0.4, dy=0);
//   %v25 = $SUPPLY @ATTACH &VREFP => @PLACE(200, 27.2);
//   &VREFP @WIRE {#MPOUT:3 (200, 24) %v25:p};
//   %v26 = $SUPPLY @ATTACH &VREFP => @PLACE(203, 25.2);
//   &VREFP @WIRE {#MPOUT:4 (203, 22) %v26:p};
//   &GP @WIRE {#MGPN:1 #MGPP:1};
//   &PCOND @WIRE {#MGPN:2 (59, 2) (59, 12) #MGPP:2};
//   &GN @WIRE {#MGNN:1 #MGNP:1};
//   &NOFF @WIRE {#MGNN:2 (155, 2) (155, 12) #MGNP:2};
//   &AP @WIRE {#MPA0:1 #MPA1:3};
//   %pc_bus = (12, 16);
//   $JUNCTION @ATTACH %pc_bus;
//   &PCOND @WIRE {#MNA0:1 (0, 16) %pc_bus (24, 16) #MNA1:1};
//   &PCOND @WIRE {#MPA1:1 %pc_bus};
//   %pc_gate = (59, 7);
//   $JUNCTION @ATTACH %pc_gate;
//   &PCOND @WIRE {%pc_bus (50, 16) (50, 7) %pc_gate};
//   &BN @WIRE {#MNB0:3 #MNB1:1};
//   %no_bus = (108, 22);
//   $JUNCTION @ATTACH %no_bus;
//   &NOFF @WIRE {#MPB0:1 (96, 22) %no_bus (120, 22) #MPB1:1};
//   &NOFF @WIRE {#MNB0:1 %no_bus};
//   %no_gate = (155, 7);
//   $JUNCTION @ATTACH %no_gate;
//   &NOFF @WIRE {%no_bus (146, 22) (146, 7) %no_gate};
//   &BP @WIRE {#MNOUT:1 #MPOUT:1};
//   &GP @WIRE {#MGPN:1 (74, 4) (74, 52) (190, 52) (190, 22) #MPOUT:2};
//   &GN @WIRE {#MGNN:1 (180, 4) (180, 0) #MNOUT:2};
//   %p_hib = $IO_PORT @ATTACH &HIB => @PLACE(5, 26) => @ORIENT("R0");
//   &HIB @WIRE {%p_hib:p #MPA1:2};
//   %p_en = $IO_PORT @ATTACH &EN => @PLACE(89, 30) => @ORIENT("R0");
//   &EN @WIRE {%p_en:p #MPB0:2};
//   %p_enb = $IO_PORT @ATTACH &ENB => @PLACE(5, 40) => @ORIENT("R0");
//   &ENB @WIRE {%p_enb:p #MPA0:2};
//   %p_bp = $IO_PORT @ATTACH &BP => @PLACE(200, 6) => @ORIENT("R270");
//   &BP @WIRE {%p_bp:p #MNOUT:1};
//   (-10, 62) @TEXT("Reference-rail output driver j=12") => @SET-STYLE $title_style
// }
ends mq_cdac_drv12

// Matched half-capacitor pair j=12
subckt mq_cdac_bit12 (VIN VG DH RL EN ENB TOP VREFP VREFN VSS DVDD EQBUS APGATE)
// CP*: user-specified 5% bottom-plate estimate for every physical MOM unit, not extraction.
// Series tails retain one unit parasitic at MID and one at B.
// APGATE PMOS assist connects each bottom plate to VIN.
// Additional ENB NMOS sharing retains a common EQBUS.
XHCTL (DH HHIB DVDD VREFN VSS) mq_cdac_ctl_h
XLCTL (RL LHIB DVDD VREFN VSS) mq_cdac_ctl_l
XDH (HHIB EN ENB BH VREFP VREFN VSS DVDD) mq_cdac_drv12
CH (TOP BH) cfmom_2t w=5e-08 s=2.4e-07 nr=6 lr=1.69e-06 stm=2 spm=4 multi=490
CPH (BH VSS) capacitor c=2.45561050e-14
MSH (BH VG VIN VSS) nch_ulvt_mac w=1.143e-05 l=3e-08 nf=6
XDL (LHIB EN ENB BL VREFP VREFN VSS DVDD) mq_cdac_drv12
CL (TOP BL) cfmom_2t w=5e-08 s=2.4e-07 nr=6 lr=1.69e-06 stm=2 spm=4 multi=490
CPL (BL VSS) capacitor c=2.45561050e-14
MSL (BL VG VIN VSS) nch_ulvt_mac w=1.143e-05 l=3e-08 nf=6
MEQ1 (BH APGATE VIN VREFP) pch_ulvt_mac w=1.143e-05 l=3e-08 nf=6
MEQ2 (BL APGATE VIN VREFP) pch_ulvt_mac w=1.143e-05 l=3e-08 nf=6
MSHAREH (BH ENB EQBUS VSS) nch_ulvt_mac w=1.143e-05 l=3e-08 nf=6
MSHAREL (BL ENB EQBUS VSS) nch_ulvt_mac w=1.143e-05 l=3e-08 nf=6
// @RNL {
//   /* pins connected by net name: the net-name label of rnl-std-fill on every unwired pin, placed below by its key netname */
//   $LABEL_TERMINAL_SET @TEXT("${net}", key="netname", size=0.6);
//   &VSS @ADD-TO $GROUND_NET_SET; &VREFN @ADD-TO $GROUND_NET_SET;
//   &VREFP @ADD-TO $SUPPLY_NET_SET;
//   &DVDD @ADD-TO $SUPPLY_NET_SET;
//   {#CH #CL} @AS $MATCHED;
//   {#MSH #MSL} @AS $MATCHED;
//   {#MEQ1 #MEQ2} @AS $MATCHED;
//   {#MSHAREH #MSHAREL} @AS $MATCHED;
//   {#XDH #XDL} @AS $MATCHED;
//   #XHCTL @PLACE(-70, 24);
//   #XHCTL @ORIENT("R0");
//   #XHCTL:IN @TEXT("${net}", key="netname", size=0.6, halign="end", valign="middle", dx=-0.4, dy=0);
//   #XHCTL:HIB @TEXT("${net}", key="netname", size=0.6, halign="start", valign="middle", dx=0.4, dy=0);
//   %v1 = $SUPPLY @ATTACH &DVDD => @PLACE(-70, 31.2);
//   &DVDD @WIRE {#XHCTL:DVDD (-70, 28) %v1:p};
//   %g2 = $GROUND @ATTACH &VREFN => @PLACE(-72, 16.8);
//   &VREFN @WIRE {#XHCTL:VREFN (-72, 20) %g2:p};
//   %g3 = $GROUND @ATTACH &VSS => @PLACE(-68, 16.8);
//   &VSS @WIRE {#XHCTL:VSS (-68, 20) %g3:p};
//   #XLCTL @PLACE(-70, -26);
//   #XLCTL @ORIENT("R0");
//   #XLCTL:IN @TEXT("${net}", key="netname", size=0.6, halign="end", valign="middle", dx=-0.4, dy=0);
//   #XLCTL:HIB @TEXT("${net}", key="netname", size=0.6, halign="start", valign="middle", dx=0.4, dy=0);
//   %v4 = $SUPPLY @ATTACH &DVDD => @PLACE(-70, -18.8);
//   &DVDD @WIRE {#XLCTL:DVDD (-70, -22) %v4:p};
//   %g5 = $GROUND @ATTACH &VREFN => @PLACE(-72, -33.2);
//   &VREFN @WIRE {#XLCTL:VREFN (-72, -30) %g5:p};
//   %g6 = $GROUND @ATTACH &VSS => @PLACE(-68, -33.2);
//   &VSS @WIRE {#XLCTL:VSS (-68, -30) %g6:p};
//   #XDH @PLACE(-34, 24);
//   #XDH @ORIENT("R0");
//   #XDH:HIB @TEXT("${net}", key="netname", size=0.6, halign="end", valign="middle", dx=-0.4, dy=0);
//   #XDH:EN @TEXT("${net}", key="netname", size=0.6, halign="end", valign="middle", dx=-0.4, dy=0);
//   #XDH:ENB @TEXT("${net}", key="netname", size=0.6, halign="end", valign="middle", dx=-0.4, dy=0);
//   #XDH:BP @TEXT("${net}", key="netname", size=0.6, halign="start", valign="middle", dx=0.4, dy=0);
//   %v7 = $SUPPLY @ATTACH &VREFP => @PLACE(-36, 32.2);
//   &VREFP @WIRE {#XDH:VREFP (-36, 29) %v7:p};
//   %g8 = $GROUND @ATTACH &VREFN => @PLACE(-36, 15.8);
//   &VREFN @WIRE {#XDH:VREFN (-36, 19) %g8:p};
//   %g9 = $GROUND @ATTACH &VSS => @PLACE(-32, 15.8);
//   &VSS @WIRE {#XDH:VSS (-32, 19) %g9:p};
//   %v10 = $SUPPLY @ATTACH &DVDD => @PLACE(-32, 32.2);
//   &DVDD @WIRE {#XDH:DVDD (-32, 29) %v10:p};
//   #CH @PLACE(14, 24) => @ORIENT("R270");
//   #CH:1 @TEXT("${net}", key="netname", size=0.6, halign="start", valign="middle", dx=0.4, dy=0);
//   #CH:2 @TEXT("${net}", key="netname", size=0.6, halign="end", valign="middle", dx=-0.4, dy=0);
//   #CPH @PLACE(60, 20);
//   #CPH @ORIENT("R0");
//   #CPH:1 @TEXT("${net}", key="netname", size=0.6, halign="start", valign="middle", rotate=90, dx=0, dy=0.4);
//   %g11 = $GROUND @ATTACH &VSS => @PLACE(60, 14.8);
//   &VSS @WIRE {#CPH:2 (60, 18) %g11:p};
//   #MSH @PLACE(2, 8);
//   #MSH @ORIENT("R0");
//   #MSH:1 @TEXT("${net}", key="netname", size=0.6, halign="start", valign="middle", rotate=90, dx=0, dy=0.4);
//   #MSH:2 @TEXT("${net}", key="netname", size=0.6, halign="end", valign="middle", dx=-0.4, dy=0);
//   #MSH:3 @TEXT("${net}", key="netname", size=0.6, halign="end", valign="middle", rotate=90, dx=0, dy=-0.4);
//   %g12 = $GROUND @ATTACH &VSS => @PLACE(5, 4.8);
//   &VSS @WIRE {#MSH:4 (5, 8) %g12:p};
//   #XDL @PLACE(-34, -26);
//   #XDL @ORIENT("R0");
//   #XDL:HIB @TEXT("${net}", key="netname", size=0.6, halign="end", valign="middle", dx=-0.4, dy=0);
//   #XDL:EN @TEXT("${net}", key="netname", size=0.6, halign="end", valign="middle", dx=-0.4, dy=0);
//   #XDL:ENB @TEXT("${net}", key="netname", size=0.6, halign="end", valign="middle", dx=-0.4, dy=0);
//   #XDL:BP @TEXT("${net}", key="netname", size=0.6, halign="start", valign="middle", dx=0.4, dy=0);
//   %v13 = $SUPPLY @ATTACH &VREFP => @PLACE(-36, -17.8);
//   &VREFP @WIRE {#XDL:VREFP (-36, -21) %v13:p};
//   %g14 = $GROUND @ATTACH &VREFN => @PLACE(-36, -34.2);
//   &VREFN @WIRE {#XDL:VREFN (-36, -31) %g14:p};
//   %g15 = $GROUND @ATTACH &VSS => @PLACE(-32, -34.2);
//   &VSS @WIRE {#XDL:VSS (-32, -31) %g15:p};
//   %v16 = $SUPPLY @ATTACH &DVDD => @PLACE(-32, -17.8);
//   &DVDD @WIRE {#XDL:DVDD (-32, -21) %v16:p};
//   #CL @PLACE(14, -26) => @ORIENT("R270");
//   #CL:1 @TEXT("${net}", key="netname", size=0.6, halign="start", valign="middle", dx=0.4, dy=0);
//   #CL:2 @TEXT("${net}", key="netname", size=0.6, halign="end", valign="middle", dx=-0.4, dy=0);
//   #CPL @PLACE(60, -30);
//   #CPL @ORIENT("R0");
//   #CPL:1 @TEXT("${net}", key="netname", size=0.6, halign="start", valign="middle", rotate=90, dx=0, dy=0.4);
//   %g17 = $GROUND @ATTACH &VSS => @PLACE(60, -35.2);
//   &VSS @WIRE {#CPL:2 (60, -32) %g17:p};
//   #MSL @PLACE(2, -42);
//   #MSL @ORIENT("R0");
//   #MSL:1 @TEXT("${net}", key="netname", size=0.6, halign="start", valign="middle", rotate=90, dx=0, dy=0.4);
//   #MSL:2 @TEXT("${net}", key="netname", size=0.6, halign="end", valign="middle", dx=-0.4, dy=0);
//   #MSL:3 @TEXT("${net}", key="netname", size=0.6, halign="end", valign="middle", rotate=90, dx=0, dy=-0.4);
//   %g18 = $GROUND @ATTACH &VSS => @PLACE(5, -45.2);
//   &VSS @WIRE {#MSL:4 (5, -42) %g18:p};
//   #MEQ1 @PLACE(-12, 0);
//   #MEQ1 @ORIENT("R0");
//   #MEQ1:1 @TEXT("${net}", key="netname", size=0.6, halign="end", valign="middle", rotate=90, dx=0, dy=-0.4);
//   #MEQ1:2 @TEXT("${net}", key="netname", size=0.6, halign="end", valign="middle", dx=-0.4, dy=0);
//   #MEQ1:3 @TEXT("${net}", key="netname", size=0.6, halign="start", valign="middle", rotate=90, dx=0, dy=0.4);
//   %v19 = $SUPPLY @ATTACH &VREFP => @PLACE(-9, 3.2);
//   &VREFP @WIRE {#MEQ1:4 (-9, 0) %v19:p};
//   #MEQ2 @PLACE(-12, -50);
//   #MEQ2 @ORIENT("R0");
//   #MEQ2:1 @TEXT("${net}", key="netname", size=0.6, halign="end", valign="middle", rotate=90, dx=0, dy=-0.4);
//   #MEQ2:2 @TEXT("${net}", key="netname", size=0.6, halign="end", valign="middle", dx=-0.4, dy=0);
//   #MEQ2:3 @TEXT("${net}", key="netname", size=0.6, halign="start", valign="middle", rotate=90, dx=0, dy=0.4);
//   %v20 = $SUPPLY @ATTACH &VREFP => @PLACE(-9, -46.8);
//   &VREFP @WIRE {#MEQ2:4 (-9, -50) %v20:p};
//   #MSHAREH @PLACE(56, -2);
//   #MSHAREH @ORIENT("R0");
//   #MSHAREH:1 @TEXT("${net}", key="netname", size=0.6, halign="start", valign="middle", rotate=90, dx=0, dy=0.4);
//   #MSHAREH:2 @TEXT("${net}", key="netname", size=0.6, halign="end", valign="middle", dx=-0.4, dy=0);
//   #MSHAREH:3 @TEXT("${net}", key="netname", size=0.6, halign="end", valign="middle", rotate=90, dx=0, dy=-0.4);
//   %g21 = $GROUND @ATTACH &VSS => @PLACE(59, -5.2);
//   &VSS @WIRE {#MSHAREH:4 (59, -2) %g21:p};
//   #MSHAREL @PLACE(56, -52);
//   #MSHAREL @ORIENT("R0");
//   #MSHAREL:1 @TEXT("${net}", key="netname", size=0.6, halign="start", valign="middle", rotate=90, dx=0, dy=0.4);
//   #MSHAREL:2 @TEXT("${net}", key="netname", size=0.6, halign="end", valign="middle", dx=-0.4, dy=0);
//   #MSHAREL:3 @TEXT("${net}", key="netname", size=0.6, halign="end", valign="middle", rotate=90, dx=0, dy=-0.4);
//   %g22 = $GROUND @ATTACH &VSS => @PLACE(59, -55.2);
//   &VSS @WIRE {#MSHAREL:4 (59, -52) %g22:p};
//   &HHIB @WIRE {#XHCTL:HIB (-52, 24) (-52, 26) #XDH:HIB};
//   %b_H = (-12, 24);
//   $JUNCTION @ATTACH %b_H;
//   &BH @WIRE {#XDH:BP %b_H};
//   &BH @WIRE {%b_H #CH:2};
//   &BH @WIRE {%b_H (-12, 10) #MSH:1};
//   &BH @WIRE {%b_H #MEQ1:1};
//   &LHIB @WIRE {#XLCTL:HIB (-52, -26) (-52, -24) #XDL:HIB};
//   %b_L = (-12, -26);
//   $JUNCTION @ATTACH %b_L;
//   &BL @WIRE {#XDL:BP %b_L};
//   &BL @WIRE {%b_L #CL:2};
//   &BL @WIRE {%b_L (-12, -40) #MSL:1};
//   &BL @WIRE {%b_L #MEQ2:1};
//   &VIN @WIRE {#MSH:3 (6, 6) (6, -44) #MSL:3};
//   &VG @WIRE {#MSH:2 (-5, 8) (-5, -42) #MSL:2};
//   %top_H = (44, 24);
//   $JUNCTION @ATTACH %top_H;
//   %top_L = (44, -26);
//   $JUNCTION @ATTACH %top_L;
//   &TOP @WIRE {#CH:1 %top_H};
//   &TOP @WIRE {#CL:1 %top_L};
//   &TOP @WIRE {%top_H %top_L};
//   %p_vin = $IO_PORT @ATTACH &VIN => @PLACE(2, 2) => @ORIENT("R90");
//   &VIN @WIRE {%p_vin:p #MSH:3};
//   %p_vg = $IO_PORT @ATTACH &VG => @PLACE(-5, 8) => @ORIENT("R0");
//   &VG @WIRE {%p_vg:p #MSH:2};
//   %p_dh = $IO_PORT @ATTACH &DH => @PLACE(-81, 24) => @ORIENT("R0");
//   &DH @WIRE {%p_dh:p #XHCTL:IN};
//   %p_rl = $IO_PORT @ATTACH &RL => @PLACE(-81, -26) => @ORIENT("R0");
//   &RL @WIRE {%p_rl:p #XLCTL:IN};
//   %p_en = $IO_PORT @ATTACH &EN => @PLACE(-45, 24) => @ORIENT("R0");
//   &EN @WIRE {%p_en:p #XDH:EN};
//   %p_enb = $IO_PORT @ATTACH &ENB => @PLACE(-45, 22) => @ORIENT("R0");
//   &ENB @WIRE {%p_enb:p #XDH:ENB};
//   %p_top = $IO_PORT @ATTACH &TOP => @PLACE(20, 24) => @ORIENT("MY");
//   &TOP @WIRE {%p_top:p #CH:1};
//   %p_eqbus = $IO_PORT @ATTACH &EQBUS => @PLACE(56, -8) => @ORIENT("R90");
//   &EQBUS @WIRE {%p_eqbus:p #MSHAREH:3};
//   %p_apgate = $IO_PORT @ATTACH &APGATE => @PLACE(-19, 0) => @ORIENT("R0");
//   &APGATE @WIRE {%p_apgate:p #MEQ1:2};
//   (-10, 46) @TEXT("Matched half-capacitor pair j=12") => @SET-STYLE $title_style
// }
ends mq_cdac_bit12

// Reference-rail output driver j=11
subckt mq_cdac_drv11 (HIB EN ENB BP VREFP VREFN VSS DVDD)
// DVDD prelogic: PCOND = NOR(ENB,HIB); NOFF = NAND(EN,HIB).
// Reference-powered final inverters restore GP and GN to VREFP/VREFN.
// Actual current overlap, settling and device stress require measurement.
MPA0 (AP ENB DVDD DVDD) pch_ulvt_mac w=4.575e-06 l=3e-08 nf=3
MPA1 (PCOND HIB AP DVDD) pch_ulvt_mac w=4.575e-06 l=3e-08 nf=3
MNA0 (PCOND ENB VREFN VSS) nch_ulvt_mac w=2.29e-06 l=3e-08 nf=2
MNA1 (PCOND HIB VREFN VSS) nch_ulvt_mac w=2.29e-06 l=3e-08 nf=2
MPB0 (NOFF EN DVDD DVDD) pch_ulvt_mac w=2.29e-06 l=3e-08 nf=2
MPB1 (NOFF HIB DVDD DVDD) pch_ulvt_mac w=2.29e-06 l=3e-08 nf=2
MNB0 (NOFF EN BN VSS) nch_ulvt_mac w=2.29e-06 l=3e-08 nf=2
MNB1 (BN HIB VREFN VSS) nch_ulvt_mac w=2.29e-06 l=3e-08 nf=2
MGPN (GP PCOND VREFN VSS) nch_mac w=4.575e-06 l=3e-08 nf=3
MGPP (GP PCOND VREFP VREFP) pch_mac w=6.86e-06 l=3e-08 nf=4
MGNN (GN NOFF VREFN VSS) nch_mac w=4.575e-06 l=3e-08 nf=3
MGNP (GN NOFF VREFP VREFP) pch_mac w=2.29e-06 l=3e-08 nf=2
MNOUT (BP GN VREFN VSS) nch_mac w=8.58e-06 l=3e-08 nf=6
MPOUT (BP GP VREFP VREFP) pch_mac w=1.716e-05 l=3e-08 nf=12
// @RNL {
//   /* pins connected by net name: the net-name label of rnl-std-fill on every unwired pin, placed below by its key netname */
//   $LABEL_TERMINAL_SET @TEXT("${net}", key="netname", size=0.6);
//   &VSS @ADD-TO $GROUND_NET_SET; &VREFN @ADD-TO $GROUND_NET_SET;
//   &VREFP @ADD-TO $SUPPLY_NET_SET;
//   &DVDD @ADD-TO $SUPPLY_NET_SET;
//   {#MPA0 #MPA1 #MNA0 #MNA1} @GROUP;
//   {#MPB0 #MPB1 #MNB0 #MNB1} @GROUP;
//   {#MGPN #MGPP} @GROUP;
//   {#MGNN #MGNP} @GROUP;
//   {#MNOUT #MPOUT} @GROUP;
//   #MPA0 @PLACE(12, 40);
//   #MPA0 @ORIENT("R0");
//   #MPA0:1 @TEXT("${net}", key="netname", size=0.6, halign="end", valign="middle", rotate=90, dx=0, dy=-0.4);
//   #MPA0:2 @TEXT("${net}", key="netname", size=0.6, halign="end", valign="middle", dx=-0.4, dy=0);
//   %v1 = $SUPPLY @ATTACH &DVDD => @PLACE(12, 45.2);
//   &DVDD @WIRE {#MPA0:3 (12, 42) %v1:p};
//   %v2 = $SUPPLY @ATTACH &DVDD => @PLACE(15, 43.2);
//   &DVDD @WIRE {#MPA0:4 (15, 40) %v2:p};
//   #MPA1 @PLACE(12, 26);
//   #MPA1 @ORIENT("R0");
//   #MPA1:1 @TEXT("${net}", key="netname", size=0.6, halign="end", valign="middle", rotate=90, dx=0, dy=-0.4);
//   #MPA1:2 @TEXT("${net}", key="netname", size=0.6, halign="end", valign="middle", dx=-0.4, dy=0);
//   #MPA1:3 @TEXT("${net}", key="netname", size=0.6, halign="start", valign="middle", rotate=90, dx=0, dy=0.4);
//   %v3 = $SUPPLY @ATTACH &DVDD => @PLACE(15, 29.2);
//   &DVDD @WIRE {#MPA1:4 (15, 26) %v3:p};
//   #MNA0 @PLACE(0, 2);
//   #MNA0 @ORIENT("R0");
//   #MNA0:1 @TEXT("${net}", key="netname", size=0.6, halign="start", valign="middle", rotate=90, dx=0, dy=0.4);
//   #MNA0:2 @TEXT("${net}", key="netname", size=0.6, halign="end", valign="middle", dx=-0.4, dy=0);
//   %g4 = $GROUND @ATTACH &VREFN => @PLACE(0, -3.2);
//   &VREFN @WIRE {#MNA0:3 (0, 0) %g4:p};
//   %g5 = $GROUND @ATTACH &VSS => @PLACE(3, -1.2);
//   &VSS @WIRE {#MNA0:4 (3, 2) %g5:p};
//   #MNA1 @PLACE(24, 2);
//   #MNA1 @ORIENT("R0");
//   #MNA1:1 @TEXT("${net}", key="netname", size=0.6, halign="start", valign="middle", rotate=90, dx=0, dy=0.4);
//   #MNA1:2 @TEXT("${net}", key="netname", size=0.6, halign="end", valign="middle", dx=-0.4, dy=0);
//   %g6 = $GROUND @ATTACH &VREFN => @PLACE(24, -3.2);
//   &VREFN @WIRE {#MNA1:3 (24, 0) %g6:p};
//   %g7 = $GROUND @ATTACH &VSS => @PLACE(27, -1.2);
//   &VSS @WIRE {#MNA1:4 (27, 2) %g7:p};
//   #MPB0 @PLACE(96, 30);
//   #MPB0 @ORIENT("R0");
//   #MPB0:1 @TEXT("${net}", key="netname", size=0.6, halign="end", valign="middle", rotate=90, dx=0, dy=-0.4);
//   #MPB0:2 @TEXT("${net}", key="netname", size=0.6, halign="end", valign="middle", dx=-0.4, dy=0);
//   %v8 = $SUPPLY @ATTACH &DVDD => @PLACE(96, 35.2);
//   &DVDD @WIRE {#MPB0:3 (96, 32) %v8:p};
//   %v9 = $SUPPLY @ATTACH &DVDD => @PLACE(99, 33.2);
//   &DVDD @WIRE {#MPB0:4 (99, 30) %v9:p};
//   #MPB1 @PLACE(120, 30);
//   #MPB1 @ORIENT("R0");
//   #MPB1:1 @TEXT("${net}", key="netname", size=0.6, halign="end", valign="middle", rotate=90, dx=0, dy=-0.4);
//   #MPB1:2 @TEXT("${net}", key="netname", size=0.6, halign="end", valign="middle", dx=-0.4, dy=0);
//   %v10 = $SUPPLY @ATTACH &DVDD => @PLACE(120, 35.2);
//   &DVDD @WIRE {#MPB1:3 (120, 32) %v10:p};
//   %v11 = $SUPPLY @ATTACH &DVDD => @PLACE(123, 33.2);
//   &DVDD @WIRE {#MPB1:4 (123, 30) %v11:p};
//   #MNB0 @PLACE(108, 12);
//   #MNB0 @ORIENT("R0");
//   #MNB0:1 @TEXT("${net}", key="netname", size=0.6, halign="start", valign="middle", rotate=90, dx=0, dy=0.4);
//   #MNB0:2 @TEXT("${net}", key="netname", size=0.6, halign="end", valign="middle", dx=-0.4, dy=0);
//   #MNB0:3 @TEXT("${net}", key="netname", size=0.6, halign="end", valign="middle", rotate=90, dx=0, dy=-0.4);
//   %g12 = $GROUND @ATTACH &VSS => @PLACE(111, 8.8);
//   &VSS @WIRE {#MNB0:4 (111, 12) %g12:p};
//   #MNB1 @PLACE(108, -2);
//   #MNB1 @ORIENT("R0");
//   #MNB1:1 @TEXT("${net}", key="netname", size=0.6, halign="start", valign="middle", rotate=90, dx=0, dy=0.4);
//   #MNB1:2 @TEXT("${net}", key="netname", size=0.6, halign="end", valign="middle", dx=-0.4, dy=0);
//   %g13 = $GROUND @ATTACH &VREFN => @PLACE(108, -7.2);
//   &VREFN @WIRE {#MNB1:3 (108, -4) %g13:p};
//   %g14 = $GROUND @ATTACH &VSS => @PLACE(111, -5.2);
//   &VSS @WIRE {#MNB1:4 (111, -2) %g14:p};
//   #MGPN @PLACE(64, 2);
//   #MGPN @ORIENT("R0");
//   #MGPN:1 @TEXT("${net}", key="netname", size=0.6, halign="start", valign="middle", rotate=90, dx=0, dy=0.4);
//   #MGPN:2 @TEXT("${net}", key="netname", size=0.6, halign="end", valign="middle", dx=-0.4, dy=0);
//   %g15 = $GROUND @ATTACH &VREFN => @PLACE(64, -3.2);
//   &VREFN @WIRE {#MGPN:3 (64, 0) %g15:p};
//   %g16 = $GROUND @ATTACH &VSS => @PLACE(67, -1.2);
//   &VSS @WIRE {#MGPN:4 (67, 2) %g16:p};
//   #MGPP @PLACE(64, 12);
//   #MGPP @ORIENT("R0");
//   #MGPP:1 @TEXT("${net}", key="netname", size=0.6, halign="end", valign="middle", rotate=90, dx=0, dy=-0.4);
//   #MGPP:2 @TEXT("${net}", key="netname", size=0.6, halign="end", valign="middle", dx=-0.4, dy=0);
//   %v17 = $SUPPLY @ATTACH &VREFP => @PLACE(64, 17.2);
//   &VREFP @WIRE {#MGPP:3 (64, 14) %v17:p};
//   %v18 = $SUPPLY @ATTACH &VREFP => @PLACE(67, 15.2);
//   &VREFP @WIRE {#MGPP:4 (67, 12) %v18:p};
//   #MGNN @PLACE(160, 2);
//   #MGNN @ORIENT("R0");
//   #MGNN:1 @TEXT("${net}", key="netname", size=0.6, halign="start", valign="middle", rotate=90, dx=0, dy=0.4);
//   #MGNN:2 @TEXT("${net}", key="netname", size=0.6, halign="end", valign="middle", dx=-0.4, dy=0);
//   %g19 = $GROUND @ATTACH &VREFN => @PLACE(160, -3.2);
//   &VREFN @WIRE {#MGNN:3 (160, 0) %g19:p};
//   %g20 = $GROUND @ATTACH &VSS => @PLACE(163, -1.2);
//   &VSS @WIRE {#MGNN:4 (163, 2) %g20:p};
//   #MGNP @PLACE(160, 12);
//   #MGNP @ORIENT("R0");
//   #MGNP:1 @TEXT("${net}", key="netname", size=0.6, halign="end", valign="middle", rotate=90, dx=0, dy=-0.4);
//   #MGNP:2 @TEXT("${net}", key="netname", size=0.6, halign="end", valign="middle", dx=-0.4, dy=0);
//   %v21 = $SUPPLY @ATTACH &VREFP => @PLACE(160, 17.2);
//   &VREFP @WIRE {#MGNP:3 (160, 14) %v21:p};
//   %v22 = $SUPPLY @ATTACH &VREFP => @PLACE(163, 15.2);
//   &VREFP @WIRE {#MGNP:4 (163, 12) %v22:p};
//   #MNOUT @PLACE(200, 0);
//   #MNOUT @ORIENT("R0");
//   #MNOUT:1 @TEXT("${net}", key="netname", size=0.6, halign="start", valign="middle", rotate=90, dx=0, dy=0.4);
//   #MNOUT:2 @TEXT("${net}", key="netname", size=0.6, halign="end", valign="middle", dx=-0.4, dy=0);
//   %g23 = $GROUND @ATTACH &VREFN => @PLACE(200, -5.2);
//   &VREFN @WIRE {#MNOUT:3 (200, -2) %g23:p};
//   %g24 = $GROUND @ATTACH &VSS => @PLACE(203, -3.2);
//   &VSS @WIRE {#MNOUT:4 (203, 0) %g24:p};
//   #MPOUT @PLACE(200, 22);
//   #MPOUT @ORIENT("R0");
//   #MPOUT:1 @TEXT("${net}", key="netname", size=0.6, halign="end", valign="middle", rotate=90, dx=0, dy=-0.4);
//   #MPOUT:2 @TEXT("${net}", key="netname", size=0.6, halign="end", valign="middle", dx=-0.4, dy=0);
//   %v25 = $SUPPLY @ATTACH &VREFP => @PLACE(200, 27.2);
//   &VREFP @WIRE {#MPOUT:3 (200, 24) %v25:p};
//   %v26 = $SUPPLY @ATTACH &VREFP => @PLACE(203, 25.2);
//   &VREFP @WIRE {#MPOUT:4 (203, 22) %v26:p};
//   &GP @WIRE {#MGPN:1 #MGPP:1};
//   &PCOND @WIRE {#MGPN:2 (59, 2) (59, 12) #MGPP:2};
//   &GN @WIRE {#MGNN:1 #MGNP:1};
//   &NOFF @WIRE {#MGNN:2 (155, 2) (155, 12) #MGNP:2};
//   &AP @WIRE {#MPA0:1 #MPA1:3};
//   %pc_bus = (12, 16);
//   $JUNCTION @ATTACH %pc_bus;
//   &PCOND @WIRE {#MNA0:1 (0, 16) %pc_bus (24, 16) #MNA1:1};
//   &PCOND @WIRE {#MPA1:1 %pc_bus};
//   %pc_gate = (59, 7);
//   $JUNCTION @ATTACH %pc_gate;
//   &PCOND @WIRE {%pc_bus (50, 16) (50, 7) %pc_gate};
//   &BN @WIRE {#MNB0:3 #MNB1:1};
//   %no_bus = (108, 22);
//   $JUNCTION @ATTACH %no_bus;
//   &NOFF @WIRE {#MPB0:1 (96, 22) %no_bus (120, 22) #MPB1:1};
//   &NOFF @WIRE {#MNB0:1 %no_bus};
//   %no_gate = (155, 7);
//   $JUNCTION @ATTACH %no_gate;
//   &NOFF @WIRE {%no_bus (146, 22) (146, 7) %no_gate};
//   &BP @WIRE {#MNOUT:1 #MPOUT:1};
//   &GP @WIRE {#MGPN:1 (74, 4) (74, 52) (190, 52) (190, 22) #MPOUT:2};
//   &GN @WIRE {#MGNN:1 (180, 4) (180, 0) #MNOUT:2};
//   %p_hib = $IO_PORT @ATTACH &HIB => @PLACE(5, 26) => @ORIENT("R0");
//   &HIB @WIRE {%p_hib:p #MPA1:2};
//   %p_en = $IO_PORT @ATTACH &EN => @PLACE(89, 30) => @ORIENT("R0");
//   &EN @WIRE {%p_en:p #MPB0:2};
//   %p_enb = $IO_PORT @ATTACH &ENB => @PLACE(5, 40) => @ORIENT("R0");
//   &ENB @WIRE {%p_enb:p #MPA0:2};
//   %p_bp = $IO_PORT @ATTACH &BP => @PLACE(200, 6) => @ORIENT("R270");
//   &BP @WIRE {%p_bp:p #MNOUT:1};
//   (-10, 62) @TEXT("Reference-rail output driver j=11") => @SET-STYLE $title_style
// }
ends mq_cdac_drv11

// Matched half-capacitor pair j=11
subckt mq_cdac_bit11 (VIN VG DH RL EN ENB TOP VREFP VREFN VSS DVDD EQBUS APGATE)
// CP*: user-specified 5% bottom-plate estimate for every physical MOM unit, not extraction.
// Series tails retain one unit parasitic at MID and one at B.
// APGATE PMOS assist connects each bottom plate to VIN.
// Additional ENB NMOS sharing retains a common EQBUS.
XHCTL (DH HHIB DVDD VREFN VSS) mq_cdac_ctl_h
XLCTL (RL LHIB DVDD VREFN VSS) mq_cdac_ctl_l
XDH (HHIB EN ENB BH VREFP VREFN VSS DVDD) mq_cdac_drv11
CH (TOP BH) cfmom_2t w=5e-08 s=2.4e-07 nr=6 lr=1.69e-06 stm=2 spm=4 multi=280
CPH (BH VSS) capacitor c=1.40320600e-14
MSH (BH VG VIN VSS) nch_ulvt_mac w=6.54e-06 l=3e-08 nf=4
XDL (LHIB EN ENB BL VREFP VREFN VSS DVDD) mq_cdac_drv11
CL (TOP BL) cfmom_2t w=5e-08 s=2.4e-07 nr=6 lr=1.69e-06 stm=2 spm=4 multi=280
CPL (BL VSS) capacitor c=1.40320600e-14
MSL (BL VG VIN VSS) nch_ulvt_mac w=6.54e-06 l=3e-08 nf=4
MEQ1 (BH APGATE VIN VREFP) pch_ulvt_mac w=6.54e-06 l=3e-08 nf=4
MEQ2 (BL APGATE VIN VREFP) pch_ulvt_mac w=6.54e-06 l=3e-08 nf=4
MSHAREH (BH ENB EQBUS VSS) nch_ulvt_mac w=6.54e-06 l=3e-08 nf=4
MSHAREL (BL ENB EQBUS VSS) nch_ulvt_mac w=6.54e-06 l=3e-08 nf=4
// @RNL {
//   /* pins connected by net name: the net-name label of rnl-std-fill on every unwired pin, placed below by its key netname */
//   $LABEL_TERMINAL_SET @TEXT("${net}", key="netname", size=0.6);
//   &VSS @ADD-TO $GROUND_NET_SET; &VREFN @ADD-TO $GROUND_NET_SET;
//   &VREFP @ADD-TO $SUPPLY_NET_SET;
//   &DVDD @ADD-TO $SUPPLY_NET_SET;
//   {#CH #CL} @AS $MATCHED;
//   {#MSH #MSL} @AS $MATCHED;
//   {#MEQ1 #MEQ2} @AS $MATCHED;
//   {#MSHAREH #MSHAREL} @AS $MATCHED;
//   {#XDH #XDL} @AS $MATCHED;
//   #XHCTL @PLACE(-70, 24);
//   #XHCTL @ORIENT("R0");
//   #XHCTL:IN @TEXT("${net}", key="netname", size=0.6, halign="end", valign="middle", dx=-0.4, dy=0);
//   #XHCTL:HIB @TEXT("${net}", key="netname", size=0.6, halign="start", valign="middle", dx=0.4, dy=0);
//   %v1 = $SUPPLY @ATTACH &DVDD => @PLACE(-70, 31.2);
//   &DVDD @WIRE {#XHCTL:DVDD (-70, 28) %v1:p};
//   %g2 = $GROUND @ATTACH &VREFN => @PLACE(-72, 16.8);
//   &VREFN @WIRE {#XHCTL:VREFN (-72, 20) %g2:p};
//   %g3 = $GROUND @ATTACH &VSS => @PLACE(-68, 16.8);
//   &VSS @WIRE {#XHCTL:VSS (-68, 20) %g3:p};
//   #XLCTL @PLACE(-70, -26);
//   #XLCTL @ORIENT("R0");
//   #XLCTL:IN @TEXT("${net}", key="netname", size=0.6, halign="end", valign="middle", dx=-0.4, dy=0);
//   #XLCTL:HIB @TEXT("${net}", key="netname", size=0.6, halign="start", valign="middle", dx=0.4, dy=0);
//   %v4 = $SUPPLY @ATTACH &DVDD => @PLACE(-70, -18.8);
//   &DVDD @WIRE {#XLCTL:DVDD (-70, -22) %v4:p};
//   %g5 = $GROUND @ATTACH &VREFN => @PLACE(-72, -33.2);
//   &VREFN @WIRE {#XLCTL:VREFN (-72, -30) %g5:p};
//   %g6 = $GROUND @ATTACH &VSS => @PLACE(-68, -33.2);
//   &VSS @WIRE {#XLCTL:VSS (-68, -30) %g6:p};
//   #XDH @PLACE(-34, 24);
//   #XDH @ORIENT("R0");
//   #XDH:HIB @TEXT("${net}", key="netname", size=0.6, halign="end", valign="middle", dx=-0.4, dy=0);
//   #XDH:EN @TEXT("${net}", key="netname", size=0.6, halign="end", valign="middle", dx=-0.4, dy=0);
//   #XDH:ENB @TEXT("${net}", key="netname", size=0.6, halign="end", valign="middle", dx=-0.4, dy=0);
//   #XDH:BP @TEXT("${net}", key="netname", size=0.6, halign="start", valign="middle", dx=0.4, dy=0);
//   %v7 = $SUPPLY @ATTACH &VREFP => @PLACE(-36, 32.2);
//   &VREFP @WIRE {#XDH:VREFP (-36, 29) %v7:p};
//   %g8 = $GROUND @ATTACH &VREFN => @PLACE(-36, 15.8);
//   &VREFN @WIRE {#XDH:VREFN (-36, 19) %g8:p};
//   %g9 = $GROUND @ATTACH &VSS => @PLACE(-32, 15.8);
//   &VSS @WIRE {#XDH:VSS (-32, 19) %g9:p};
//   %v10 = $SUPPLY @ATTACH &DVDD => @PLACE(-32, 32.2);
//   &DVDD @WIRE {#XDH:DVDD (-32, 29) %v10:p};
//   #CH @PLACE(14, 24) => @ORIENT("R270");
//   #CH:1 @TEXT("${net}", key="netname", size=0.6, halign="start", valign="middle", dx=0.4, dy=0);
//   #CH:2 @TEXT("${net}", key="netname", size=0.6, halign="end", valign="middle", dx=-0.4, dy=0);
//   #CPH @PLACE(60, 20);
//   #CPH @ORIENT("R0");
//   #CPH:1 @TEXT("${net}", key="netname", size=0.6, halign="start", valign="middle", rotate=90, dx=0, dy=0.4);
//   %g11 = $GROUND @ATTACH &VSS => @PLACE(60, 14.8);
//   &VSS @WIRE {#CPH:2 (60, 18) %g11:p};
//   #MSH @PLACE(2, 8);
//   #MSH @ORIENT("R0");
//   #MSH:1 @TEXT("${net}", key="netname", size=0.6, halign="start", valign="middle", rotate=90, dx=0, dy=0.4);
//   #MSH:2 @TEXT("${net}", key="netname", size=0.6, halign="end", valign="middle", dx=-0.4, dy=0);
//   #MSH:3 @TEXT("${net}", key="netname", size=0.6, halign="end", valign="middle", rotate=90, dx=0, dy=-0.4);
//   %g12 = $GROUND @ATTACH &VSS => @PLACE(5, 4.8);
//   &VSS @WIRE {#MSH:4 (5, 8) %g12:p};
//   #XDL @PLACE(-34, -26);
//   #XDL @ORIENT("R0");
//   #XDL:HIB @TEXT("${net}", key="netname", size=0.6, halign="end", valign="middle", dx=-0.4, dy=0);
//   #XDL:EN @TEXT("${net}", key="netname", size=0.6, halign="end", valign="middle", dx=-0.4, dy=0);
//   #XDL:ENB @TEXT("${net}", key="netname", size=0.6, halign="end", valign="middle", dx=-0.4, dy=0);
//   #XDL:BP @TEXT("${net}", key="netname", size=0.6, halign="start", valign="middle", dx=0.4, dy=0);
//   %v13 = $SUPPLY @ATTACH &VREFP => @PLACE(-36, -17.8);
//   &VREFP @WIRE {#XDL:VREFP (-36, -21) %v13:p};
//   %g14 = $GROUND @ATTACH &VREFN => @PLACE(-36, -34.2);
//   &VREFN @WIRE {#XDL:VREFN (-36, -31) %g14:p};
//   %g15 = $GROUND @ATTACH &VSS => @PLACE(-32, -34.2);
//   &VSS @WIRE {#XDL:VSS (-32, -31) %g15:p};
//   %v16 = $SUPPLY @ATTACH &DVDD => @PLACE(-32, -17.8);
//   &DVDD @WIRE {#XDL:DVDD (-32, -21) %v16:p};
//   #CL @PLACE(14, -26) => @ORIENT("R270");
//   #CL:1 @TEXT("${net}", key="netname", size=0.6, halign="start", valign="middle", dx=0.4, dy=0);
//   #CL:2 @TEXT("${net}", key="netname", size=0.6, halign="end", valign="middle", dx=-0.4, dy=0);
//   #CPL @PLACE(60, -30);
//   #CPL @ORIENT("R0");
//   #CPL:1 @TEXT("${net}", key="netname", size=0.6, halign="start", valign="middle", rotate=90, dx=0, dy=0.4);
//   %g17 = $GROUND @ATTACH &VSS => @PLACE(60, -35.2);
//   &VSS @WIRE {#CPL:2 (60, -32) %g17:p};
//   #MSL @PLACE(2, -42);
//   #MSL @ORIENT("R0");
//   #MSL:1 @TEXT("${net}", key="netname", size=0.6, halign="start", valign="middle", rotate=90, dx=0, dy=0.4);
//   #MSL:2 @TEXT("${net}", key="netname", size=0.6, halign="end", valign="middle", dx=-0.4, dy=0);
//   #MSL:3 @TEXT("${net}", key="netname", size=0.6, halign="end", valign="middle", rotate=90, dx=0, dy=-0.4);
//   %g18 = $GROUND @ATTACH &VSS => @PLACE(5, -45.2);
//   &VSS @WIRE {#MSL:4 (5, -42) %g18:p};
//   #MEQ1 @PLACE(-12, 0);
//   #MEQ1 @ORIENT("R0");
//   #MEQ1:1 @TEXT("${net}", key="netname", size=0.6, halign="end", valign="middle", rotate=90, dx=0, dy=-0.4);
//   #MEQ1:2 @TEXT("${net}", key="netname", size=0.6, halign="end", valign="middle", dx=-0.4, dy=0);
//   #MEQ1:3 @TEXT("${net}", key="netname", size=0.6, halign="start", valign="middle", rotate=90, dx=0, dy=0.4);
//   %v19 = $SUPPLY @ATTACH &VREFP => @PLACE(-9, 3.2);
//   &VREFP @WIRE {#MEQ1:4 (-9, 0) %v19:p};
//   #MEQ2 @PLACE(-12, -50);
//   #MEQ2 @ORIENT("R0");
//   #MEQ2:1 @TEXT("${net}", key="netname", size=0.6, halign="end", valign="middle", rotate=90, dx=0, dy=-0.4);
//   #MEQ2:2 @TEXT("${net}", key="netname", size=0.6, halign="end", valign="middle", dx=-0.4, dy=0);
//   #MEQ2:3 @TEXT("${net}", key="netname", size=0.6, halign="start", valign="middle", rotate=90, dx=0, dy=0.4);
//   %v20 = $SUPPLY @ATTACH &VREFP => @PLACE(-9, -46.8);
//   &VREFP @WIRE {#MEQ2:4 (-9, -50) %v20:p};
//   #MSHAREH @PLACE(56, -2);
//   #MSHAREH @ORIENT("R0");
//   #MSHAREH:1 @TEXT("${net}", key="netname", size=0.6, halign="start", valign="middle", rotate=90, dx=0, dy=0.4);
//   #MSHAREH:2 @TEXT("${net}", key="netname", size=0.6, halign="end", valign="middle", dx=-0.4, dy=0);
//   #MSHAREH:3 @TEXT("${net}", key="netname", size=0.6, halign="end", valign="middle", rotate=90, dx=0, dy=-0.4);
//   %g21 = $GROUND @ATTACH &VSS => @PLACE(59, -5.2);
//   &VSS @WIRE {#MSHAREH:4 (59, -2) %g21:p};
//   #MSHAREL @PLACE(56, -52);
//   #MSHAREL @ORIENT("R0");
//   #MSHAREL:1 @TEXT("${net}", key="netname", size=0.6, halign="start", valign="middle", rotate=90, dx=0, dy=0.4);
//   #MSHAREL:2 @TEXT("${net}", key="netname", size=0.6, halign="end", valign="middle", dx=-0.4, dy=0);
//   #MSHAREL:3 @TEXT("${net}", key="netname", size=0.6, halign="end", valign="middle", rotate=90, dx=0, dy=-0.4);
//   %g22 = $GROUND @ATTACH &VSS => @PLACE(59, -55.2);
//   &VSS @WIRE {#MSHAREL:4 (59, -52) %g22:p};
//   &HHIB @WIRE {#XHCTL:HIB (-52, 24) (-52, 26) #XDH:HIB};
//   %b_H = (-12, 24);
//   $JUNCTION @ATTACH %b_H;
//   &BH @WIRE {#XDH:BP %b_H};
//   &BH @WIRE {%b_H #CH:2};
//   &BH @WIRE {%b_H (-12, 10) #MSH:1};
//   &BH @WIRE {%b_H #MEQ1:1};
//   &LHIB @WIRE {#XLCTL:HIB (-52, -26) (-52, -24) #XDL:HIB};
//   %b_L = (-12, -26);
//   $JUNCTION @ATTACH %b_L;
//   &BL @WIRE {#XDL:BP %b_L};
//   &BL @WIRE {%b_L #CL:2};
//   &BL @WIRE {%b_L (-12, -40) #MSL:1};
//   &BL @WIRE {%b_L #MEQ2:1};
//   &VIN @WIRE {#MSH:3 (6, 6) (6, -44) #MSL:3};
//   &VG @WIRE {#MSH:2 (-5, 8) (-5, -42) #MSL:2};
//   %top_H = (44, 24);
//   $JUNCTION @ATTACH %top_H;
//   %top_L = (44, -26);
//   $JUNCTION @ATTACH %top_L;
//   &TOP @WIRE {#CH:1 %top_H};
//   &TOP @WIRE {#CL:1 %top_L};
//   &TOP @WIRE {%top_H %top_L};
//   %p_vin = $IO_PORT @ATTACH &VIN => @PLACE(2, 2) => @ORIENT("R90");
//   &VIN @WIRE {%p_vin:p #MSH:3};
//   %p_vg = $IO_PORT @ATTACH &VG => @PLACE(-5, 8) => @ORIENT("R0");
//   &VG @WIRE {%p_vg:p #MSH:2};
//   %p_dh = $IO_PORT @ATTACH &DH => @PLACE(-81, 24) => @ORIENT("R0");
//   &DH @WIRE {%p_dh:p #XHCTL:IN};
//   %p_rl = $IO_PORT @ATTACH &RL => @PLACE(-81, -26) => @ORIENT("R0");
//   &RL @WIRE {%p_rl:p #XLCTL:IN};
//   %p_en = $IO_PORT @ATTACH &EN => @PLACE(-45, 24) => @ORIENT("R0");
//   &EN @WIRE {%p_en:p #XDH:EN};
//   %p_enb = $IO_PORT @ATTACH &ENB => @PLACE(-45, 22) => @ORIENT("R0");
//   &ENB @WIRE {%p_enb:p #XDH:ENB};
//   %p_top = $IO_PORT @ATTACH &TOP => @PLACE(20, 24) => @ORIENT("MY");
//   &TOP @WIRE {%p_top:p #CH:1};
//   %p_eqbus = $IO_PORT @ATTACH &EQBUS => @PLACE(56, -8) => @ORIENT("R90");
//   &EQBUS @WIRE {%p_eqbus:p #MSHAREH:3};
//   %p_apgate = $IO_PORT @ATTACH &APGATE => @PLACE(-19, 0) => @ORIENT("R0");
//   &APGATE @WIRE {%p_apgate:p #MEQ1:2};
//   (-10, 46) @TEXT("Matched half-capacitor pair j=11") => @SET-STYLE $title_style
// }
ends mq_cdac_bit11

// Reference-rail output driver j=10
subckt mq_cdac_drv10 (HIB EN ENB BP VREFP VREFN VSS DVDD)
// DVDD prelogic: PCOND = NOR(ENB,HIB); NOFF = NAND(EN,HIB).
// Reference-powered final inverters restore GP and GN to VREFP/VREFN.
// Actual current overlap, settling and device stress require measurement.
MPA0 (AP ENB DVDD DVDD) pch_ulvt_mac w=2.6e-06 l=3e-08 nf=2
MPA1 (PCOND HIB AP DVDD) pch_ulvt_mac w=2.6e-06 l=3e-08 nf=2
MNA0 (PCOND ENB VREFN VSS) nch_ulvt_mac w=1.3e-06 l=3e-08 nf=1
MNA1 (PCOND HIB VREFN VSS) nch_ulvt_mac w=1.3e-06 l=3e-08 nf=1
MPB0 (NOFF EN DVDD DVDD) pch_ulvt_mac w=1.3e-06 l=3e-08 nf=1
MPB1 (NOFF HIB DVDD DVDD) pch_ulvt_mac w=1.3e-06 l=3e-08 nf=1
MNB0 (NOFF EN BN VSS) nch_ulvt_mac w=1.3e-06 l=3e-08 nf=1
MNB1 (BN HIB VREFN VSS) nch_ulvt_mac w=1.3e-06 l=3e-08 nf=1
MGPN (GP PCOND VREFN VSS) nch_mac w=2.6e-06 l=3e-08 nf=2
MGPP (GP PCOND VREFP VREFP) pch_mac w=3.89e-06 l=3e-08 nf=2
MGNN (GN NOFF VREFN VSS) nch_mac w=2.6e-06 l=3e-08 nf=2
MGNP (GN NOFF VREFP VREFP) pch_mac w=1.3e-06 l=3e-08 nf=1
MNOUT (BP GN VREFN VSS) nch_mac w=4.86e-06 l=3e-08 nf=4
MPOUT (BP GP VREFP VREFP) pch_mac w=9.73e-06 l=3e-08 nf=7
// @RNL {
//   /* pins connected by net name: the net-name label of rnl-std-fill on every unwired pin, placed below by its key netname */
//   $LABEL_TERMINAL_SET @TEXT("${net}", key="netname", size=0.6);
//   &VSS @ADD-TO $GROUND_NET_SET; &VREFN @ADD-TO $GROUND_NET_SET;
//   &VREFP @ADD-TO $SUPPLY_NET_SET;
//   &DVDD @ADD-TO $SUPPLY_NET_SET;
//   {#MPA0 #MPA1 #MNA0 #MNA1} @GROUP;
//   {#MPB0 #MPB1 #MNB0 #MNB1} @GROUP;
//   {#MGPN #MGPP} @GROUP;
//   {#MGNN #MGNP} @GROUP;
//   {#MNOUT #MPOUT} @GROUP;
//   #MPA0 @PLACE(12, 40);
//   #MPA0 @ORIENT("R0");
//   #MPA0:1 @TEXT("${net}", key="netname", size=0.6, halign="end", valign="middle", rotate=90, dx=0, dy=-0.4);
//   #MPA0:2 @TEXT("${net}", key="netname", size=0.6, halign="end", valign="middle", dx=-0.4, dy=0);
//   %v1 = $SUPPLY @ATTACH &DVDD => @PLACE(12, 45.2);
//   &DVDD @WIRE {#MPA0:3 (12, 42) %v1:p};
//   %v2 = $SUPPLY @ATTACH &DVDD => @PLACE(15, 43.2);
//   &DVDD @WIRE {#MPA0:4 (15, 40) %v2:p};
//   #MPA1 @PLACE(12, 26);
//   #MPA1 @ORIENT("R0");
//   #MPA1:1 @TEXT("${net}", key="netname", size=0.6, halign="end", valign="middle", rotate=90, dx=0, dy=-0.4);
//   #MPA1:2 @TEXT("${net}", key="netname", size=0.6, halign="end", valign="middle", dx=-0.4, dy=0);
//   #MPA1:3 @TEXT("${net}", key="netname", size=0.6, halign="start", valign="middle", rotate=90, dx=0, dy=0.4);
//   %v3 = $SUPPLY @ATTACH &DVDD => @PLACE(15, 29.2);
//   &DVDD @WIRE {#MPA1:4 (15, 26) %v3:p};
//   #MNA0 @PLACE(0, 2);
//   #MNA0 @ORIENT("R0");
//   #MNA0:1 @TEXT("${net}", key="netname", size=0.6, halign="start", valign="middle", rotate=90, dx=0, dy=0.4);
//   #MNA0:2 @TEXT("${net}", key="netname", size=0.6, halign="end", valign="middle", dx=-0.4, dy=0);
//   %g4 = $GROUND @ATTACH &VREFN => @PLACE(0, -3.2);
//   &VREFN @WIRE {#MNA0:3 (0, 0) %g4:p};
//   %g5 = $GROUND @ATTACH &VSS => @PLACE(3, -1.2);
//   &VSS @WIRE {#MNA0:4 (3, 2) %g5:p};
//   #MNA1 @PLACE(24, 2);
//   #MNA1 @ORIENT("R0");
//   #MNA1:1 @TEXT("${net}", key="netname", size=0.6, halign="start", valign="middle", rotate=90, dx=0, dy=0.4);
//   #MNA1:2 @TEXT("${net}", key="netname", size=0.6, halign="end", valign="middle", dx=-0.4, dy=0);
//   %g6 = $GROUND @ATTACH &VREFN => @PLACE(24, -3.2);
//   &VREFN @WIRE {#MNA1:3 (24, 0) %g6:p};
//   %g7 = $GROUND @ATTACH &VSS => @PLACE(27, -1.2);
//   &VSS @WIRE {#MNA1:4 (27, 2) %g7:p};
//   #MPB0 @PLACE(96, 30);
//   #MPB0 @ORIENT("R0");
//   #MPB0:1 @TEXT("${net}", key="netname", size=0.6, halign="end", valign="middle", rotate=90, dx=0, dy=-0.4);
//   #MPB0:2 @TEXT("${net}", key="netname", size=0.6, halign="end", valign="middle", dx=-0.4, dy=0);
//   %v8 = $SUPPLY @ATTACH &DVDD => @PLACE(96, 35.2);
//   &DVDD @WIRE {#MPB0:3 (96, 32) %v8:p};
//   %v9 = $SUPPLY @ATTACH &DVDD => @PLACE(99, 33.2);
//   &DVDD @WIRE {#MPB0:4 (99, 30) %v9:p};
//   #MPB1 @PLACE(120, 30);
//   #MPB1 @ORIENT("R0");
//   #MPB1:1 @TEXT("${net}", key="netname", size=0.6, halign="end", valign="middle", rotate=90, dx=0, dy=-0.4);
//   #MPB1:2 @TEXT("${net}", key="netname", size=0.6, halign="end", valign="middle", dx=-0.4, dy=0);
//   %v10 = $SUPPLY @ATTACH &DVDD => @PLACE(120, 35.2);
//   &DVDD @WIRE {#MPB1:3 (120, 32) %v10:p};
//   %v11 = $SUPPLY @ATTACH &DVDD => @PLACE(123, 33.2);
//   &DVDD @WIRE {#MPB1:4 (123, 30) %v11:p};
//   #MNB0 @PLACE(108, 12);
//   #MNB0 @ORIENT("R0");
//   #MNB0:1 @TEXT("${net}", key="netname", size=0.6, halign="start", valign="middle", rotate=90, dx=0, dy=0.4);
//   #MNB0:2 @TEXT("${net}", key="netname", size=0.6, halign="end", valign="middle", dx=-0.4, dy=0);
//   #MNB0:3 @TEXT("${net}", key="netname", size=0.6, halign="end", valign="middle", rotate=90, dx=0, dy=-0.4);
//   %g12 = $GROUND @ATTACH &VSS => @PLACE(111, 8.8);
//   &VSS @WIRE {#MNB0:4 (111, 12) %g12:p};
//   #MNB1 @PLACE(108, -2);
//   #MNB1 @ORIENT("R0");
//   #MNB1:1 @TEXT("${net}", key="netname", size=0.6, halign="start", valign="middle", rotate=90, dx=0, dy=0.4);
//   #MNB1:2 @TEXT("${net}", key="netname", size=0.6, halign="end", valign="middle", dx=-0.4, dy=0);
//   %g13 = $GROUND @ATTACH &VREFN => @PLACE(108, -7.2);
//   &VREFN @WIRE {#MNB1:3 (108, -4) %g13:p};
//   %g14 = $GROUND @ATTACH &VSS => @PLACE(111, -5.2);
//   &VSS @WIRE {#MNB1:4 (111, -2) %g14:p};
//   #MGPN @PLACE(64, 2);
//   #MGPN @ORIENT("R0");
//   #MGPN:1 @TEXT("${net}", key="netname", size=0.6, halign="start", valign="middle", rotate=90, dx=0, dy=0.4);
//   #MGPN:2 @TEXT("${net}", key="netname", size=0.6, halign="end", valign="middle", dx=-0.4, dy=0);
//   %g15 = $GROUND @ATTACH &VREFN => @PLACE(64, -3.2);
//   &VREFN @WIRE {#MGPN:3 (64, 0) %g15:p};
//   %g16 = $GROUND @ATTACH &VSS => @PLACE(67, -1.2);
//   &VSS @WIRE {#MGPN:4 (67, 2) %g16:p};
//   #MGPP @PLACE(64, 12);
//   #MGPP @ORIENT("R0");
//   #MGPP:1 @TEXT("${net}", key="netname", size=0.6, halign="end", valign="middle", rotate=90, dx=0, dy=-0.4);
//   #MGPP:2 @TEXT("${net}", key="netname", size=0.6, halign="end", valign="middle", dx=-0.4, dy=0);
//   %v17 = $SUPPLY @ATTACH &VREFP => @PLACE(64, 17.2);
//   &VREFP @WIRE {#MGPP:3 (64, 14) %v17:p};
//   %v18 = $SUPPLY @ATTACH &VREFP => @PLACE(67, 15.2);
//   &VREFP @WIRE {#MGPP:4 (67, 12) %v18:p};
//   #MGNN @PLACE(160, 2);
//   #MGNN @ORIENT("R0");
//   #MGNN:1 @TEXT("${net}", key="netname", size=0.6, halign="start", valign="middle", rotate=90, dx=0, dy=0.4);
//   #MGNN:2 @TEXT("${net}", key="netname", size=0.6, halign="end", valign="middle", dx=-0.4, dy=0);
//   %g19 = $GROUND @ATTACH &VREFN => @PLACE(160, -3.2);
//   &VREFN @WIRE {#MGNN:3 (160, 0) %g19:p};
//   %g20 = $GROUND @ATTACH &VSS => @PLACE(163, -1.2);
//   &VSS @WIRE {#MGNN:4 (163, 2) %g20:p};
//   #MGNP @PLACE(160, 12);
//   #MGNP @ORIENT("R0");
//   #MGNP:1 @TEXT("${net}", key="netname", size=0.6, halign="end", valign="middle", rotate=90, dx=0, dy=-0.4);
//   #MGNP:2 @TEXT("${net}", key="netname", size=0.6, halign="end", valign="middle", dx=-0.4, dy=0);
//   %v21 = $SUPPLY @ATTACH &VREFP => @PLACE(160, 17.2);
//   &VREFP @WIRE {#MGNP:3 (160, 14) %v21:p};
//   %v22 = $SUPPLY @ATTACH &VREFP => @PLACE(163, 15.2);
//   &VREFP @WIRE {#MGNP:4 (163, 12) %v22:p};
//   #MNOUT @PLACE(200, 0);
//   #MNOUT @ORIENT("R0");
//   #MNOUT:1 @TEXT("${net}", key="netname", size=0.6, halign="start", valign="middle", rotate=90, dx=0, dy=0.4);
//   #MNOUT:2 @TEXT("${net}", key="netname", size=0.6, halign="end", valign="middle", dx=-0.4, dy=0);
//   %g23 = $GROUND @ATTACH &VREFN => @PLACE(200, -5.2);
//   &VREFN @WIRE {#MNOUT:3 (200, -2) %g23:p};
//   %g24 = $GROUND @ATTACH &VSS => @PLACE(203, -3.2);
//   &VSS @WIRE {#MNOUT:4 (203, 0) %g24:p};
//   #MPOUT @PLACE(200, 22);
//   #MPOUT @ORIENT("R0");
//   #MPOUT:1 @TEXT("${net}", key="netname", size=0.6, halign="end", valign="middle", rotate=90, dx=0, dy=-0.4);
//   #MPOUT:2 @TEXT("${net}", key="netname", size=0.6, halign="end", valign="middle", dx=-0.4, dy=0);
//   %v25 = $SUPPLY @ATTACH &VREFP => @PLACE(200, 27.2);
//   &VREFP @WIRE {#MPOUT:3 (200, 24) %v25:p};
//   %v26 = $SUPPLY @ATTACH &VREFP => @PLACE(203, 25.2);
//   &VREFP @WIRE {#MPOUT:4 (203, 22) %v26:p};
//   &GP @WIRE {#MGPN:1 #MGPP:1};
//   &PCOND @WIRE {#MGPN:2 (59, 2) (59, 12) #MGPP:2};
//   &GN @WIRE {#MGNN:1 #MGNP:1};
//   &NOFF @WIRE {#MGNN:2 (155, 2) (155, 12) #MGNP:2};
//   &AP @WIRE {#MPA0:1 #MPA1:3};
//   %pc_bus = (12, 16);
//   $JUNCTION @ATTACH %pc_bus;
//   &PCOND @WIRE {#MNA0:1 (0, 16) %pc_bus (24, 16) #MNA1:1};
//   &PCOND @WIRE {#MPA1:1 %pc_bus};
//   %pc_gate = (59, 7);
//   $JUNCTION @ATTACH %pc_gate;
//   &PCOND @WIRE {%pc_bus (50, 16) (50, 7) %pc_gate};
//   &BN @WIRE {#MNB0:3 #MNB1:1};
//   %no_bus = (108, 22);
//   $JUNCTION @ATTACH %no_bus;
//   &NOFF @WIRE {#MPB0:1 (96, 22) %no_bus (120, 22) #MPB1:1};
//   &NOFF @WIRE {#MNB0:1 %no_bus};
//   %no_gate = (155, 7);
//   $JUNCTION @ATTACH %no_gate;
//   &NOFF @WIRE {%no_bus (146, 22) (146, 7) %no_gate};
//   &BP @WIRE {#MNOUT:1 #MPOUT:1};
//   &GP @WIRE {#MGPN:1 (74, 4) (74, 52) (190, 52) (190, 22) #MPOUT:2};
//   &GN @WIRE {#MGNN:1 (180, 4) (180, 0) #MNOUT:2};
//   %p_hib = $IO_PORT @ATTACH &HIB => @PLACE(5, 26) => @ORIENT("R0");
//   &HIB @WIRE {%p_hib:p #MPA1:2};
//   %p_en = $IO_PORT @ATTACH &EN => @PLACE(89, 30) => @ORIENT("R0");
//   &EN @WIRE {%p_en:p #MPB0:2};
//   %p_enb = $IO_PORT @ATTACH &ENB => @PLACE(5, 40) => @ORIENT("R0");
//   &ENB @WIRE {%p_enb:p #MPA0:2};
//   %p_bp = $IO_PORT @ATTACH &BP => @PLACE(200, 6) => @ORIENT("R270");
//   &BP @WIRE {%p_bp:p #MNOUT:1};
//   (-10, 62) @TEXT("Reference-rail output driver j=10") => @SET-STYLE $title_style
// }
ends mq_cdac_drv10

// Matched half-capacitor pair j=10
subckt mq_cdac_bit10 (VIN VG DH RL EN ENB TOP VREFP VREFN VSS DVDD EQBUS APGATE)
// CP*: user-specified 5% bottom-plate estimate for every physical MOM unit, not extraction.
// Series tails retain one unit parasitic at MID and one at B.
// APGATE PMOS assist connects each bottom plate to VIN.
// Additional ENB NMOS sharing retains a common EQBUS.
XHCTL (DH HHIB DVDD VREFN VSS) mq_cdac_ctl_h
XLCTL (RL LHIB DVDD VREFN VSS) mq_cdac_ctl_l
XDH (HHIB EN ENB BH VREFP VREFN VSS DVDD) mq_cdac_drv10
CH (TOP BH) cfmom_2t w=5e-08 s=2.4e-07 nr=6 lr=1.69e-06 stm=2 spm=4 multi=159
CPH (BH VSS) capacitor c=7.9682055e-15
MSH (BH VG VIN VSS) nch_ulvt_mac w=3.71e-06 l=3e-08 nf=2
XDL (LHIB EN ENB BL VREFP VREFN VSS DVDD) mq_cdac_drv10
CL (TOP BL) cfmom_2t w=5e-08 s=2.4e-07 nr=6 lr=1.69e-06 stm=2 spm=4 multi=159
CPL (BL VSS) capacitor c=7.9682055e-15
MSL (BL VG VIN VSS) nch_ulvt_mac w=3.71e-06 l=3e-08 nf=2
MEQ1 (BH APGATE VIN VREFP) pch_ulvt_mac w=3.71e-06 l=3e-08 nf=2
MEQ2 (BL APGATE VIN VREFP) pch_ulvt_mac w=3.71e-06 l=3e-08 nf=2
MSHAREH (BH ENB EQBUS VSS) nch_ulvt_mac w=3.71e-06 l=3e-08 nf=2
MSHAREL (BL ENB EQBUS VSS) nch_ulvt_mac w=3.71e-06 l=3e-08 nf=2
// @RNL {
//   /* pins connected by net name: the net-name label of rnl-std-fill on every unwired pin, placed below by its key netname */
//   $LABEL_TERMINAL_SET @TEXT("${net}", key="netname", size=0.6);
//   &VSS @ADD-TO $GROUND_NET_SET; &VREFN @ADD-TO $GROUND_NET_SET;
//   &VREFP @ADD-TO $SUPPLY_NET_SET;
//   &DVDD @ADD-TO $SUPPLY_NET_SET;
//   {#CH #CL} @AS $MATCHED;
//   {#MSH #MSL} @AS $MATCHED;
//   {#MEQ1 #MEQ2} @AS $MATCHED;
//   {#MSHAREH #MSHAREL} @AS $MATCHED;
//   {#XDH #XDL} @AS $MATCHED;
//   #XHCTL @PLACE(-70, 24);
//   #XHCTL @ORIENT("R0");
//   #XHCTL:IN @TEXT("${net}", key="netname", size=0.6, halign="end", valign="middle", dx=-0.4, dy=0);
//   #XHCTL:HIB @TEXT("${net}", key="netname", size=0.6, halign="start", valign="middle", dx=0.4, dy=0);
//   %v1 = $SUPPLY @ATTACH &DVDD => @PLACE(-70, 31.2);
//   &DVDD @WIRE {#XHCTL:DVDD (-70, 28) %v1:p};
//   %g2 = $GROUND @ATTACH &VREFN => @PLACE(-72, 16.8);
//   &VREFN @WIRE {#XHCTL:VREFN (-72, 20) %g2:p};
//   %g3 = $GROUND @ATTACH &VSS => @PLACE(-68, 16.8);
//   &VSS @WIRE {#XHCTL:VSS (-68, 20) %g3:p};
//   #XLCTL @PLACE(-70, -26);
//   #XLCTL @ORIENT("R0");
//   #XLCTL:IN @TEXT("${net}", key="netname", size=0.6, halign="end", valign="middle", dx=-0.4, dy=0);
//   #XLCTL:HIB @TEXT("${net}", key="netname", size=0.6, halign="start", valign="middle", dx=0.4, dy=0);
//   %v4 = $SUPPLY @ATTACH &DVDD => @PLACE(-70, -18.8);
//   &DVDD @WIRE {#XLCTL:DVDD (-70, -22) %v4:p};
//   %g5 = $GROUND @ATTACH &VREFN => @PLACE(-72, -33.2);
//   &VREFN @WIRE {#XLCTL:VREFN (-72, -30) %g5:p};
//   %g6 = $GROUND @ATTACH &VSS => @PLACE(-68, -33.2);
//   &VSS @WIRE {#XLCTL:VSS (-68, -30) %g6:p};
//   #XDH @PLACE(-34, 24);
//   #XDH @ORIENT("R0");
//   #XDH:HIB @TEXT("${net}", key="netname", size=0.6, halign="end", valign="middle", dx=-0.4, dy=0);
//   #XDH:EN @TEXT("${net}", key="netname", size=0.6, halign="end", valign="middle", dx=-0.4, dy=0);
//   #XDH:ENB @TEXT("${net}", key="netname", size=0.6, halign="end", valign="middle", dx=-0.4, dy=0);
//   #XDH:BP @TEXT("${net}", key="netname", size=0.6, halign="start", valign="middle", dx=0.4, dy=0);
//   %v7 = $SUPPLY @ATTACH &VREFP => @PLACE(-36, 32.2);
//   &VREFP @WIRE {#XDH:VREFP (-36, 29) %v7:p};
//   %g8 = $GROUND @ATTACH &VREFN => @PLACE(-36, 15.8);
//   &VREFN @WIRE {#XDH:VREFN (-36, 19) %g8:p};
//   %g9 = $GROUND @ATTACH &VSS => @PLACE(-32, 15.8);
//   &VSS @WIRE {#XDH:VSS (-32, 19) %g9:p};
//   %v10 = $SUPPLY @ATTACH &DVDD => @PLACE(-32, 32.2);
//   &DVDD @WIRE {#XDH:DVDD (-32, 29) %v10:p};
//   #CH @PLACE(14, 24) => @ORIENT("R270");
//   #CH:1 @TEXT("${net}", key="netname", size=0.6, halign="start", valign="middle", dx=0.4, dy=0);
//   #CH:2 @TEXT("${net}", key="netname", size=0.6, halign="end", valign="middle", dx=-0.4, dy=0);
//   #CPH @PLACE(60, 20);
//   #CPH @ORIENT("R0");
//   #CPH:1 @TEXT("${net}", key="netname", size=0.6, halign="start", valign="middle", rotate=90, dx=0, dy=0.4);
//   %g11 = $GROUND @ATTACH &VSS => @PLACE(60, 14.8);
//   &VSS @WIRE {#CPH:2 (60, 18) %g11:p};
//   #MSH @PLACE(2, 8);
//   #MSH @ORIENT("R0");
//   #MSH:1 @TEXT("${net}", key="netname", size=0.6, halign="start", valign="middle", rotate=90, dx=0, dy=0.4);
//   #MSH:2 @TEXT("${net}", key="netname", size=0.6, halign="end", valign="middle", dx=-0.4, dy=0);
//   #MSH:3 @TEXT("${net}", key="netname", size=0.6, halign="end", valign="middle", rotate=90, dx=0, dy=-0.4);
//   %g12 = $GROUND @ATTACH &VSS => @PLACE(5, 4.8);
//   &VSS @WIRE {#MSH:4 (5, 8) %g12:p};
//   #XDL @PLACE(-34, -26);
//   #XDL @ORIENT("R0");
//   #XDL:HIB @TEXT("${net}", key="netname", size=0.6, halign="end", valign="middle", dx=-0.4, dy=0);
//   #XDL:EN @TEXT("${net}", key="netname", size=0.6, halign="end", valign="middle", dx=-0.4, dy=0);
//   #XDL:ENB @TEXT("${net}", key="netname", size=0.6, halign="end", valign="middle", dx=-0.4, dy=0);
//   #XDL:BP @TEXT("${net}", key="netname", size=0.6, halign="start", valign="middle", dx=0.4, dy=0);
//   %v13 = $SUPPLY @ATTACH &VREFP => @PLACE(-36, -17.8);
//   &VREFP @WIRE {#XDL:VREFP (-36, -21) %v13:p};
//   %g14 = $GROUND @ATTACH &VREFN => @PLACE(-36, -34.2);
//   &VREFN @WIRE {#XDL:VREFN (-36, -31) %g14:p};
//   %g15 = $GROUND @ATTACH &VSS => @PLACE(-32, -34.2);
//   &VSS @WIRE {#XDL:VSS (-32, -31) %g15:p};
//   %v16 = $SUPPLY @ATTACH &DVDD => @PLACE(-32, -17.8);
//   &DVDD @WIRE {#XDL:DVDD (-32, -21) %v16:p};
//   #CL @PLACE(14, -26) => @ORIENT("R270");
//   #CL:1 @TEXT("${net}", key="netname", size=0.6, halign="start", valign="middle", dx=0.4, dy=0);
//   #CL:2 @TEXT("${net}", key="netname", size=0.6, halign="end", valign="middle", dx=-0.4, dy=0);
//   #CPL @PLACE(60, -30);
//   #CPL @ORIENT("R0");
//   #CPL:1 @TEXT("${net}", key="netname", size=0.6, halign="start", valign="middle", rotate=90, dx=0, dy=0.4);
//   %g17 = $GROUND @ATTACH &VSS => @PLACE(60, -35.2);
//   &VSS @WIRE {#CPL:2 (60, -32) %g17:p};
//   #MSL @PLACE(2, -42);
//   #MSL @ORIENT("R0");
//   #MSL:1 @TEXT("${net}", key="netname", size=0.6, halign="start", valign="middle", rotate=90, dx=0, dy=0.4);
//   #MSL:2 @TEXT("${net}", key="netname", size=0.6, halign="end", valign="middle", dx=-0.4, dy=0);
//   #MSL:3 @TEXT("${net}", key="netname", size=0.6, halign="end", valign="middle", rotate=90, dx=0, dy=-0.4);
//   %g18 = $GROUND @ATTACH &VSS => @PLACE(5, -45.2);
//   &VSS @WIRE {#MSL:4 (5, -42) %g18:p};
//   #MEQ1 @PLACE(-12, 0);
//   #MEQ1 @ORIENT("R0");
//   #MEQ1:1 @TEXT("${net}", key="netname", size=0.6, halign="end", valign="middle", rotate=90, dx=0, dy=-0.4);
//   #MEQ1:2 @TEXT("${net}", key="netname", size=0.6, halign="end", valign="middle", dx=-0.4, dy=0);
//   #MEQ1:3 @TEXT("${net}", key="netname", size=0.6, halign="start", valign="middle", rotate=90, dx=0, dy=0.4);
//   %v19 = $SUPPLY @ATTACH &VREFP => @PLACE(-9, 3.2);
//   &VREFP @WIRE {#MEQ1:4 (-9, 0) %v19:p};
//   #MEQ2 @PLACE(-12, -50);
//   #MEQ2 @ORIENT("R0");
//   #MEQ2:1 @TEXT("${net}", key="netname", size=0.6, halign="end", valign="middle", rotate=90, dx=0, dy=-0.4);
//   #MEQ2:2 @TEXT("${net}", key="netname", size=0.6, halign="end", valign="middle", dx=-0.4, dy=0);
//   #MEQ2:3 @TEXT("${net}", key="netname", size=0.6, halign="start", valign="middle", rotate=90, dx=0, dy=0.4);
//   %v20 = $SUPPLY @ATTACH &VREFP => @PLACE(-9, -46.8);
//   &VREFP @WIRE {#MEQ2:4 (-9, -50) %v20:p};
//   #MSHAREH @PLACE(56, -2);
//   #MSHAREH @ORIENT("R0");
//   #MSHAREH:1 @TEXT("${net}", key="netname", size=0.6, halign="start", valign="middle", rotate=90, dx=0, dy=0.4);
//   #MSHAREH:2 @TEXT("${net}", key="netname", size=0.6, halign="end", valign="middle", dx=-0.4, dy=0);
//   #MSHAREH:3 @TEXT("${net}", key="netname", size=0.6, halign="end", valign="middle", rotate=90, dx=0, dy=-0.4);
//   %g21 = $GROUND @ATTACH &VSS => @PLACE(59, -5.2);
//   &VSS @WIRE {#MSHAREH:4 (59, -2) %g21:p};
//   #MSHAREL @PLACE(56, -52);
//   #MSHAREL @ORIENT("R0");
//   #MSHAREL:1 @TEXT("${net}", key="netname", size=0.6, halign="start", valign="middle", rotate=90, dx=0, dy=0.4);
//   #MSHAREL:2 @TEXT("${net}", key="netname", size=0.6, halign="end", valign="middle", dx=-0.4, dy=0);
//   #MSHAREL:3 @TEXT("${net}", key="netname", size=0.6, halign="end", valign="middle", rotate=90, dx=0, dy=-0.4);
//   %g22 = $GROUND @ATTACH &VSS => @PLACE(59, -55.2);
//   &VSS @WIRE {#MSHAREL:4 (59, -52) %g22:p};
//   &HHIB @WIRE {#XHCTL:HIB (-52, 24) (-52, 26) #XDH:HIB};
//   %b_H = (-12, 24);
//   $JUNCTION @ATTACH %b_H;
//   &BH @WIRE {#XDH:BP %b_H};
//   &BH @WIRE {%b_H #CH:2};
//   &BH @WIRE {%b_H (-12, 10) #MSH:1};
//   &BH @WIRE {%b_H #MEQ1:1};
//   &LHIB @WIRE {#XLCTL:HIB (-52, -26) (-52, -24) #XDL:HIB};
//   %b_L = (-12, -26);
//   $JUNCTION @ATTACH %b_L;
//   &BL @WIRE {#XDL:BP %b_L};
//   &BL @WIRE {%b_L #CL:2};
//   &BL @WIRE {%b_L (-12, -40) #MSL:1};
//   &BL @WIRE {%b_L #MEQ2:1};
//   &VIN @WIRE {#MSH:3 (6, 6) (6, -44) #MSL:3};
//   &VG @WIRE {#MSH:2 (-5, 8) (-5, -42) #MSL:2};
//   %top_H = (44, 24);
//   $JUNCTION @ATTACH %top_H;
//   %top_L = (44, -26);
//   $JUNCTION @ATTACH %top_L;
//   &TOP @WIRE {#CH:1 %top_H};
//   &TOP @WIRE {#CL:1 %top_L};
//   &TOP @WIRE {%top_H %top_L};
//   %p_vin = $IO_PORT @ATTACH &VIN => @PLACE(2, 2) => @ORIENT("R90");
//   &VIN @WIRE {%p_vin:p #MSH:3};
//   %p_vg = $IO_PORT @ATTACH &VG => @PLACE(-5, 8) => @ORIENT("R0");
//   &VG @WIRE {%p_vg:p #MSH:2};
//   %p_dh = $IO_PORT @ATTACH &DH => @PLACE(-81, 24) => @ORIENT("R0");
//   &DH @WIRE {%p_dh:p #XHCTL:IN};
//   %p_rl = $IO_PORT @ATTACH &RL => @PLACE(-81, -26) => @ORIENT("R0");
//   &RL @WIRE {%p_rl:p #XLCTL:IN};
//   %p_en = $IO_PORT @ATTACH &EN => @PLACE(-45, 24) => @ORIENT("R0");
//   &EN @WIRE {%p_en:p #XDH:EN};
//   %p_enb = $IO_PORT @ATTACH &ENB => @PLACE(-45, 22) => @ORIENT("R0");
//   &ENB @WIRE {%p_enb:p #XDH:ENB};
//   %p_top = $IO_PORT @ATTACH &TOP => @PLACE(20, 24) => @ORIENT("MY");
//   &TOP @WIRE {%p_top:p #CH:1};
//   %p_eqbus = $IO_PORT @ATTACH &EQBUS => @PLACE(56, -8) => @ORIENT("R90");
//   &EQBUS @WIRE {%p_eqbus:p #MSHAREH:3};
//   %p_apgate = $IO_PORT @ATTACH &APGATE => @PLACE(-19, 0) => @ORIENT("R0");
//   &APGATE @WIRE {%p_apgate:p #MEQ1:2};
//   (-10, 46) @TEXT("Matched half-capacitor pair j=10") => @SET-STYLE $title_style
// }
ends mq_cdac_bit10

// Reference-rail output driver j=9
subckt mq_cdac_drv9 (HIB EN ENB BP VREFP VREFN VSS DVDD)
// DVDD prelogic: PCOND = NOR(ENB,HIB); NOFF = NAND(EN,HIB).
// Reference-powered final inverters restore GP and GN to VREFP/VREFN.
// Actual current overlap, settling and device stress require measurement.
MPA0 (AP ENB DVDD DVDD) pch_ulvt_mac w=1.47e-06 l=3e-08 nf=1
MPA1 (PCOND HIB AP DVDD) pch_ulvt_mac w=1.47e-06 l=3e-08 nf=1
MNA0 (PCOND ENB VREFN VSS) nch_ulvt_mac w=7.35e-07 l=3e-08 nf=1
MNA1 (PCOND HIB VREFN VSS) nch_ulvt_mac w=7.35e-07 l=3e-08 nf=1
MPB0 (NOFF EN DVDD DVDD) pch_ulvt_mac w=7.35e-07 l=3e-08 nf=1
MPB1 (NOFF HIB DVDD DVDD) pch_ulvt_mac w=7.35e-07 l=3e-08 nf=1
MNB0 (NOFF EN BN VSS) nch_ulvt_mac w=7.35e-07 l=3e-08 nf=1
MNB1 (BN HIB VREFN VSS) nch_ulvt_mac w=7.35e-07 l=3e-08 nf=1
MGPN (GP PCOND VREFN VSS) nch_mac w=1.47e-06 l=3e-08 nf=1
MGPP (GP PCOND VREFP VREFP) pch_mac w=2.2e-06 l=3e-08 nf=2
MGNN (GN NOFF VREFN VSS) nch_mac w=1.47e-06 l=3e-08 nf=1
MGNP (GN NOFF VREFP VREFP) pch_mac w=7.35e-07 l=3e-08 nf=1
MNOUT (BP GN VREFN VSS) nch_mac w=8.25e-06 l=3e-08 nf=6
MPOUT (BP GP VREFP VREFP) pch_mac w=1.65e-05 l=3e-08 nf=12
// @RNL {
//   /* pins connected by net name: the net-name label of rnl-std-fill on every unwired pin, placed below by its key netname */
//   $LABEL_TERMINAL_SET @TEXT("${net}", key="netname", size=0.6);
//   &VSS @ADD-TO $GROUND_NET_SET; &VREFN @ADD-TO $GROUND_NET_SET;
//   &VREFP @ADD-TO $SUPPLY_NET_SET;
//   &DVDD @ADD-TO $SUPPLY_NET_SET;
//   {#MPA0 #MPA1 #MNA0 #MNA1} @GROUP;
//   {#MPB0 #MPB1 #MNB0 #MNB1} @GROUP;
//   {#MGPN #MGPP} @GROUP;
//   {#MGNN #MGNP} @GROUP;
//   {#MNOUT #MPOUT} @GROUP;
//   #MPA0 @PLACE(12, 40);
//   #MPA0 @ORIENT("R0");
//   #MPA0:1 @TEXT("${net}", key="netname", size=0.6, halign="end", valign="middle", rotate=90, dx=0, dy=-0.4);
//   #MPA0:2 @TEXT("${net}", key="netname", size=0.6, halign="end", valign="middle", dx=-0.4, dy=0);
//   %v1 = $SUPPLY @ATTACH &DVDD => @PLACE(12, 45.2);
//   &DVDD @WIRE {#MPA0:3 (12, 42) %v1:p};
//   %v2 = $SUPPLY @ATTACH &DVDD => @PLACE(15, 43.2);
//   &DVDD @WIRE {#MPA0:4 (15, 40) %v2:p};
//   #MPA1 @PLACE(12, 26);
//   #MPA1 @ORIENT("R0");
//   #MPA1:1 @TEXT("${net}", key="netname", size=0.6, halign="end", valign="middle", rotate=90, dx=0, dy=-0.4);
//   #MPA1:2 @TEXT("${net}", key="netname", size=0.6, halign="end", valign="middle", dx=-0.4, dy=0);
//   #MPA1:3 @TEXT("${net}", key="netname", size=0.6, halign="start", valign="middle", rotate=90, dx=0, dy=0.4);
//   %v3 = $SUPPLY @ATTACH &DVDD => @PLACE(15, 29.2);
//   &DVDD @WIRE {#MPA1:4 (15, 26) %v3:p};
//   #MNA0 @PLACE(0, 2);
//   #MNA0 @ORIENT("R0");
//   #MNA0:1 @TEXT("${net}", key="netname", size=0.6, halign="start", valign="middle", rotate=90, dx=0, dy=0.4);
//   #MNA0:2 @TEXT("${net}", key="netname", size=0.6, halign="end", valign="middle", dx=-0.4, dy=0);
//   %g4 = $GROUND @ATTACH &VREFN => @PLACE(0, -3.2);
//   &VREFN @WIRE {#MNA0:3 (0, 0) %g4:p};
//   %g5 = $GROUND @ATTACH &VSS => @PLACE(3, -1.2);
//   &VSS @WIRE {#MNA0:4 (3, 2) %g5:p};
//   #MNA1 @PLACE(24, 2);
//   #MNA1 @ORIENT("R0");
//   #MNA1:1 @TEXT("${net}", key="netname", size=0.6, halign="start", valign="middle", rotate=90, dx=0, dy=0.4);
//   #MNA1:2 @TEXT("${net}", key="netname", size=0.6, halign="end", valign="middle", dx=-0.4, dy=0);
//   %g6 = $GROUND @ATTACH &VREFN => @PLACE(24, -3.2);
//   &VREFN @WIRE {#MNA1:3 (24, 0) %g6:p};
//   %g7 = $GROUND @ATTACH &VSS => @PLACE(27, -1.2);
//   &VSS @WIRE {#MNA1:4 (27, 2) %g7:p};
//   #MPB0 @PLACE(96, 30);
//   #MPB0 @ORIENT("R0");
//   #MPB0:1 @TEXT("${net}", key="netname", size=0.6, halign="end", valign="middle", rotate=90, dx=0, dy=-0.4);
//   #MPB0:2 @TEXT("${net}", key="netname", size=0.6, halign="end", valign="middle", dx=-0.4, dy=0);
//   %v8 = $SUPPLY @ATTACH &DVDD => @PLACE(96, 35.2);
//   &DVDD @WIRE {#MPB0:3 (96, 32) %v8:p};
//   %v9 = $SUPPLY @ATTACH &DVDD => @PLACE(99, 33.2);
//   &DVDD @WIRE {#MPB0:4 (99, 30) %v9:p};
//   #MPB1 @PLACE(120, 30);
//   #MPB1 @ORIENT("R0");
//   #MPB1:1 @TEXT("${net}", key="netname", size=0.6, halign="end", valign="middle", rotate=90, dx=0, dy=-0.4);
//   #MPB1:2 @TEXT("${net}", key="netname", size=0.6, halign="end", valign="middle", dx=-0.4, dy=0);
//   %v10 = $SUPPLY @ATTACH &DVDD => @PLACE(120, 35.2);
//   &DVDD @WIRE {#MPB1:3 (120, 32) %v10:p};
//   %v11 = $SUPPLY @ATTACH &DVDD => @PLACE(123, 33.2);
//   &DVDD @WIRE {#MPB1:4 (123, 30) %v11:p};
//   #MNB0 @PLACE(108, 12);
//   #MNB0 @ORIENT("R0");
//   #MNB0:1 @TEXT("${net}", key="netname", size=0.6, halign="start", valign="middle", rotate=90, dx=0, dy=0.4);
//   #MNB0:2 @TEXT("${net}", key="netname", size=0.6, halign="end", valign="middle", dx=-0.4, dy=0);
//   #MNB0:3 @TEXT("${net}", key="netname", size=0.6, halign="end", valign="middle", rotate=90, dx=0, dy=-0.4);
//   %g12 = $GROUND @ATTACH &VSS => @PLACE(111, 8.8);
//   &VSS @WIRE {#MNB0:4 (111, 12) %g12:p};
//   #MNB1 @PLACE(108, -2);
//   #MNB1 @ORIENT("R0");
//   #MNB1:1 @TEXT("${net}", key="netname", size=0.6, halign="start", valign="middle", rotate=90, dx=0, dy=0.4);
//   #MNB1:2 @TEXT("${net}", key="netname", size=0.6, halign="end", valign="middle", dx=-0.4, dy=0);
//   %g13 = $GROUND @ATTACH &VREFN => @PLACE(108, -7.2);
//   &VREFN @WIRE {#MNB1:3 (108, -4) %g13:p};
//   %g14 = $GROUND @ATTACH &VSS => @PLACE(111, -5.2);
//   &VSS @WIRE {#MNB1:4 (111, -2) %g14:p};
//   #MGPN @PLACE(64, 2);
//   #MGPN @ORIENT("R0");
//   #MGPN:1 @TEXT("${net}", key="netname", size=0.6, halign="start", valign="middle", rotate=90, dx=0, dy=0.4);
//   #MGPN:2 @TEXT("${net}", key="netname", size=0.6, halign="end", valign="middle", dx=-0.4, dy=0);
//   %g15 = $GROUND @ATTACH &VREFN => @PLACE(64, -3.2);
//   &VREFN @WIRE {#MGPN:3 (64, 0) %g15:p};
//   %g16 = $GROUND @ATTACH &VSS => @PLACE(67, -1.2);
//   &VSS @WIRE {#MGPN:4 (67, 2) %g16:p};
//   #MGPP @PLACE(64, 12);
//   #MGPP @ORIENT("R0");
//   #MGPP:1 @TEXT("${net}", key="netname", size=0.6, halign="end", valign="middle", rotate=90, dx=0, dy=-0.4);
//   #MGPP:2 @TEXT("${net}", key="netname", size=0.6, halign="end", valign="middle", dx=-0.4, dy=0);
//   %v17 = $SUPPLY @ATTACH &VREFP => @PLACE(64, 17.2);
//   &VREFP @WIRE {#MGPP:3 (64, 14) %v17:p};
//   %v18 = $SUPPLY @ATTACH &VREFP => @PLACE(67, 15.2);
//   &VREFP @WIRE {#MGPP:4 (67, 12) %v18:p};
//   #MGNN @PLACE(160, 2);
//   #MGNN @ORIENT("R0");
//   #MGNN:1 @TEXT("${net}", key="netname", size=0.6, halign="start", valign="middle", rotate=90, dx=0, dy=0.4);
//   #MGNN:2 @TEXT("${net}", key="netname", size=0.6, halign="end", valign="middle", dx=-0.4, dy=0);
//   %g19 = $GROUND @ATTACH &VREFN => @PLACE(160, -3.2);
//   &VREFN @WIRE {#MGNN:3 (160, 0) %g19:p};
//   %g20 = $GROUND @ATTACH &VSS => @PLACE(163, -1.2);
//   &VSS @WIRE {#MGNN:4 (163, 2) %g20:p};
//   #MGNP @PLACE(160, 12);
//   #MGNP @ORIENT("R0");
//   #MGNP:1 @TEXT("${net}", key="netname", size=0.6, halign="end", valign="middle", rotate=90, dx=0, dy=-0.4);
//   #MGNP:2 @TEXT("${net}", key="netname", size=0.6, halign="end", valign="middle", dx=-0.4, dy=0);
//   %v21 = $SUPPLY @ATTACH &VREFP => @PLACE(160, 17.2);
//   &VREFP @WIRE {#MGNP:3 (160, 14) %v21:p};
//   %v22 = $SUPPLY @ATTACH &VREFP => @PLACE(163, 15.2);
//   &VREFP @WIRE {#MGNP:4 (163, 12) %v22:p};
//   #MNOUT @PLACE(200, 0);
//   #MNOUT @ORIENT("R0");
//   #MNOUT:1 @TEXT("${net}", key="netname", size=0.6, halign="start", valign="middle", rotate=90, dx=0, dy=0.4);
//   #MNOUT:2 @TEXT("${net}", key="netname", size=0.6, halign="end", valign="middle", dx=-0.4, dy=0);
//   %g23 = $GROUND @ATTACH &VREFN => @PLACE(200, -5.2);
//   &VREFN @WIRE {#MNOUT:3 (200, -2) %g23:p};
//   %g24 = $GROUND @ATTACH &VSS => @PLACE(203, -3.2);
//   &VSS @WIRE {#MNOUT:4 (203, 0) %g24:p};
//   #MPOUT @PLACE(200, 22);
//   #MPOUT @ORIENT("R0");
//   #MPOUT:1 @TEXT("${net}", key="netname", size=0.6, halign="end", valign="middle", rotate=90, dx=0, dy=-0.4);
//   #MPOUT:2 @TEXT("${net}", key="netname", size=0.6, halign="end", valign="middle", dx=-0.4, dy=0);
//   %v25 = $SUPPLY @ATTACH &VREFP => @PLACE(200, 27.2);
//   &VREFP @WIRE {#MPOUT:3 (200, 24) %v25:p};
//   %v26 = $SUPPLY @ATTACH &VREFP => @PLACE(203, 25.2);
//   &VREFP @WIRE {#MPOUT:4 (203, 22) %v26:p};
//   &GP @WIRE {#MGPN:1 #MGPP:1};
//   &PCOND @WIRE {#MGPN:2 (59, 2) (59, 12) #MGPP:2};
//   &GN @WIRE {#MGNN:1 #MGNP:1};
//   &NOFF @WIRE {#MGNN:2 (155, 2) (155, 12) #MGNP:2};
//   &AP @WIRE {#MPA0:1 #MPA1:3};
//   %pc_bus = (12, 16);
//   $JUNCTION @ATTACH %pc_bus;
//   &PCOND @WIRE {#MNA0:1 (0, 16) %pc_bus (24, 16) #MNA1:1};
//   &PCOND @WIRE {#MPA1:1 %pc_bus};
//   %pc_gate = (59, 7);
//   $JUNCTION @ATTACH %pc_gate;
//   &PCOND @WIRE {%pc_bus (50, 16) (50, 7) %pc_gate};
//   &BN @WIRE {#MNB0:3 #MNB1:1};
//   %no_bus = (108, 22);
//   $JUNCTION @ATTACH %no_bus;
//   &NOFF @WIRE {#MPB0:1 (96, 22) %no_bus (120, 22) #MPB1:1};
//   &NOFF @WIRE {#MNB0:1 %no_bus};
//   %no_gate = (155, 7);
//   $JUNCTION @ATTACH %no_gate;
//   &NOFF @WIRE {%no_bus (146, 22) (146, 7) %no_gate};
//   &BP @WIRE {#MNOUT:1 #MPOUT:1};
//   &GP @WIRE {#MGPN:1 (74, 4) (74, 52) (190, 52) (190, 22) #MPOUT:2};
//   &GN @WIRE {#MGNN:1 (180, 4) (180, 0) #MNOUT:2};
//   %p_hib = $IO_PORT @ATTACH &HIB => @PLACE(5, 26) => @ORIENT("R0");
//   &HIB @WIRE {%p_hib:p #MPA1:2};
//   %p_en = $IO_PORT @ATTACH &EN => @PLACE(89, 30) => @ORIENT("R0");
//   &EN @WIRE {%p_en:p #MPB0:2};
//   %p_enb = $IO_PORT @ATTACH &ENB => @PLACE(5, 40) => @ORIENT("R0");
//   &ENB @WIRE {%p_enb:p #MPA0:2};
//   %p_bp = $IO_PORT @ATTACH &BP => @PLACE(200, 6) => @ORIENT("R270");
//   &BP @WIRE {%p_bp:p #MNOUT:1};
//   (-10, 62) @TEXT("Reference-rail output driver j=9") => @SET-STYLE $title_style
// }
ends mq_cdac_drv9

// Matched half-capacitor pair j=9
subckt mq_cdac_bit9 (DH RL EN ENB TOP VREFP VREFN VSS DVDD)
// CP*: user-specified 5% bottom-plate estimate for every physical MOM unit, not extraction.
// Series tails retain one unit parasitic at MID and one at B.
XHCTL (DH HHIB DVDD VREFN VSS) mq_cdac_ctl_h
XLCTL (RL LHIB DVDD VREFN VSS) mq_cdac_ctl_l
XDH (HHIB EN ENB BH VREFP VREFN VSS DVDD) mq_cdac_drv9
CH (TOP BH) cfmom_2t w=5e-08 s=2.4e-07 nr=6 lr=1.69e-06 stm=2 spm=4 multi=90
CPH (BH VSS) capacitor c=4.5103050e-15
XDL (LHIB EN ENB BL VREFP VREFN VSS DVDD) mq_cdac_drv9
CL (TOP BL) cfmom_2t w=5e-08 s=2.4e-07 nr=6 lr=1.69e-06 stm=2 spm=4 multi=90
CPL (BL VSS) capacitor c=4.5103050e-15
// @RNL {
//   /* pins connected by net name: the net-name label of rnl-std-fill on every unwired pin, placed below by its key netname */
//   $LABEL_TERMINAL_SET @TEXT("${net}", key="netname", size=0.6);
//   &VSS @ADD-TO $GROUND_NET_SET; &VREFN @ADD-TO $GROUND_NET_SET;
//   &VREFP @ADD-TO $SUPPLY_NET_SET;
//   &DVDD @ADD-TO $SUPPLY_NET_SET;
//   {#CH #CL} @AS $MATCHED;
//   {#XDH #XDL} @AS $MATCHED;
//   #XHCTL @PLACE(-70, 24);
//   #XHCTL @ORIENT("R0");
//   #XHCTL:IN @TEXT("${net}", key="netname", size=0.6, halign="end", valign="middle", dx=-0.4, dy=0);
//   #XHCTL:HIB @TEXT("${net}", key="netname", size=0.6, halign="start", valign="middle", dx=0.4, dy=0);
//   %v1 = $SUPPLY @ATTACH &DVDD => @PLACE(-70, 31.2);
//   &DVDD @WIRE {#XHCTL:DVDD (-70, 28) %v1:p};
//   %g2 = $GROUND @ATTACH &VREFN => @PLACE(-72, 16.8);
//   &VREFN @WIRE {#XHCTL:VREFN (-72, 20) %g2:p};
//   %g3 = $GROUND @ATTACH &VSS => @PLACE(-68, 16.8);
//   &VSS @WIRE {#XHCTL:VSS (-68, 20) %g3:p};
//   #XLCTL @PLACE(-70, -26);
//   #XLCTL @ORIENT("R0");
//   #XLCTL:IN @TEXT("${net}", key="netname", size=0.6, halign="end", valign="middle", dx=-0.4, dy=0);
//   #XLCTL:HIB @TEXT("${net}", key="netname", size=0.6, halign="start", valign="middle", dx=0.4, dy=0);
//   %v4 = $SUPPLY @ATTACH &DVDD => @PLACE(-70, -18.8);
//   &DVDD @WIRE {#XLCTL:DVDD (-70, -22) %v4:p};
//   %g5 = $GROUND @ATTACH &VREFN => @PLACE(-72, -33.2);
//   &VREFN @WIRE {#XLCTL:VREFN (-72, -30) %g5:p};
//   %g6 = $GROUND @ATTACH &VSS => @PLACE(-68, -33.2);
//   &VSS @WIRE {#XLCTL:VSS (-68, -30) %g6:p};
//   #XDH @PLACE(-34, 24);
//   #XDH @ORIENT("R0");
//   #XDH:HIB @TEXT("${net}", key="netname", size=0.6, halign="end", valign="middle", dx=-0.4, dy=0);
//   #XDH:EN @TEXT("${net}", key="netname", size=0.6, halign="end", valign="middle", dx=-0.4, dy=0);
//   #XDH:ENB @TEXT("${net}", key="netname", size=0.6, halign="end", valign="middle", dx=-0.4, dy=0);
//   #XDH:BP @TEXT("${net}", key="netname", size=0.6, halign="start", valign="middle", dx=0.4, dy=0);
//   %v7 = $SUPPLY @ATTACH &VREFP => @PLACE(-36, 32.2);
//   &VREFP @WIRE {#XDH:VREFP (-36, 29) %v7:p};
//   %g8 = $GROUND @ATTACH &VREFN => @PLACE(-36, 15.8);
//   &VREFN @WIRE {#XDH:VREFN (-36, 19) %g8:p};
//   %g9 = $GROUND @ATTACH &VSS => @PLACE(-32, 15.8);
//   &VSS @WIRE {#XDH:VSS (-32, 19) %g9:p};
//   %v10 = $SUPPLY @ATTACH &DVDD => @PLACE(-32, 32.2);
//   &DVDD @WIRE {#XDH:DVDD (-32, 29) %v10:p};
//   #CH @PLACE(14, 24) => @ORIENT("R270");
//   #CH:1 @TEXT("${net}", key="netname", size=0.6, halign="start", valign="middle", dx=0.4, dy=0);
//   #CH:2 @TEXT("${net}", key="netname", size=0.6, halign="end", valign="middle", dx=-0.4, dy=0);
//   #CPH @PLACE(60, 20);
//   #CPH @ORIENT("R0");
//   #CPH:1 @TEXT("${net}", key="netname", size=0.6, halign="start", valign="middle", rotate=90, dx=0, dy=0.4);
//   %g11 = $GROUND @ATTACH &VSS => @PLACE(60, 14.8);
//   &VSS @WIRE {#CPH:2 (60, 18) %g11:p};
//   #XDL @PLACE(-34, -26);
//   #XDL @ORIENT("R0");
//   #XDL:HIB @TEXT("${net}", key="netname", size=0.6, halign="end", valign="middle", dx=-0.4, dy=0);
//   #XDL:EN @TEXT("${net}", key="netname", size=0.6, halign="end", valign="middle", dx=-0.4, dy=0);
//   #XDL:ENB @TEXT("${net}", key="netname", size=0.6, halign="end", valign="middle", dx=-0.4, dy=0);
//   #XDL:BP @TEXT("${net}", key="netname", size=0.6, halign="start", valign="middle", dx=0.4, dy=0);
//   %v12 = $SUPPLY @ATTACH &VREFP => @PLACE(-36, -17.8);
//   &VREFP @WIRE {#XDL:VREFP (-36, -21) %v12:p};
//   %g13 = $GROUND @ATTACH &VREFN => @PLACE(-36, -34.2);
//   &VREFN @WIRE {#XDL:VREFN (-36, -31) %g13:p};
//   %g14 = $GROUND @ATTACH &VSS => @PLACE(-32, -34.2);
//   &VSS @WIRE {#XDL:VSS (-32, -31) %g14:p};
//   %v15 = $SUPPLY @ATTACH &DVDD => @PLACE(-32, -17.8);
//   &DVDD @WIRE {#XDL:DVDD (-32, -21) %v15:p};
//   #CL @PLACE(14, -26) => @ORIENT("R270");
//   #CL:1 @TEXT("${net}", key="netname", size=0.6, halign="start", valign="middle", dx=0.4, dy=0);
//   #CL:2 @TEXT("${net}", key="netname", size=0.6, halign="end", valign="middle", dx=-0.4, dy=0);
//   #CPL @PLACE(60, -30);
//   #CPL @ORIENT("R0");
//   #CPL:1 @TEXT("${net}", key="netname", size=0.6, halign="start", valign="middle", rotate=90, dx=0, dy=0.4);
//   %g16 = $GROUND @ATTACH &VSS => @PLACE(60, -35.2);
//   &VSS @WIRE {#CPL:2 (60, -32) %g16:p};
//   &HHIB @WIRE {#XHCTL:HIB (-52, 24) (-52, 26) #XDH:HIB};
//   %b_H = (-12, 24);
//   $JUNCTION @ATTACH %b_H;
//   &BH @WIRE {#XDH:BP %b_H};
//   &BH @WIRE {%b_H #CH:2};
//   &LHIB @WIRE {#XLCTL:HIB (-52, -26) (-52, -24) #XDL:HIB};
//   %b_L = (-12, -26);
//   $JUNCTION @ATTACH %b_L;
//   &BL @WIRE {#XDL:BP %b_L};
//   &BL @WIRE {%b_L #CL:2};
//   %top_H = (44, 24);
//   $JUNCTION @ATTACH %top_H;
//   %top_L = (44, -26);
//   $JUNCTION @ATTACH %top_L;
//   &TOP @WIRE {#CH:1 %top_H};
//   &TOP @WIRE {#CL:1 %top_L};
//   &TOP @WIRE {%top_H %top_L};
//   %p_dh = $IO_PORT @ATTACH &DH => @PLACE(-81, 24) => @ORIENT("R0");
//   &DH @WIRE {%p_dh:p #XHCTL:IN};
//   %p_rl = $IO_PORT @ATTACH &RL => @PLACE(-81, -26) => @ORIENT("R0");
//   &RL @WIRE {%p_rl:p #XLCTL:IN};
//   %p_en = $IO_PORT @ATTACH &EN => @PLACE(-45, 24) => @ORIENT("R0");
//   &EN @WIRE {%p_en:p #XDH:EN};
//   %p_enb = $IO_PORT @ATTACH &ENB => @PLACE(-45, 22) => @ORIENT("R0");
//   &ENB @WIRE {%p_enb:p #XDH:ENB};
//   %p_top = $IO_PORT @ATTACH &TOP => @PLACE(20, 24) => @ORIENT("MY");
//   &TOP @WIRE {%p_top:p #CH:1};
//   (-10, 46) @TEXT("Matched half-capacitor pair j=9") => @SET-STYLE $title_style
// }
ends mq_cdac_bit9

// Reference-rail output driver j=8
subckt mq_cdac_drv8 (HIB EN ENB BP VREFP VREFN VSS DVDD)
// DVDD prelogic: PCOND = NOR(ENB,HIB); NOFF = NAND(EN,HIB).
// Reference-powered final inverters restore GP and GN to VREFP/VREFN.
// Actual current overlap, settling and device stress require measurement.
MPA0 (AP ENB DVDD DVDD) pch_ulvt_mac w=8.35e-07 l=3e-08 nf=1
MPA1 (PCOND HIB AP DVDD) pch_ulvt_mac w=8.35e-07 l=3e-08 nf=1
MNA0 (PCOND ENB VREFN VSS) nch_ulvt_mac w=4.15e-07 l=3e-08 nf=1
MNA1 (PCOND HIB VREFN VSS) nch_ulvt_mac w=4.15e-07 l=3e-08 nf=1
MPB0 (NOFF EN DVDD DVDD) pch_ulvt_mac w=4.15e-07 l=3e-08 nf=1
MPB1 (NOFF HIB DVDD DVDD) pch_ulvt_mac w=4.15e-07 l=3e-08 nf=1
MNB0 (NOFF EN BN VSS) nch_ulvt_mac w=4.15e-07 l=3e-08 nf=1
MNB1 (BN HIB VREFN VSS) nch_ulvt_mac w=4.15e-07 l=3e-08 nf=1
MGPN (GP PCOND VREFN VSS) nch_mac w=8.35e-07 l=3e-08 nf=1
MGPP (GP PCOND VREFP VREFP) pch_mac w=1.25e-06 l=3e-08 nf=1
MGNN (GN NOFF VREFN VSS) nch_mac w=8.35e-07 l=3e-08 nf=1
MGNP (GN NOFF VREFP VREFP) pch_mac w=4.15e-07 l=3e-08 nf=1
MNOUT (BP GN VREFN VSS) nch_mac w=1.56e-06 l=3e-08 nf=2
MPOUT (BP GP VREFP VREFP) pch_mac w=3.12e-06 l=3e-08 nf=3
// @RNL {
//   /* pins connected by net name: the net-name label of rnl-std-fill on every unwired pin, placed below by its key netname */
//   $LABEL_TERMINAL_SET @TEXT("${net}", key="netname", size=0.6);
//   &VSS @ADD-TO $GROUND_NET_SET; &VREFN @ADD-TO $GROUND_NET_SET;
//   &VREFP @ADD-TO $SUPPLY_NET_SET;
//   &DVDD @ADD-TO $SUPPLY_NET_SET;
//   {#MPA0 #MPA1 #MNA0 #MNA1} @GROUP;
//   {#MPB0 #MPB1 #MNB0 #MNB1} @GROUP;
//   {#MGPN #MGPP} @GROUP;
//   {#MGNN #MGNP} @GROUP;
//   {#MNOUT #MPOUT} @GROUP;
//   #MPA0 @PLACE(12, 40);
//   #MPA0 @ORIENT("R0");
//   #MPA0:1 @TEXT("${net}", key="netname", size=0.6, halign="end", valign="middle", rotate=90, dx=0, dy=-0.4);
//   #MPA0:2 @TEXT("${net}", key="netname", size=0.6, halign="end", valign="middle", dx=-0.4, dy=0);
//   %v1 = $SUPPLY @ATTACH &DVDD => @PLACE(12, 45.2);
//   &DVDD @WIRE {#MPA0:3 (12, 42) %v1:p};
//   %v2 = $SUPPLY @ATTACH &DVDD => @PLACE(15, 43.2);
//   &DVDD @WIRE {#MPA0:4 (15, 40) %v2:p};
//   #MPA1 @PLACE(12, 26);
//   #MPA1 @ORIENT("R0");
//   #MPA1:1 @TEXT("${net}", key="netname", size=0.6, halign="end", valign="middle", rotate=90, dx=0, dy=-0.4);
//   #MPA1:2 @TEXT("${net}", key="netname", size=0.6, halign="end", valign="middle", dx=-0.4, dy=0);
//   #MPA1:3 @TEXT("${net}", key="netname", size=0.6, halign="start", valign="middle", rotate=90, dx=0, dy=0.4);
//   %v3 = $SUPPLY @ATTACH &DVDD => @PLACE(15, 29.2);
//   &DVDD @WIRE {#MPA1:4 (15, 26) %v3:p};
//   #MNA0 @PLACE(0, 2);
//   #MNA0 @ORIENT("R0");
//   #MNA0:1 @TEXT("${net}", key="netname", size=0.6, halign="start", valign="middle", rotate=90, dx=0, dy=0.4);
//   #MNA0:2 @TEXT("${net}", key="netname", size=0.6, halign="end", valign="middle", dx=-0.4, dy=0);
//   %g4 = $GROUND @ATTACH &VREFN => @PLACE(0, -3.2);
//   &VREFN @WIRE {#MNA0:3 (0, 0) %g4:p};
//   %g5 = $GROUND @ATTACH &VSS => @PLACE(3, -1.2);
//   &VSS @WIRE {#MNA0:4 (3, 2) %g5:p};
//   #MNA1 @PLACE(24, 2);
//   #MNA1 @ORIENT("R0");
//   #MNA1:1 @TEXT("${net}", key="netname", size=0.6, halign="start", valign="middle", rotate=90, dx=0, dy=0.4);
//   #MNA1:2 @TEXT("${net}", key="netname", size=0.6, halign="end", valign="middle", dx=-0.4, dy=0);
//   %g6 = $GROUND @ATTACH &VREFN => @PLACE(24, -3.2);
//   &VREFN @WIRE {#MNA1:3 (24, 0) %g6:p};
//   %g7 = $GROUND @ATTACH &VSS => @PLACE(27, -1.2);
//   &VSS @WIRE {#MNA1:4 (27, 2) %g7:p};
//   #MPB0 @PLACE(96, 30);
//   #MPB0 @ORIENT("R0");
//   #MPB0:1 @TEXT("${net}", key="netname", size=0.6, halign="end", valign="middle", rotate=90, dx=0, dy=-0.4);
//   #MPB0:2 @TEXT("${net}", key="netname", size=0.6, halign="end", valign="middle", dx=-0.4, dy=0);
//   %v8 = $SUPPLY @ATTACH &DVDD => @PLACE(96, 35.2);
//   &DVDD @WIRE {#MPB0:3 (96, 32) %v8:p};
//   %v9 = $SUPPLY @ATTACH &DVDD => @PLACE(99, 33.2);
//   &DVDD @WIRE {#MPB0:4 (99, 30) %v9:p};
//   #MPB1 @PLACE(120, 30);
//   #MPB1 @ORIENT("R0");
//   #MPB1:1 @TEXT("${net}", key="netname", size=0.6, halign="end", valign="middle", rotate=90, dx=0, dy=-0.4);
//   #MPB1:2 @TEXT("${net}", key="netname", size=0.6, halign="end", valign="middle", dx=-0.4, dy=0);
//   %v10 = $SUPPLY @ATTACH &DVDD => @PLACE(120, 35.2);
//   &DVDD @WIRE {#MPB1:3 (120, 32) %v10:p};
//   %v11 = $SUPPLY @ATTACH &DVDD => @PLACE(123, 33.2);
//   &DVDD @WIRE {#MPB1:4 (123, 30) %v11:p};
//   #MNB0 @PLACE(108, 12);
//   #MNB0 @ORIENT("R0");
//   #MNB0:1 @TEXT("${net}", key="netname", size=0.6, halign="start", valign="middle", rotate=90, dx=0, dy=0.4);
//   #MNB0:2 @TEXT("${net}", key="netname", size=0.6, halign="end", valign="middle", dx=-0.4, dy=0);
//   #MNB0:3 @TEXT("${net}", key="netname", size=0.6, halign="end", valign="middle", rotate=90, dx=0, dy=-0.4);
//   %g12 = $GROUND @ATTACH &VSS => @PLACE(111, 8.8);
//   &VSS @WIRE {#MNB0:4 (111, 12) %g12:p};
//   #MNB1 @PLACE(108, -2);
//   #MNB1 @ORIENT("R0");
//   #MNB1:1 @TEXT("${net}", key="netname", size=0.6, halign="start", valign="middle", rotate=90, dx=0, dy=0.4);
//   #MNB1:2 @TEXT("${net}", key="netname", size=0.6, halign="end", valign="middle", dx=-0.4, dy=0);
//   %g13 = $GROUND @ATTACH &VREFN => @PLACE(108, -7.2);
//   &VREFN @WIRE {#MNB1:3 (108, -4) %g13:p};
//   %g14 = $GROUND @ATTACH &VSS => @PLACE(111, -5.2);
//   &VSS @WIRE {#MNB1:4 (111, -2) %g14:p};
//   #MGPN @PLACE(64, 2);
//   #MGPN @ORIENT("R0");
//   #MGPN:1 @TEXT("${net}", key="netname", size=0.6, halign="start", valign="middle", rotate=90, dx=0, dy=0.4);
//   #MGPN:2 @TEXT("${net}", key="netname", size=0.6, halign="end", valign="middle", dx=-0.4, dy=0);
//   %g15 = $GROUND @ATTACH &VREFN => @PLACE(64, -3.2);
//   &VREFN @WIRE {#MGPN:3 (64, 0) %g15:p};
//   %g16 = $GROUND @ATTACH &VSS => @PLACE(67, -1.2);
//   &VSS @WIRE {#MGPN:4 (67, 2) %g16:p};
//   #MGPP @PLACE(64, 12);
//   #MGPP @ORIENT("R0");
//   #MGPP:1 @TEXT("${net}", key="netname", size=0.6, halign="end", valign="middle", rotate=90, dx=0, dy=-0.4);
//   #MGPP:2 @TEXT("${net}", key="netname", size=0.6, halign="end", valign="middle", dx=-0.4, dy=0);
//   %v17 = $SUPPLY @ATTACH &VREFP => @PLACE(64, 17.2);
//   &VREFP @WIRE {#MGPP:3 (64, 14) %v17:p};
//   %v18 = $SUPPLY @ATTACH &VREFP => @PLACE(67, 15.2);
//   &VREFP @WIRE {#MGPP:4 (67, 12) %v18:p};
//   #MGNN @PLACE(160, 2);
//   #MGNN @ORIENT("R0");
//   #MGNN:1 @TEXT("${net}", key="netname", size=0.6, halign="start", valign="middle", rotate=90, dx=0, dy=0.4);
//   #MGNN:2 @TEXT("${net}", key="netname", size=0.6, halign="end", valign="middle", dx=-0.4, dy=0);
//   %g19 = $GROUND @ATTACH &VREFN => @PLACE(160, -3.2);
//   &VREFN @WIRE {#MGNN:3 (160, 0) %g19:p};
//   %g20 = $GROUND @ATTACH &VSS => @PLACE(163, -1.2);
//   &VSS @WIRE {#MGNN:4 (163, 2) %g20:p};
//   #MGNP @PLACE(160, 12);
//   #MGNP @ORIENT("R0");
//   #MGNP:1 @TEXT("${net}", key="netname", size=0.6, halign="end", valign="middle", rotate=90, dx=0, dy=-0.4);
//   #MGNP:2 @TEXT("${net}", key="netname", size=0.6, halign="end", valign="middle", dx=-0.4, dy=0);
//   %v21 = $SUPPLY @ATTACH &VREFP => @PLACE(160, 17.2);
//   &VREFP @WIRE {#MGNP:3 (160, 14) %v21:p};
//   %v22 = $SUPPLY @ATTACH &VREFP => @PLACE(163, 15.2);
//   &VREFP @WIRE {#MGNP:4 (163, 12) %v22:p};
//   #MNOUT @PLACE(200, 0);
//   #MNOUT @ORIENT("R0");
//   #MNOUT:1 @TEXT("${net}", key="netname", size=0.6, halign="start", valign="middle", rotate=90, dx=0, dy=0.4);
//   #MNOUT:2 @TEXT("${net}", key="netname", size=0.6, halign="end", valign="middle", dx=-0.4, dy=0);
//   %g23 = $GROUND @ATTACH &VREFN => @PLACE(200, -5.2);
//   &VREFN @WIRE {#MNOUT:3 (200, -2) %g23:p};
//   %g24 = $GROUND @ATTACH &VSS => @PLACE(203, -3.2);
//   &VSS @WIRE {#MNOUT:4 (203, 0) %g24:p};
//   #MPOUT @PLACE(200, 22);
//   #MPOUT @ORIENT("R0");
//   #MPOUT:1 @TEXT("${net}", key="netname", size=0.6, halign="end", valign="middle", rotate=90, dx=0, dy=-0.4);
//   #MPOUT:2 @TEXT("${net}", key="netname", size=0.6, halign="end", valign="middle", dx=-0.4, dy=0);
//   %v25 = $SUPPLY @ATTACH &VREFP => @PLACE(200, 27.2);
//   &VREFP @WIRE {#MPOUT:3 (200, 24) %v25:p};
//   %v26 = $SUPPLY @ATTACH &VREFP => @PLACE(203, 25.2);
//   &VREFP @WIRE {#MPOUT:4 (203, 22) %v26:p};
//   &GP @WIRE {#MGPN:1 #MGPP:1};
//   &PCOND @WIRE {#MGPN:2 (59, 2) (59, 12) #MGPP:2};
//   &GN @WIRE {#MGNN:1 #MGNP:1};
//   &NOFF @WIRE {#MGNN:2 (155, 2) (155, 12) #MGNP:2};
//   &AP @WIRE {#MPA0:1 #MPA1:3};
//   %pc_bus = (12, 16);
//   $JUNCTION @ATTACH %pc_bus;
//   &PCOND @WIRE {#MNA0:1 (0, 16) %pc_bus (24, 16) #MNA1:1};
//   &PCOND @WIRE {#MPA1:1 %pc_bus};
//   %pc_gate = (59, 7);
//   $JUNCTION @ATTACH %pc_gate;
//   &PCOND @WIRE {%pc_bus (50, 16) (50, 7) %pc_gate};
//   &BN @WIRE {#MNB0:3 #MNB1:1};
//   %no_bus = (108, 22);
//   $JUNCTION @ATTACH %no_bus;
//   &NOFF @WIRE {#MPB0:1 (96, 22) %no_bus (120, 22) #MPB1:1};
//   &NOFF @WIRE {#MNB0:1 %no_bus};
//   %no_gate = (155, 7);
//   $JUNCTION @ATTACH %no_gate;
//   &NOFF @WIRE {%no_bus (146, 22) (146, 7) %no_gate};
//   &BP @WIRE {#MNOUT:1 #MPOUT:1};
//   &GP @WIRE {#MGPN:1 (74, 4) (74, 52) (190, 52) (190, 22) #MPOUT:2};
//   &GN @WIRE {#MGNN:1 (180, 4) (180, 0) #MNOUT:2};
//   %p_hib = $IO_PORT @ATTACH &HIB => @PLACE(5, 26) => @ORIENT("R0");
//   &HIB @WIRE {%p_hib:p #MPA1:2};
//   %p_en = $IO_PORT @ATTACH &EN => @PLACE(89, 30) => @ORIENT("R0");
//   &EN @WIRE {%p_en:p #MPB0:2};
//   %p_enb = $IO_PORT @ATTACH &ENB => @PLACE(5, 40) => @ORIENT("R0");
//   &ENB @WIRE {%p_enb:p #MPA0:2};
//   %p_bp = $IO_PORT @ATTACH &BP => @PLACE(200, 6) => @ORIENT("R270");
//   &BP @WIRE {%p_bp:p #MNOUT:1};
//   (-10, 62) @TEXT("Reference-rail output driver j=8") => @SET-STYLE $title_style
// }
ends mq_cdac_drv8

// Matched half-capacitor pair j=8
subckt mq_cdac_bit8 (VIN VG DH RL EN ENB TOP VREFP VREFN VSS DVDD EQBUS APGATE)
// CP*: user-specified 5% bottom-plate estimate for every physical MOM unit, not extraction.
// Series tails retain one unit parasitic at MID and one at B.
// APGATE PMOS assist connects each bottom plate to VIN.
// Additional ENB NMOS sharing retains a common EQBUS.
XHCTL (DH HHIB DVDD VREFN VSS) mq_cdac_ctl_h
XLCTL (RL LHIB DVDD VREFN VSS) mq_cdac_ctl_l
XDH (HHIB EN ENB BH VREFP VREFN VSS DVDD) mq_cdac_drv8
CH (TOP BH) cfmom_2t w=5e-08 s=2.4e-07 nr=6 lr=1.69e-06 stm=2 spm=4 multi=51
CPH (BH VSS) capacitor c=2.5558395e-15
MSH (BH VG VIN VSS) nch_ulvt_mac w=1.19e-06 l=3e-08 nf=1
XDL (LHIB EN ENB BL VREFP VREFN VSS DVDD) mq_cdac_drv8
CL (TOP BL) cfmom_2t w=5e-08 s=2.4e-07 nr=6 lr=1.69e-06 stm=2 spm=4 multi=51
CPL (BL VSS) capacitor c=2.5558395e-15
MSL (BL VG VIN VSS) nch_ulvt_mac w=1.19e-06 l=3e-08 nf=1
MEQ1 (BH APGATE VIN VREFP) pch_ulvt_mac w=1.19e-06 l=3e-08 nf=1
MEQ2 (BL APGATE VIN VREFP) pch_ulvt_mac w=1.19e-06 l=3e-08 nf=1
MSHAREH (BH ENB EQBUS VSS) nch_ulvt_mac w=1.19e-06 l=3e-08 nf=1
MSHAREL (BL ENB EQBUS VSS) nch_ulvt_mac w=1.19e-06 l=3e-08 nf=1
// @RNL {
//   /* pins connected by net name: the net-name label of rnl-std-fill on every unwired pin, placed below by its key netname */
//   $LABEL_TERMINAL_SET @TEXT("${net}", key="netname", size=0.6);
//   &VSS @ADD-TO $GROUND_NET_SET; &VREFN @ADD-TO $GROUND_NET_SET;
//   &VREFP @ADD-TO $SUPPLY_NET_SET;
//   &DVDD @ADD-TO $SUPPLY_NET_SET;
//   {#CH #CL} @AS $MATCHED;
//   {#MSH #MSL} @AS $MATCHED;
//   {#MEQ1 #MEQ2} @AS $MATCHED;
//   {#MSHAREH #MSHAREL} @AS $MATCHED;
//   {#XDH #XDL} @AS $MATCHED;
//   #XHCTL @PLACE(-70, 24);
//   #XHCTL @ORIENT("R0");
//   #XHCTL:IN @TEXT("${net}", key="netname", size=0.6, halign="end", valign="middle", dx=-0.4, dy=0);
//   #XHCTL:HIB @TEXT("${net}", key="netname", size=0.6, halign="start", valign="middle", dx=0.4, dy=0);
//   %v1 = $SUPPLY @ATTACH &DVDD => @PLACE(-70, 31.2);
//   &DVDD @WIRE {#XHCTL:DVDD (-70, 28) %v1:p};
//   %g2 = $GROUND @ATTACH &VREFN => @PLACE(-72, 16.8);
//   &VREFN @WIRE {#XHCTL:VREFN (-72, 20) %g2:p};
//   %g3 = $GROUND @ATTACH &VSS => @PLACE(-68, 16.8);
//   &VSS @WIRE {#XHCTL:VSS (-68, 20) %g3:p};
//   #XLCTL @PLACE(-70, -26);
//   #XLCTL @ORIENT("R0");
//   #XLCTL:IN @TEXT("${net}", key="netname", size=0.6, halign="end", valign="middle", dx=-0.4, dy=0);
//   #XLCTL:HIB @TEXT("${net}", key="netname", size=0.6, halign="start", valign="middle", dx=0.4, dy=0);
//   %v4 = $SUPPLY @ATTACH &DVDD => @PLACE(-70, -18.8);
//   &DVDD @WIRE {#XLCTL:DVDD (-70, -22) %v4:p};
//   %g5 = $GROUND @ATTACH &VREFN => @PLACE(-72, -33.2);
//   &VREFN @WIRE {#XLCTL:VREFN (-72, -30) %g5:p};
//   %g6 = $GROUND @ATTACH &VSS => @PLACE(-68, -33.2);
//   &VSS @WIRE {#XLCTL:VSS (-68, -30) %g6:p};
//   #XDH @PLACE(-34, 24);
//   #XDH @ORIENT("R0");
//   #XDH:HIB @TEXT("${net}", key="netname", size=0.6, halign="end", valign="middle", dx=-0.4, dy=0);
//   #XDH:EN @TEXT("${net}", key="netname", size=0.6, halign="end", valign="middle", dx=-0.4, dy=0);
//   #XDH:ENB @TEXT("${net}", key="netname", size=0.6, halign="end", valign="middle", dx=-0.4, dy=0);
//   #XDH:BP @TEXT("${net}", key="netname", size=0.6, halign="start", valign="middle", dx=0.4, dy=0);
//   %v7 = $SUPPLY @ATTACH &VREFP => @PLACE(-36, 32.2);
//   &VREFP @WIRE {#XDH:VREFP (-36, 29) %v7:p};
//   %g8 = $GROUND @ATTACH &VREFN => @PLACE(-36, 15.8);
//   &VREFN @WIRE {#XDH:VREFN (-36, 19) %g8:p};
//   %g9 = $GROUND @ATTACH &VSS => @PLACE(-32, 15.8);
//   &VSS @WIRE {#XDH:VSS (-32, 19) %g9:p};
//   %v10 = $SUPPLY @ATTACH &DVDD => @PLACE(-32, 32.2);
//   &DVDD @WIRE {#XDH:DVDD (-32, 29) %v10:p};
//   #CH @PLACE(14, 24) => @ORIENT("R270");
//   #CH:1 @TEXT("${net}", key="netname", size=0.6, halign="start", valign="middle", dx=0.4, dy=0);
//   #CH:2 @TEXT("${net}", key="netname", size=0.6, halign="end", valign="middle", dx=-0.4, dy=0);
//   #CPH @PLACE(60, 20);
//   #CPH @ORIENT("R0");
//   #CPH:1 @TEXT("${net}", key="netname", size=0.6, halign="start", valign="middle", rotate=90, dx=0, dy=0.4);
//   %g11 = $GROUND @ATTACH &VSS => @PLACE(60, 14.8);
//   &VSS @WIRE {#CPH:2 (60, 18) %g11:p};
//   #MSH @PLACE(2, 8);
//   #MSH @ORIENT("R0");
//   #MSH:1 @TEXT("${net}", key="netname", size=0.6, halign="start", valign="middle", rotate=90, dx=0, dy=0.4);
//   #MSH:2 @TEXT("${net}", key="netname", size=0.6, halign="end", valign="middle", dx=-0.4, dy=0);
//   #MSH:3 @TEXT("${net}", key="netname", size=0.6, halign="end", valign="middle", rotate=90, dx=0, dy=-0.4);
//   %g12 = $GROUND @ATTACH &VSS => @PLACE(5, 4.8);
//   &VSS @WIRE {#MSH:4 (5, 8) %g12:p};
//   #XDL @PLACE(-34, -26);
//   #XDL @ORIENT("R0");
//   #XDL:HIB @TEXT("${net}", key="netname", size=0.6, halign="end", valign="middle", dx=-0.4, dy=0);
//   #XDL:EN @TEXT("${net}", key="netname", size=0.6, halign="end", valign="middle", dx=-0.4, dy=0);
//   #XDL:ENB @TEXT("${net}", key="netname", size=0.6, halign="end", valign="middle", dx=-0.4, dy=0);
//   #XDL:BP @TEXT("${net}", key="netname", size=0.6, halign="start", valign="middle", dx=0.4, dy=0);
//   %v13 = $SUPPLY @ATTACH &VREFP => @PLACE(-36, -17.8);
//   &VREFP @WIRE {#XDL:VREFP (-36, -21) %v13:p};
//   %g14 = $GROUND @ATTACH &VREFN => @PLACE(-36, -34.2);
//   &VREFN @WIRE {#XDL:VREFN (-36, -31) %g14:p};
//   %g15 = $GROUND @ATTACH &VSS => @PLACE(-32, -34.2);
//   &VSS @WIRE {#XDL:VSS (-32, -31) %g15:p};
//   %v16 = $SUPPLY @ATTACH &DVDD => @PLACE(-32, -17.8);
//   &DVDD @WIRE {#XDL:DVDD (-32, -21) %v16:p};
//   #CL @PLACE(14, -26) => @ORIENT("R270");
//   #CL:1 @TEXT("${net}", key="netname", size=0.6, halign="start", valign="middle", dx=0.4, dy=0);
//   #CL:2 @TEXT("${net}", key="netname", size=0.6, halign="end", valign="middle", dx=-0.4, dy=0);
//   #CPL @PLACE(60, -30);
//   #CPL @ORIENT("R0");
//   #CPL:1 @TEXT("${net}", key="netname", size=0.6, halign="start", valign="middle", rotate=90, dx=0, dy=0.4);
//   %g17 = $GROUND @ATTACH &VSS => @PLACE(60, -35.2);
//   &VSS @WIRE {#CPL:2 (60, -32) %g17:p};
//   #MSL @PLACE(2, -42);
//   #MSL @ORIENT("R0");
//   #MSL:1 @TEXT("${net}", key="netname", size=0.6, halign="start", valign="middle", rotate=90, dx=0, dy=0.4);
//   #MSL:2 @TEXT("${net}", key="netname", size=0.6, halign="end", valign="middle", dx=-0.4, dy=0);
//   #MSL:3 @TEXT("${net}", key="netname", size=0.6, halign="end", valign="middle", rotate=90, dx=0, dy=-0.4);
//   %g18 = $GROUND @ATTACH &VSS => @PLACE(5, -45.2);
//   &VSS @WIRE {#MSL:4 (5, -42) %g18:p};
//   #MEQ1 @PLACE(-12, 0);
//   #MEQ1 @ORIENT("R0");
//   #MEQ1:1 @TEXT("${net}", key="netname", size=0.6, halign="end", valign="middle", rotate=90, dx=0, dy=-0.4);
//   #MEQ1:2 @TEXT("${net}", key="netname", size=0.6, halign="end", valign="middle", dx=-0.4, dy=0);
//   #MEQ1:3 @TEXT("${net}", key="netname", size=0.6, halign="start", valign="middle", rotate=90, dx=0, dy=0.4);
//   %v19 = $SUPPLY @ATTACH &VREFP => @PLACE(-9, 3.2);
//   &VREFP @WIRE {#MEQ1:4 (-9, 0) %v19:p};
//   #MEQ2 @PLACE(-12, -50);
//   #MEQ2 @ORIENT("R0");
//   #MEQ2:1 @TEXT("${net}", key="netname", size=0.6, halign="end", valign="middle", rotate=90, dx=0, dy=-0.4);
//   #MEQ2:2 @TEXT("${net}", key="netname", size=0.6, halign="end", valign="middle", dx=-0.4, dy=0);
//   #MEQ2:3 @TEXT("${net}", key="netname", size=0.6, halign="start", valign="middle", rotate=90, dx=0, dy=0.4);
//   %v20 = $SUPPLY @ATTACH &VREFP => @PLACE(-9, -46.8);
//   &VREFP @WIRE {#MEQ2:4 (-9, -50) %v20:p};
//   #MSHAREH @PLACE(56, -2);
//   #MSHAREH @ORIENT("R0");
//   #MSHAREH:1 @TEXT("${net}", key="netname", size=0.6, halign="start", valign="middle", rotate=90, dx=0, dy=0.4);
//   #MSHAREH:2 @TEXT("${net}", key="netname", size=0.6, halign="end", valign="middle", dx=-0.4, dy=0);
//   #MSHAREH:3 @TEXT("${net}", key="netname", size=0.6, halign="end", valign="middle", rotate=90, dx=0, dy=-0.4);
//   %g21 = $GROUND @ATTACH &VSS => @PLACE(59, -5.2);
//   &VSS @WIRE {#MSHAREH:4 (59, -2) %g21:p};
//   #MSHAREL @PLACE(56, -52);
//   #MSHAREL @ORIENT("R0");
//   #MSHAREL:1 @TEXT("${net}", key="netname", size=0.6, halign="start", valign="middle", rotate=90, dx=0, dy=0.4);
//   #MSHAREL:2 @TEXT("${net}", key="netname", size=0.6, halign="end", valign="middle", dx=-0.4, dy=0);
//   #MSHAREL:3 @TEXT("${net}", key="netname", size=0.6, halign="end", valign="middle", rotate=90, dx=0, dy=-0.4);
//   %g22 = $GROUND @ATTACH &VSS => @PLACE(59, -55.2);
//   &VSS @WIRE {#MSHAREL:4 (59, -52) %g22:p};
//   &HHIB @WIRE {#XHCTL:HIB (-52, 24) (-52, 26) #XDH:HIB};
//   %b_H = (-12, 24);
//   $JUNCTION @ATTACH %b_H;
//   &BH @WIRE {#XDH:BP %b_H};
//   &BH @WIRE {%b_H #CH:2};
//   &BH @WIRE {%b_H (-12, 10) #MSH:1};
//   &BH @WIRE {%b_H #MEQ1:1};
//   &LHIB @WIRE {#XLCTL:HIB (-52, -26) (-52, -24) #XDL:HIB};
//   %b_L = (-12, -26);
//   $JUNCTION @ATTACH %b_L;
//   &BL @WIRE {#XDL:BP %b_L};
//   &BL @WIRE {%b_L #CL:2};
//   &BL @WIRE {%b_L (-12, -40) #MSL:1};
//   &BL @WIRE {%b_L #MEQ2:1};
//   &VIN @WIRE {#MSH:3 (6, 6) (6, -44) #MSL:3};
//   &VG @WIRE {#MSH:2 (-5, 8) (-5, -42) #MSL:2};
//   %top_H = (44, 24);
//   $JUNCTION @ATTACH %top_H;
//   %top_L = (44, -26);
//   $JUNCTION @ATTACH %top_L;
//   &TOP @WIRE {#CH:1 %top_H};
//   &TOP @WIRE {#CL:1 %top_L};
//   &TOP @WIRE {%top_H %top_L};
//   %p_vin = $IO_PORT @ATTACH &VIN => @PLACE(2, 2) => @ORIENT("R90");
//   &VIN @WIRE {%p_vin:p #MSH:3};
//   %p_vg = $IO_PORT @ATTACH &VG => @PLACE(-5, 8) => @ORIENT("R0");
//   &VG @WIRE {%p_vg:p #MSH:2};
//   %p_dh = $IO_PORT @ATTACH &DH => @PLACE(-81, 24) => @ORIENT("R0");
//   &DH @WIRE {%p_dh:p #XHCTL:IN};
//   %p_rl = $IO_PORT @ATTACH &RL => @PLACE(-81, -26) => @ORIENT("R0");
//   &RL @WIRE {%p_rl:p #XLCTL:IN};
//   %p_en = $IO_PORT @ATTACH &EN => @PLACE(-45, 24) => @ORIENT("R0");
//   &EN @WIRE {%p_en:p #XDH:EN};
//   %p_enb = $IO_PORT @ATTACH &ENB => @PLACE(-45, 22) => @ORIENT("R0");
//   &ENB @WIRE {%p_enb:p #XDH:ENB};
//   %p_top = $IO_PORT @ATTACH &TOP => @PLACE(20, 24) => @ORIENT("MY");
//   &TOP @WIRE {%p_top:p #CH:1};
//   %p_eqbus = $IO_PORT @ATTACH &EQBUS => @PLACE(56, -8) => @ORIENT("R90");
//   &EQBUS @WIRE {%p_eqbus:p #MSHAREH:3};
//   %p_apgate = $IO_PORT @ATTACH &APGATE => @PLACE(-19, 0) => @ORIENT("R0");
//   &APGATE @WIRE {%p_apgate:p #MEQ1:2};
//   (-10, 46) @TEXT("Matched half-capacitor pair j=8") => @SET-STYLE $title_style
// }
ends mq_cdac_bit8

// Reference-rail output driver j=7
subckt mq_cdac_drv7 (HIB EN ENB BP VREFP VREFN VSS DVDD)
// DVDD prelogic: PCOND = NOR(ENB,HIB); NOFF = NAND(EN,HIB).
// Reference-powered final inverters restore GP and GN to VREFP/VREFN.
// Actual current overlap, settling and device stress require measurement.
MPA0 (AP ENB DVDD DVDD) pch_ulvt_mac w=4.65e-07 l=3e-08 nf=1
MPA1 (PCOND HIB AP DVDD) pch_ulvt_mac w=4.65e-07 l=3e-08 nf=1
MNA0 (PCOND ENB VREFN VSS) nch_ulvt_mac w=2.35e-07 l=3e-08 nf=1
MNA1 (PCOND HIB VREFN VSS) nch_ulvt_mac w=2.35e-07 l=3e-08 nf=1
MPB0 (NOFF EN DVDD DVDD) pch_ulvt_mac w=2.35e-07 l=3e-08 nf=1
MPB1 (NOFF HIB DVDD DVDD) pch_ulvt_mac w=2.35e-07 l=3e-08 nf=1
MNB0 (NOFF EN BN VSS) nch_ulvt_mac w=2.35e-07 l=3e-08 nf=1
MNB1 (BN HIB VREFN VSS) nch_ulvt_mac w=2.35e-07 l=3e-08 nf=1
MGPN (GP PCOND VREFN VSS) nch_mac w=4.65e-07 l=3e-08 nf=1
MGPP (GP PCOND VREFP VREFP) pch_mac w=7e-07 l=3e-08 nf=1
MGNN (GN NOFF VREFN VSS) nch_mac w=4.65e-07 l=3e-08 nf=1
MGNP (GN NOFF VREFP VREFP) pch_mac w=2.35e-07 l=3e-08 nf=1
MNOUT (BP GN VREFN VSS) nch_mac w=8.75e-07 l=3e-08 nf=1
MPOUT (BP GP VREFP VREFP) pch_mac w=1.75e-06 l=3e-08 nf=2
// @RNL {
//   /* pins connected by net name: the net-name label of rnl-std-fill on every unwired pin, placed below by its key netname */
//   $LABEL_TERMINAL_SET @TEXT("${net}", key="netname", size=0.6);
//   &VSS @ADD-TO $GROUND_NET_SET; &VREFN @ADD-TO $GROUND_NET_SET;
//   &VREFP @ADD-TO $SUPPLY_NET_SET;
//   &DVDD @ADD-TO $SUPPLY_NET_SET;
//   {#MPA0 #MPA1 #MNA0 #MNA1} @GROUP;
//   {#MPB0 #MPB1 #MNB0 #MNB1} @GROUP;
//   {#MGPN #MGPP} @GROUP;
//   {#MGNN #MGNP} @GROUP;
//   {#MNOUT #MPOUT} @GROUP;
//   #MPA0 @PLACE(12, 40);
//   #MPA0 @ORIENT("R0");
//   #MPA0:1 @TEXT("${net}", key="netname", size=0.6, halign="end", valign="middle", rotate=90, dx=0, dy=-0.4);
//   #MPA0:2 @TEXT("${net}", key="netname", size=0.6, halign="end", valign="middle", dx=-0.4, dy=0);
//   %v1 = $SUPPLY @ATTACH &DVDD => @PLACE(12, 45.2);
//   &DVDD @WIRE {#MPA0:3 (12, 42) %v1:p};
//   %v2 = $SUPPLY @ATTACH &DVDD => @PLACE(15, 43.2);
//   &DVDD @WIRE {#MPA0:4 (15, 40) %v2:p};
//   #MPA1 @PLACE(12, 26);
//   #MPA1 @ORIENT("R0");
//   #MPA1:1 @TEXT("${net}", key="netname", size=0.6, halign="end", valign="middle", rotate=90, dx=0, dy=-0.4);
//   #MPA1:2 @TEXT("${net}", key="netname", size=0.6, halign="end", valign="middle", dx=-0.4, dy=0);
//   #MPA1:3 @TEXT("${net}", key="netname", size=0.6, halign="start", valign="middle", rotate=90, dx=0, dy=0.4);
//   %v3 = $SUPPLY @ATTACH &DVDD => @PLACE(15, 29.2);
//   &DVDD @WIRE {#MPA1:4 (15, 26) %v3:p};
//   #MNA0 @PLACE(0, 2);
//   #MNA0 @ORIENT("R0");
//   #MNA0:1 @TEXT("${net}", key="netname", size=0.6, halign="start", valign="middle", rotate=90, dx=0, dy=0.4);
//   #MNA0:2 @TEXT("${net}", key="netname", size=0.6, halign="end", valign="middle", dx=-0.4, dy=0);
//   %g4 = $GROUND @ATTACH &VREFN => @PLACE(0, -3.2);
//   &VREFN @WIRE {#MNA0:3 (0, 0) %g4:p};
//   %g5 = $GROUND @ATTACH &VSS => @PLACE(3, -1.2);
//   &VSS @WIRE {#MNA0:4 (3, 2) %g5:p};
//   #MNA1 @PLACE(24, 2);
//   #MNA1 @ORIENT("R0");
//   #MNA1:1 @TEXT("${net}", key="netname", size=0.6, halign="start", valign="middle", rotate=90, dx=0, dy=0.4);
//   #MNA1:2 @TEXT("${net}", key="netname", size=0.6, halign="end", valign="middle", dx=-0.4, dy=0);
//   %g6 = $GROUND @ATTACH &VREFN => @PLACE(24, -3.2);
//   &VREFN @WIRE {#MNA1:3 (24, 0) %g6:p};
//   %g7 = $GROUND @ATTACH &VSS => @PLACE(27, -1.2);
//   &VSS @WIRE {#MNA1:4 (27, 2) %g7:p};
//   #MPB0 @PLACE(96, 30);
//   #MPB0 @ORIENT("R0");
//   #MPB0:1 @TEXT("${net}", key="netname", size=0.6, halign="end", valign="middle", rotate=90, dx=0, dy=-0.4);
//   #MPB0:2 @TEXT("${net}", key="netname", size=0.6, halign="end", valign="middle", dx=-0.4, dy=0);
//   %v8 = $SUPPLY @ATTACH &DVDD => @PLACE(96, 35.2);
//   &DVDD @WIRE {#MPB0:3 (96, 32) %v8:p};
//   %v9 = $SUPPLY @ATTACH &DVDD => @PLACE(99, 33.2);
//   &DVDD @WIRE {#MPB0:4 (99, 30) %v9:p};
//   #MPB1 @PLACE(120, 30);
//   #MPB1 @ORIENT("R0");
//   #MPB1:1 @TEXT("${net}", key="netname", size=0.6, halign="end", valign="middle", rotate=90, dx=0, dy=-0.4);
//   #MPB1:2 @TEXT("${net}", key="netname", size=0.6, halign="end", valign="middle", dx=-0.4, dy=0);
//   %v10 = $SUPPLY @ATTACH &DVDD => @PLACE(120, 35.2);
//   &DVDD @WIRE {#MPB1:3 (120, 32) %v10:p};
//   %v11 = $SUPPLY @ATTACH &DVDD => @PLACE(123, 33.2);
//   &DVDD @WIRE {#MPB1:4 (123, 30) %v11:p};
//   #MNB0 @PLACE(108, 12);
//   #MNB0 @ORIENT("R0");
//   #MNB0:1 @TEXT("${net}", key="netname", size=0.6, halign="start", valign="middle", rotate=90, dx=0, dy=0.4);
//   #MNB0:2 @TEXT("${net}", key="netname", size=0.6, halign="end", valign="middle", dx=-0.4, dy=0);
//   #MNB0:3 @TEXT("${net}", key="netname", size=0.6, halign="end", valign="middle", rotate=90, dx=0, dy=-0.4);
//   %g12 = $GROUND @ATTACH &VSS => @PLACE(111, 8.8);
//   &VSS @WIRE {#MNB0:4 (111, 12) %g12:p};
//   #MNB1 @PLACE(108, -2);
//   #MNB1 @ORIENT("R0");
//   #MNB1:1 @TEXT("${net}", key="netname", size=0.6, halign="start", valign="middle", rotate=90, dx=0, dy=0.4);
//   #MNB1:2 @TEXT("${net}", key="netname", size=0.6, halign="end", valign="middle", dx=-0.4, dy=0);
//   %g13 = $GROUND @ATTACH &VREFN => @PLACE(108, -7.2);
//   &VREFN @WIRE {#MNB1:3 (108, -4) %g13:p};
//   %g14 = $GROUND @ATTACH &VSS => @PLACE(111, -5.2);
//   &VSS @WIRE {#MNB1:4 (111, -2) %g14:p};
//   #MGPN @PLACE(64, 2);
//   #MGPN @ORIENT("R0");
//   #MGPN:1 @TEXT("${net}", key="netname", size=0.6, halign="start", valign="middle", rotate=90, dx=0, dy=0.4);
//   #MGPN:2 @TEXT("${net}", key="netname", size=0.6, halign="end", valign="middle", dx=-0.4, dy=0);
//   %g15 = $GROUND @ATTACH &VREFN => @PLACE(64, -3.2);
//   &VREFN @WIRE {#MGPN:3 (64, 0) %g15:p};
//   %g16 = $GROUND @ATTACH &VSS => @PLACE(67, -1.2);
//   &VSS @WIRE {#MGPN:4 (67, 2) %g16:p};
//   #MGPP @PLACE(64, 12);
//   #MGPP @ORIENT("R0");
//   #MGPP:1 @TEXT("${net}", key="netname", size=0.6, halign="end", valign="middle", rotate=90, dx=0, dy=-0.4);
//   #MGPP:2 @TEXT("${net}", key="netname", size=0.6, halign="end", valign="middle", dx=-0.4, dy=0);
//   %v17 = $SUPPLY @ATTACH &VREFP => @PLACE(64, 17.2);
//   &VREFP @WIRE {#MGPP:3 (64, 14) %v17:p};
//   %v18 = $SUPPLY @ATTACH &VREFP => @PLACE(67, 15.2);
//   &VREFP @WIRE {#MGPP:4 (67, 12) %v18:p};
//   #MGNN @PLACE(160, 2);
//   #MGNN @ORIENT("R0");
//   #MGNN:1 @TEXT("${net}", key="netname", size=0.6, halign="start", valign="middle", rotate=90, dx=0, dy=0.4);
//   #MGNN:2 @TEXT("${net}", key="netname", size=0.6, halign="end", valign="middle", dx=-0.4, dy=0);
//   %g19 = $GROUND @ATTACH &VREFN => @PLACE(160, -3.2);
//   &VREFN @WIRE {#MGNN:3 (160, 0) %g19:p};
//   %g20 = $GROUND @ATTACH &VSS => @PLACE(163, -1.2);
//   &VSS @WIRE {#MGNN:4 (163, 2) %g20:p};
//   #MGNP @PLACE(160, 12);
//   #MGNP @ORIENT("R0");
//   #MGNP:1 @TEXT("${net}", key="netname", size=0.6, halign="end", valign="middle", rotate=90, dx=0, dy=-0.4);
//   #MGNP:2 @TEXT("${net}", key="netname", size=0.6, halign="end", valign="middle", dx=-0.4, dy=0);
//   %v21 = $SUPPLY @ATTACH &VREFP => @PLACE(160, 17.2);
//   &VREFP @WIRE {#MGNP:3 (160, 14) %v21:p};
//   %v22 = $SUPPLY @ATTACH &VREFP => @PLACE(163, 15.2);
//   &VREFP @WIRE {#MGNP:4 (163, 12) %v22:p};
//   #MNOUT @PLACE(200, 0);
//   #MNOUT @ORIENT("R0");
//   #MNOUT:1 @TEXT("${net}", key="netname", size=0.6, halign="start", valign="middle", rotate=90, dx=0, dy=0.4);
//   #MNOUT:2 @TEXT("${net}", key="netname", size=0.6, halign="end", valign="middle", dx=-0.4, dy=0);
//   %g23 = $GROUND @ATTACH &VREFN => @PLACE(200, -5.2);
//   &VREFN @WIRE {#MNOUT:3 (200, -2) %g23:p};
//   %g24 = $GROUND @ATTACH &VSS => @PLACE(203, -3.2);
//   &VSS @WIRE {#MNOUT:4 (203, 0) %g24:p};
//   #MPOUT @PLACE(200, 22);
//   #MPOUT @ORIENT("R0");
//   #MPOUT:1 @TEXT("${net}", key="netname", size=0.6, halign="end", valign="middle", rotate=90, dx=0, dy=-0.4);
//   #MPOUT:2 @TEXT("${net}", key="netname", size=0.6, halign="end", valign="middle", dx=-0.4, dy=0);
//   %v25 = $SUPPLY @ATTACH &VREFP => @PLACE(200, 27.2);
//   &VREFP @WIRE {#MPOUT:3 (200, 24) %v25:p};
//   %v26 = $SUPPLY @ATTACH &VREFP => @PLACE(203, 25.2);
//   &VREFP @WIRE {#MPOUT:4 (203, 22) %v26:p};
//   &GP @WIRE {#MGPN:1 #MGPP:1};
//   &PCOND @WIRE {#MGPN:2 (59, 2) (59, 12) #MGPP:2};
//   &GN @WIRE {#MGNN:1 #MGNP:1};
//   &NOFF @WIRE {#MGNN:2 (155, 2) (155, 12) #MGNP:2};
//   &AP @WIRE {#MPA0:1 #MPA1:3};
//   %pc_bus = (12, 16);
//   $JUNCTION @ATTACH %pc_bus;
//   &PCOND @WIRE {#MNA0:1 (0, 16) %pc_bus (24, 16) #MNA1:1};
//   &PCOND @WIRE {#MPA1:1 %pc_bus};
//   %pc_gate = (59, 7);
//   $JUNCTION @ATTACH %pc_gate;
//   &PCOND @WIRE {%pc_bus (50, 16) (50, 7) %pc_gate};
//   &BN @WIRE {#MNB0:3 #MNB1:1};
//   %no_bus = (108, 22);
//   $JUNCTION @ATTACH %no_bus;
//   &NOFF @WIRE {#MPB0:1 (96, 22) %no_bus (120, 22) #MPB1:1};
//   &NOFF @WIRE {#MNB0:1 %no_bus};
//   %no_gate = (155, 7);
//   $JUNCTION @ATTACH %no_gate;
//   &NOFF @WIRE {%no_bus (146, 22) (146, 7) %no_gate};
//   &BP @WIRE {#MNOUT:1 #MPOUT:1};
//   &GP @WIRE {#MGPN:1 (74, 4) (74, 52) (190, 52) (190, 22) #MPOUT:2};
//   &GN @WIRE {#MGNN:1 (180, 4) (180, 0) #MNOUT:2};
//   %p_hib = $IO_PORT @ATTACH &HIB => @PLACE(5, 26) => @ORIENT("R0");
//   &HIB @WIRE {%p_hib:p #MPA1:2};
//   %p_en = $IO_PORT @ATTACH &EN => @PLACE(89, 30) => @ORIENT("R0");
//   &EN @WIRE {%p_en:p #MPB0:2};
//   %p_enb = $IO_PORT @ATTACH &ENB => @PLACE(5, 40) => @ORIENT("R0");
//   &ENB @WIRE {%p_enb:p #MPA0:2};
//   %p_bp = $IO_PORT @ATTACH &BP => @PLACE(200, 6) => @ORIENT("R270");
//   &BP @WIRE {%p_bp:p #MNOUT:1};
//   (-10, 62) @TEXT("Reference-rail output driver j=7") => @SET-STYLE $title_style
// }
ends mq_cdac_drv7

// Matched half-capacitor pair j=7
subckt mq_cdac_bit7 (VIN VG DH RL EN ENB TOP VREFP VREFN VSS PHI_S DVDD PHI_SB EQBUS APGATE)
// CP*: user-specified 5% bottom-plate estimate for every physical MOM unit, not extraction.
// Series tails retain one unit parasitic at MID and one at B.
// APGATE PMOS assist connects each bottom plate to VIN.
// MID-to-VIN transmission gates provide physical initialization during PHI_S.
// Additional ENB NMOS sharing retains a common EQBUS.
XHCTL (DH HHIB DVDD VREFN VSS) mq_cdac_ctl_h
XLCTL (RL LHIB DVDD VREFN VSS) mq_cdac_ctl_l
XDH (HHIB EN ENB BH VREFP VREFN VSS DVDD) mq_cdac_drv7
CH (TOP BH) cfmom_2t w=5e-08 s=2.4e-07 nr=6 lr=1.69e-06 stm=2 spm=4 multi=28
CPH (BH VSS) capacitor c=1.4032060e-15
CHA (TOP MIDH) cfmom_2t w=5e-08 s=2.4e-07 nr=6 lr=1.69e-06 stm=2 spm=4 multi=1
CPHA (MIDH VSS) capacitor c=5.01145e-17
CHB (MIDH BH) cfmom_2t w=5e-08 s=2.4e-07 nr=6 lr=1.69e-06 stm=2 spm=4 multi=1
CPHB (BH VSS) capacitor c=5.01145e-17
MSH (BH VG VIN VSS) nch_ulvt_mac w=6.65e-07 l=3e-08 nf=1
XDL (LHIB EN ENB BL VREFP VREFN VSS DVDD) mq_cdac_drv7
CL (TOP BL) cfmom_2t w=5e-08 s=2.4e-07 nr=6 lr=1.69e-06 stm=2 spm=4 multi=28
CPL (BL VSS) capacitor c=1.4032060e-15
CLA (TOP MIDL) cfmom_2t w=5e-08 s=2.4e-07 nr=6 lr=1.69e-06 stm=2 spm=4 multi=1
CPLA (MIDL VSS) capacitor c=5.01145e-17
CLB (MIDL BL) cfmom_2t w=5e-08 s=2.4e-07 nr=6 lr=1.69e-06 stm=2 spm=4 multi=1
CPLB (BL VSS) capacitor c=5.01145e-17
MSL (BL VG VIN VSS) nch_ulvt_mac w=6.65e-07 l=3e-08 nf=1
MEQ1 (BH APGATE VIN VREFP) pch_ulvt_mac w=6.65e-07 l=3e-08 nf=1
MEQ2 (BL APGATE VIN VREFP) pch_ulvt_mac w=6.65e-07 l=3e-08 nf=1
MMIDNH (MIDH PHI_S VIN VSS) nch_ulvt_mac w=1.2e-07 l=3e-08 nf=1
MMIDPH (MIDH PHI_SB VIN VREFP) pch_mac w=1.2e-07 l=3e-08 nf=1
MMIDNL (MIDL PHI_S VIN VSS) nch_ulvt_mac w=1.2e-07 l=3e-08 nf=1
MMIDPL (MIDL PHI_SB VIN VREFP) pch_mac w=1.2e-07 l=3e-08 nf=1
MSHAREH (BH ENB EQBUS VSS) nch_ulvt_mac w=6.65e-07 l=3e-08 nf=1
MSHAREL (BL ENB EQBUS VSS) nch_ulvt_mac w=6.65e-07 l=3e-08 nf=1
// @RNL {
//   /* pins connected by net name: the net-name label of rnl-std-fill on every unwired pin, placed below by its key netname */
//   $LABEL_TERMINAL_SET @TEXT("${net}", key="netname", size=0.6);
//   &VSS @ADD-TO $GROUND_NET_SET; &VREFN @ADD-TO $GROUND_NET_SET;
//   &VREFP @ADD-TO $SUPPLY_NET_SET;
//   &DVDD @ADD-TO $SUPPLY_NET_SET;
//   {#CH #CL} @AS $MATCHED;
//   {#CHA #CHB #CLA #CLB} @AS $MATCHED;
//   {#CHA #CHB #CLA #CLB} @GROUP;
//   {#MSH #MSL} @AS $MATCHED;
//   {#MEQ1 #MEQ2} @AS $MATCHED;
//   {#MMIDNH #MMIDNL} @AS $MATCHED;
//   {#MMIDPH #MMIDPL} @AS $MATCHED;
//   {#MSHAREH #MSHAREL} @AS $MATCHED;
//   {#XDH #XDL} @AS $MATCHED;
//   #XHCTL @PLACE(-70, 24);
//   #XHCTL @ORIENT("R0");
//   #XHCTL:IN @TEXT("${net}", key="netname", size=0.6, halign="end", valign="middle", dx=-0.4, dy=0);
//   #XHCTL:HIB @TEXT("${net}", key="netname", size=0.6, halign="start", valign="middle", dx=0.4, dy=0);
//   %v1 = $SUPPLY @ATTACH &DVDD => @PLACE(-70, 31.2);
//   &DVDD @WIRE {#XHCTL:DVDD (-70, 28) %v1:p};
//   %g2 = $GROUND @ATTACH &VREFN => @PLACE(-72, 16.8);
//   &VREFN @WIRE {#XHCTL:VREFN (-72, 20) %g2:p};
//   %g3 = $GROUND @ATTACH &VSS => @PLACE(-68, 16.8);
//   &VSS @WIRE {#XHCTL:VSS (-68, 20) %g3:p};
//   #XLCTL @PLACE(-70, -26);
//   #XLCTL @ORIENT("R0");
//   #XLCTL:IN @TEXT("${net}", key="netname", size=0.6, halign="end", valign="middle", dx=-0.4, dy=0);
//   #XLCTL:HIB @TEXT("${net}", key="netname", size=0.6, halign="start", valign="middle", dx=0.4, dy=0);
//   %v4 = $SUPPLY @ATTACH &DVDD => @PLACE(-70, -18.8);
//   &DVDD @WIRE {#XLCTL:DVDD (-70, -22) %v4:p};
//   %g5 = $GROUND @ATTACH &VREFN => @PLACE(-72, -33.2);
//   &VREFN @WIRE {#XLCTL:VREFN (-72, -30) %g5:p};
//   %g6 = $GROUND @ATTACH &VSS => @PLACE(-68, -33.2);
//   &VSS @WIRE {#XLCTL:VSS (-68, -30) %g6:p};
//   #XDH @PLACE(-34, 24);
//   #XDH @ORIENT("R0");
//   #XDH:HIB @TEXT("${net}", key="netname", size=0.6, halign="end", valign="middle", dx=-0.4, dy=0);
//   #XDH:EN @TEXT("${net}", key="netname", size=0.6, halign="end", valign="middle", dx=-0.4, dy=0);
//   #XDH:ENB @TEXT("${net}", key="netname", size=0.6, halign="end", valign="middle", dx=-0.4, dy=0);
//   #XDH:BP @TEXT("${net}", key="netname", size=0.6, halign="start", valign="middle", dx=0.4, dy=0);
//   %v7 = $SUPPLY @ATTACH &VREFP => @PLACE(-36, 32.2);
//   &VREFP @WIRE {#XDH:VREFP (-36, 29) %v7:p};
//   %g8 = $GROUND @ATTACH &VREFN => @PLACE(-36, 15.8);
//   &VREFN @WIRE {#XDH:VREFN (-36, 19) %g8:p};
//   %g9 = $GROUND @ATTACH &VSS => @PLACE(-32, 15.8);
//   &VSS @WIRE {#XDH:VSS (-32, 19) %g9:p};
//   %v10 = $SUPPLY @ATTACH &DVDD => @PLACE(-32, 32.2);
//   &DVDD @WIRE {#XDH:DVDD (-32, 29) %v10:p};
//   #CH @PLACE(14, 24) => @ORIENT("R270");
//   #CH:1 @TEXT("${net}", key="netname", size=0.6, halign="start", valign="middle", dx=0.4, dy=0);
//   #CH:2 @TEXT("${net}", key="netname", size=0.6, halign="end", valign="middle", dx=-0.4, dy=0);
//   #CPH @PLACE(60, 20);
//   #CPH @ORIENT("R0");
//   #CPH:1 @TEXT("${net}", key="netname", size=0.6, halign="start", valign="middle", rotate=90, dx=0, dy=0.4);
//   %g11 = $GROUND @ATTACH &VSS => @PLACE(60, 14.8);
//   &VSS @WIRE {#CPH:2 (60, 18) %g11:p};
//   #CHA @PLACE(30, 38) => @ORIENT("R270");
//   #CHA:1 @TEXT("${net}", key="netname", size=0.6, halign="start", valign="middle", dx=0.4, dy=0);
//   #CHA:2 @TEXT("${net}", key="netname", size=0.6, halign="end", valign="middle", dx=-0.4, dy=0);
//   #CPHA @PLACE(76, 20);
//   #CPHA @ORIENT("R0");
//   #CPHA:1 @TEXT("${net}", key="netname", size=0.6, halign="start", valign="middle", rotate=90, dx=0, dy=0.4);
//   %g12 = $GROUND @ATTACH &VSS => @PLACE(76, 14.8);
//   &VSS @WIRE {#CPHA:2 (76, 18) %g12:p};
//   #CHB @PLACE(10, 38) => @ORIENT("R270");
//   #CHB:1 @TEXT("${net}", key="netname", size=0.6, halign="start", valign="middle", dx=0.4, dy=0);
//   #CHB:2 @TEXT("${net}", key="netname", size=0.6, halign="end", valign="middle", dx=-0.4, dy=0);
//   #CPHB @PLACE(92, 20);
//   #CPHB @ORIENT("R0");
//   #CPHB:1 @TEXT("${net}", key="netname", size=0.6, halign="start", valign="middle", rotate=90, dx=0, dy=0.4);
//   %g13 = $GROUND @ATTACH &VSS => @PLACE(92, 14.8);
//   &VSS @WIRE {#CPHB:2 (92, 18) %g13:p};
//   #MSH @PLACE(2, 8);
//   #MSH @ORIENT("R0");
//   #MSH:1 @TEXT("${net}", key="netname", size=0.6, halign="start", valign="middle", rotate=90, dx=0, dy=0.4);
//   #MSH:2 @TEXT("${net}", key="netname", size=0.6, halign="end", valign="middle", dx=-0.4, dy=0);
//   #MSH:3 @TEXT("${net}", key="netname", size=0.6, halign="end", valign="middle", rotate=90, dx=0, dy=-0.4);
//   %g14 = $GROUND @ATTACH &VSS => @PLACE(5, 4.8);
//   &VSS @WIRE {#MSH:4 (5, 8) %g14:p};
//   #XDL @PLACE(-34, -26);
//   #XDL @ORIENT("R0");
//   #XDL:HIB @TEXT("${net}", key="netname", size=0.6, halign="end", valign="middle", dx=-0.4, dy=0);
//   #XDL:EN @TEXT("${net}", key="netname", size=0.6, halign="end", valign="middle", dx=-0.4, dy=0);
//   #XDL:ENB @TEXT("${net}", key="netname", size=0.6, halign="end", valign="middle", dx=-0.4, dy=0);
//   #XDL:BP @TEXT("${net}", key="netname", size=0.6, halign="start", valign="middle", dx=0.4, dy=0);
//   %v15 = $SUPPLY @ATTACH &VREFP => @PLACE(-36, -17.8);
//   &VREFP @WIRE {#XDL:VREFP (-36, -21) %v15:p};
//   %g16 = $GROUND @ATTACH &VREFN => @PLACE(-36, -34.2);
//   &VREFN @WIRE {#XDL:VREFN (-36, -31) %g16:p};
//   %g17 = $GROUND @ATTACH &VSS => @PLACE(-32, -34.2);
//   &VSS @WIRE {#XDL:VSS (-32, -31) %g17:p};
//   %v18 = $SUPPLY @ATTACH &DVDD => @PLACE(-32, -17.8);
//   &DVDD @WIRE {#XDL:DVDD (-32, -21) %v18:p};
//   #CL @PLACE(14, -26) => @ORIENT("R270");
//   #CL:1 @TEXT("${net}", key="netname", size=0.6, halign="start", valign="middle", dx=0.4, dy=0);
//   #CL:2 @TEXT("${net}", key="netname", size=0.6, halign="end", valign="middle", dx=-0.4, dy=0);
//   #CPL @PLACE(60, -30);
//   #CPL @ORIENT("R0");
//   #CPL:1 @TEXT("${net}", key="netname", size=0.6, halign="start", valign="middle", rotate=90, dx=0, dy=0.4);
//   %g19 = $GROUND @ATTACH &VSS => @PLACE(60, -35.2);
//   &VSS @WIRE {#CPL:2 (60, -32) %g19:p};
//   #CLA @PLACE(30, -12) => @ORIENT("R270");
//   #CLA:1 @TEXT("${net}", key="netname", size=0.6, halign="start", valign="middle", dx=0.4, dy=0);
//   #CLA:2 @TEXT("${net}", key="netname", size=0.6, halign="end", valign="middle", dx=-0.4, dy=0);
//   #CPLA @PLACE(76, -30);
//   #CPLA @ORIENT("R0");
//   #CPLA:1 @TEXT("${net}", key="netname", size=0.6, halign="start", valign="middle", rotate=90, dx=0, dy=0.4);
//   %g20 = $GROUND @ATTACH &VSS => @PLACE(76, -35.2);
//   &VSS @WIRE {#CPLA:2 (76, -32) %g20:p};
//   #CLB @PLACE(10, -12) => @ORIENT("R270");
//   #CLB:1 @TEXT("${net}", key="netname", size=0.6, halign="start", valign="middle", dx=0.4, dy=0);
//   #CLB:2 @TEXT("${net}", key="netname", size=0.6, halign="end", valign="middle", dx=-0.4, dy=0);
//   #CPLB @PLACE(92, -30);
//   #CPLB @ORIENT("R0");
//   #CPLB:1 @TEXT("${net}", key="netname", size=0.6, halign="start", valign="middle", rotate=90, dx=0, dy=0.4);
//   %g21 = $GROUND @ATTACH &VSS => @PLACE(92, -35.2);
//   &VSS @WIRE {#CPLB:2 (92, -32) %g21:p};
//   #MSL @PLACE(2, -42);
//   #MSL @ORIENT("R0");
//   #MSL:1 @TEXT("${net}", key="netname", size=0.6, halign="start", valign="middle", rotate=90, dx=0, dy=0.4);
//   #MSL:2 @TEXT("${net}", key="netname", size=0.6, halign="end", valign="middle", dx=-0.4, dy=0);
//   #MSL:3 @TEXT("${net}", key="netname", size=0.6, halign="end", valign="middle", rotate=90, dx=0, dy=-0.4);
//   %g22 = $GROUND @ATTACH &VSS => @PLACE(5, -45.2);
//   &VSS @WIRE {#MSL:4 (5, -42) %g22:p};
//   #MEQ1 @PLACE(-12, 0);
//   #MEQ1 @ORIENT("R0");
//   #MEQ1:1 @TEXT("${net}", key="netname", size=0.6, halign="end", valign="middle", rotate=90, dx=0, dy=-0.4);
//   #MEQ1:2 @TEXT("${net}", key="netname", size=0.6, halign="end", valign="middle", dx=-0.4, dy=0);
//   #MEQ1:3 @TEXT("${net}", key="netname", size=0.6, halign="start", valign="middle", rotate=90, dx=0, dy=0.4);
//   %v23 = $SUPPLY @ATTACH &VREFP => @PLACE(-9, 3.2);
//   &VREFP @WIRE {#MEQ1:4 (-9, 0) %v23:p};
//   #MEQ2 @PLACE(-12, -50);
//   #MEQ2 @ORIENT("R0");
//   #MEQ2:1 @TEXT("${net}", key="netname", size=0.6, halign="end", valign="middle", rotate=90, dx=0, dy=-0.4);
//   #MEQ2:2 @TEXT("${net}", key="netname", size=0.6, halign="end", valign="middle", dx=-0.4, dy=0);
//   #MEQ2:3 @TEXT("${net}", key="netname", size=0.6, halign="start", valign="middle", rotate=90, dx=0, dy=0.4);
//   %v24 = $SUPPLY @ATTACH &VREFP => @PLACE(-9, -46.8);
//   &VREFP @WIRE {#MEQ2:4 (-9, -50) %v24:p};
//   #MMIDNH @PLACE(115, 14);
//   #MMIDNH @ORIENT("R0");
//   #MMIDNH:1 @TEXT("${net}", key="netname", size=0.6, halign="start", valign="middle", rotate=90, dx=0, dy=0.4);
//   #MMIDNH:2 @TEXT("${net}", key="netname", size=0.6, halign="end", valign="middle", dx=-0.4, dy=0);
//   #MMIDNH:3 @TEXT("${net}", key="netname", size=0.6, halign="end", valign="middle", rotate=90, dx=0, dy=-0.4);
//   %g25 = $GROUND @ATTACH &VSS => @PLACE(118, 10.8);
//   &VSS @WIRE {#MMIDNH:4 (118, 14) %g25:p};
//   #MMIDPH @PLACE(115, 32);
//   #MMIDPH @ORIENT("R0");
//   #MMIDPH:1 @TEXT("${net}", key="netname", size=0.6, halign="end", valign="middle", rotate=90, dx=0, dy=-0.4);
//   #MMIDPH:2 @TEXT("${net}", key="netname", size=0.6, halign="end", valign="middle", dx=-0.4, dy=0);
//   #MMIDPH:3 @TEXT("${net}", key="netname", size=0.6, halign="start", valign="middle", rotate=90, dx=0, dy=0.4);
//   %v26 = $SUPPLY @ATTACH &VREFP => @PLACE(118, 35.2);
//   &VREFP @WIRE {#MMIDPH:4 (118, 32) %v26:p};
//   #MMIDNL @PLACE(115, -36);
//   #MMIDNL @ORIENT("R0");
//   #MMIDNL:1 @TEXT("${net}", key="netname", size=0.6, halign="start", valign="middle", rotate=90, dx=0, dy=0.4);
//   #MMIDNL:2 @TEXT("${net}", key="netname", size=0.6, halign="end", valign="middle", dx=-0.4, dy=0);
//   #MMIDNL:3 @TEXT("${net}", key="netname", size=0.6, halign="end", valign="middle", rotate=90, dx=0, dy=-0.4);
//   %g27 = $GROUND @ATTACH &VSS => @PLACE(118, -39.2);
//   &VSS @WIRE {#MMIDNL:4 (118, -36) %g27:p};
//   #MMIDPL @PLACE(115, -18);
//   #MMIDPL @ORIENT("R0");
//   #MMIDPL:1 @TEXT("${net}", key="netname", size=0.6, halign="end", valign="middle", rotate=90, dx=0, dy=-0.4);
//   #MMIDPL:2 @TEXT("${net}", key="netname", size=0.6, halign="end", valign="middle", dx=-0.4, dy=0);
//   #MMIDPL:3 @TEXT("${net}", key="netname", size=0.6, halign="start", valign="middle", rotate=90, dx=0, dy=0.4);
//   %v28 = $SUPPLY @ATTACH &VREFP => @PLACE(118, -14.8);
//   &VREFP @WIRE {#MMIDPL:4 (118, -18) %v28:p};
//   #MSHAREH @PLACE(56, -2);
//   #MSHAREH @ORIENT("R0");
//   #MSHAREH:1 @TEXT("${net}", key="netname", size=0.6, halign="start", valign="middle", rotate=90, dx=0, dy=0.4);
//   #MSHAREH:2 @TEXT("${net}", key="netname", size=0.6, halign="end", valign="middle", dx=-0.4, dy=0);
//   #MSHAREH:3 @TEXT("${net}", key="netname", size=0.6, halign="end", valign="middle", rotate=90, dx=0, dy=-0.4);
//   %g29 = $GROUND @ATTACH &VSS => @PLACE(59, -5.2);
//   &VSS @WIRE {#MSHAREH:4 (59, -2) %g29:p};
//   #MSHAREL @PLACE(56, -52);
//   #MSHAREL @ORIENT("R0");
//   #MSHAREL:1 @TEXT("${net}", key="netname", size=0.6, halign="start", valign="middle", rotate=90, dx=0, dy=0.4);
//   #MSHAREL:2 @TEXT("${net}", key="netname", size=0.6, halign="end", valign="middle", dx=-0.4, dy=0);
//   #MSHAREL:3 @TEXT("${net}", key="netname", size=0.6, halign="end", valign="middle", rotate=90, dx=0, dy=-0.4);
//   %g30 = $GROUND @ATTACH &VSS => @PLACE(59, -55.2);
//   &VSS @WIRE {#MSHAREL:4 (59, -52) %g30:p};
//   &HHIB @WIRE {#XHCTL:HIB (-52, 24) (-52, 26) #XDH:HIB};
//   %b_H = (-12, 24);
//   $JUNCTION @ATTACH %b_H;
//   &BH @WIRE {#XDH:BP %b_H};
//   &BH @WIRE {%b_H #CH:2};
//   &MIDH @WIRE {#CHB:1 #CHA:2};
//   &BH @WIRE {%b_H (-12, 38) #CHB:2};
//   &BH @WIRE {%b_H (-12, 10) #MSH:1};
//   &BH @WIRE {%b_H #MEQ1:1};
//   &LHIB @WIRE {#XLCTL:HIB (-52, -26) (-52, -24) #XDL:HIB};
//   %b_L = (-12, -26);
//   $JUNCTION @ATTACH %b_L;
//   &BL @WIRE {#XDL:BP %b_L};
//   &BL @WIRE {%b_L #CL:2};
//   &MIDL @WIRE {#CLB:1 #CLA:2};
//   &BL @WIRE {%b_L (-12, -12) #CLB:2};
//   &BL @WIRE {%b_L (-12, -40) #MSL:1};
//   &BL @WIRE {%b_L #MEQ2:1};
//   &VIN @WIRE {#MSH:3 (6, 6) (6, -44) #MSL:3};
//   &VG @WIRE {#MSH:2 (-5, 8) (-5, -42) #MSL:2};
//   %top_H = (44, 24);
//   $JUNCTION @ATTACH %top_H;
//   %top_L = (44, -26);
//   $JUNCTION @ATTACH %top_L;
//   &TOP @WIRE {#CHA:1 (44, 38) %top_H};
//   &TOP @WIRE {#CH:1 %top_H};
//   &TOP @WIRE {#CLA:1 (44, -12) %top_L};
//   &TOP @WIRE {#CL:1 %top_L};
//   &TOP @WIRE {%top_H %top_L};
//   &MIDH @WIRE {#MMIDNH:1 #MMIDPH:1};
//   &MIDL @WIRE {#MMIDNL:1 #MMIDPL:1};
//   %p_vin = $IO_PORT @ATTACH &VIN => @PLACE(2, 2) => @ORIENT("R90");
//   &VIN @WIRE {%p_vin:p #MSH:3};
//   %p_vg = $IO_PORT @ATTACH &VG => @PLACE(-5, 8) => @ORIENT("R0");
//   &VG @WIRE {%p_vg:p #MSH:2};
//   %p_dh = $IO_PORT @ATTACH &DH => @PLACE(-81, 24) => @ORIENT("R0");
//   &DH @WIRE {%p_dh:p #XHCTL:IN};
//   %p_rl = $IO_PORT @ATTACH &RL => @PLACE(-81, -26) => @ORIENT("R0");
//   &RL @WIRE {%p_rl:p #XLCTL:IN};
//   %p_en = $IO_PORT @ATTACH &EN => @PLACE(-45, 24) => @ORIENT("R0");
//   &EN @WIRE {%p_en:p #XDH:EN};
//   %p_enb = $IO_PORT @ATTACH &ENB => @PLACE(-45, 22) => @ORIENT("R0");
//   &ENB @WIRE {%p_enb:p #XDH:ENB};
//   %p_top = $IO_PORT @ATTACH &TOP => @PLACE(20, 24) => @ORIENT("MY");
//   &TOP @WIRE {%p_top:p #CH:1};
//   %p_phi_s = $IO_PORT @ATTACH &PHI_S => @PLACE(108, 14) => @ORIENT("R0");
//   &PHI_S @WIRE {%p_phi_s:p #MMIDNH:2};
//   %p_phi_sb = $IO_PORT @ATTACH &PHI_SB => @PLACE(108, 32) => @ORIENT("R0");
//   &PHI_SB @WIRE {%p_phi_sb:p #MMIDPH:2};
//   %p_eqbus = $IO_PORT @ATTACH &EQBUS => @PLACE(56, -8) => @ORIENT("R90");
//   &EQBUS @WIRE {%p_eqbus:p #MSHAREH:3};
//   %p_apgate = $IO_PORT @ATTACH &APGATE => @PLACE(-19, 0) => @ORIENT("R0");
//   &APGATE @WIRE {%p_apgate:p #MEQ1:2};
//   (-10, 60) @TEXT("Matched half-capacitor pair j=7") => @SET-STYLE $title_style
// }
ends mq_cdac_bit7

// Reference-rail output driver j=6
subckt mq_cdac_drv6 (HIB EN ENB BP VREFP VREFN VSS DVDD)
// DVDD prelogic: PCOND = NOR(ENB,HIB); NOFF = NAND(EN,HIB).
// Reference-powered final inverters restore GP and GN to VREFP/VREFN.
// Actual current overlap, settling and device stress require measurement.
MPA0 (AP ENB DVDD DVDD) pch_ulvt_mac w=2.6e-07 l=3e-08 nf=1
MPA1 (PCOND HIB AP DVDD) pch_ulvt_mac w=2.6e-07 l=3e-08 nf=1
MNA0 (PCOND ENB VREFN VSS) nch_ulvt_mac w=1.3e-07 l=3e-08 nf=1
MNA1 (PCOND HIB VREFN VSS) nch_ulvt_mac w=1.3e-07 l=3e-08 nf=1
MPB0 (NOFF EN DVDD DVDD) pch_ulvt_mac w=1.3e-07 l=3e-08 nf=1
MPB1 (NOFF HIB DVDD DVDD) pch_ulvt_mac w=1.3e-07 l=3e-08 nf=1
MNB0 (NOFF EN BN VSS) nch_ulvt_mac w=1.3e-07 l=3e-08 nf=1
MNB1 (BN HIB VREFN VSS) nch_ulvt_mac w=1.3e-07 l=3e-08 nf=1
MGPN (GP PCOND VREFN VSS) nch_mac w=2.6e-07 l=3e-08 nf=1
MGPP (GP PCOND VREFP VREFP) pch_mac w=3.9e-07 l=3e-08 nf=1
MGNN (GN NOFF VREFN VSS) nch_mac w=2.6e-07 l=3e-08 nf=1
MGNP (GN NOFF VREFP VREFP) pch_mac w=1.3e-07 l=3e-08 nf=1
MNOUT (BP GN VREFN VSS) nch_mac w=1.47e-06 l=3e-08 nf=3
MPOUT (BP GP VREFP VREFP) pch_mac w=2.94e-06 l=3e-08 nf=3
// @RNL {
//   /* pins connected by net name: the net-name label of rnl-std-fill on every unwired pin, placed below by its key netname */
//   $LABEL_TERMINAL_SET @TEXT("${net}", key="netname", size=0.6);
//   &VSS @ADD-TO $GROUND_NET_SET; &VREFN @ADD-TO $GROUND_NET_SET;
//   &VREFP @ADD-TO $SUPPLY_NET_SET;
//   &DVDD @ADD-TO $SUPPLY_NET_SET;
//   {#MPA0 #MPA1 #MNA0 #MNA1} @GROUP;
//   {#MPB0 #MPB1 #MNB0 #MNB1} @GROUP;
//   {#MGPN #MGPP} @GROUP;
//   {#MGNN #MGNP} @GROUP;
//   {#MNOUT #MPOUT} @GROUP;
//   #MPA0 @PLACE(12, 40);
//   #MPA0 @ORIENT("R0");
//   #MPA0:1 @TEXT("${net}", key="netname", size=0.6, halign="end", valign="middle", rotate=90, dx=0, dy=-0.4);
//   #MPA0:2 @TEXT("${net}", key="netname", size=0.6, halign="end", valign="middle", dx=-0.4, dy=0);
//   %v1 = $SUPPLY @ATTACH &DVDD => @PLACE(12, 45.2);
//   &DVDD @WIRE {#MPA0:3 (12, 42) %v1:p};
//   %v2 = $SUPPLY @ATTACH &DVDD => @PLACE(15, 43.2);
//   &DVDD @WIRE {#MPA0:4 (15, 40) %v2:p};
//   #MPA1 @PLACE(12, 26);
//   #MPA1 @ORIENT("R0");
//   #MPA1:1 @TEXT("${net}", key="netname", size=0.6, halign="end", valign="middle", rotate=90, dx=0, dy=-0.4);
//   #MPA1:2 @TEXT("${net}", key="netname", size=0.6, halign="end", valign="middle", dx=-0.4, dy=0);
//   #MPA1:3 @TEXT("${net}", key="netname", size=0.6, halign="start", valign="middle", rotate=90, dx=0, dy=0.4);
//   %v3 = $SUPPLY @ATTACH &DVDD => @PLACE(15, 29.2);
//   &DVDD @WIRE {#MPA1:4 (15, 26) %v3:p};
//   #MNA0 @PLACE(0, 2);
//   #MNA0 @ORIENT("R0");
//   #MNA0:1 @TEXT("${net}", key="netname", size=0.6, halign="start", valign="middle", rotate=90, dx=0, dy=0.4);
//   #MNA0:2 @TEXT("${net}", key="netname", size=0.6, halign="end", valign="middle", dx=-0.4, dy=0);
//   %g4 = $GROUND @ATTACH &VREFN => @PLACE(0, -3.2);
//   &VREFN @WIRE {#MNA0:3 (0, 0) %g4:p};
//   %g5 = $GROUND @ATTACH &VSS => @PLACE(3, -1.2);
//   &VSS @WIRE {#MNA0:4 (3, 2) %g5:p};
//   #MNA1 @PLACE(24, 2);
//   #MNA1 @ORIENT("R0");
//   #MNA1:1 @TEXT("${net}", key="netname", size=0.6, halign="start", valign="middle", rotate=90, dx=0, dy=0.4);
//   #MNA1:2 @TEXT("${net}", key="netname", size=0.6, halign="end", valign="middle", dx=-0.4, dy=0);
//   %g6 = $GROUND @ATTACH &VREFN => @PLACE(24, -3.2);
//   &VREFN @WIRE {#MNA1:3 (24, 0) %g6:p};
//   %g7 = $GROUND @ATTACH &VSS => @PLACE(27, -1.2);
//   &VSS @WIRE {#MNA1:4 (27, 2) %g7:p};
//   #MPB0 @PLACE(96, 30);
//   #MPB0 @ORIENT("R0");
//   #MPB0:1 @TEXT("${net}", key="netname", size=0.6, halign="end", valign="middle", rotate=90, dx=0, dy=-0.4);
//   #MPB0:2 @TEXT("${net}", key="netname", size=0.6, halign="end", valign="middle", dx=-0.4, dy=0);
//   %v8 = $SUPPLY @ATTACH &DVDD => @PLACE(96, 35.2);
//   &DVDD @WIRE {#MPB0:3 (96, 32) %v8:p};
//   %v9 = $SUPPLY @ATTACH &DVDD => @PLACE(99, 33.2);
//   &DVDD @WIRE {#MPB0:4 (99, 30) %v9:p};
//   #MPB1 @PLACE(120, 30);
//   #MPB1 @ORIENT("R0");
//   #MPB1:1 @TEXT("${net}", key="netname", size=0.6, halign="end", valign="middle", rotate=90, dx=0, dy=-0.4);
//   #MPB1:2 @TEXT("${net}", key="netname", size=0.6, halign="end", valign="middle", dx=-0.4, dy=0);
//   %v10 = $SUPPLY @ATTACH &DVDD => @PLACE(120, 35.2);
//   &DVDD @WIRE {#MPB1:3 (120, 32) %v10:p};
//   %v11 = $SUPPLY @ATTACH &DVDD => @PLACE(123, 33.2);
//   &DVDD @WIRE {#MPB1:4 (123, 30) %v11:p};
//   #MNB0 @PLACE(108, 12);
//   #MNB0 @ORIENT("R0");
//   #MNB0:1 @TEXT("${net}", key="netname", size=0.6, halign="start", valign="middle", rotate=90, dx=0, dy=0.4);
//   #MNB0:2 @TEXT("${net}", key="netname", size=0.6, halign="end", valign="middle", dx=-0.4, dy=0);
//   #MNB0:3 @TEXT("${net}", key="netname", size=0.6, halign="end", valign="middle", rotate=90, dx=0, dy=-0.4);
//   %g12 = $GROUND @ATTACH &VSS => @PLACE(111, 8.8);
//   &VSS @WIRE {#MNB0:4 (111, 12) %g12:p};
//   #MNB1 @PLACE(108, -2);
//   #MNB1 @ORIENT("R0");
//   #MNB1:1 @TEXT("${net}", key="netname", size=0.6, halign="start", valign="middle", rotate=90, dx=0, dy=0.4);
//   #MNB1:2 @TEXT("${net}", key="netname", size=0.6, halign="end", valign="middle", dx=-0.4, dy=0);
//   %g13 = $GROUND @ATTACH &VREFN => @PLACE(108, -7.2);
//   &VREFN @WIRE {#MNB1:3 (108, -4) %g13:p};
//   %g14 = $GROUND @ATTACH &VSS => @PLACE(111, -5.2);
//   &VSS @WIRE {#MNB1:4 (111, -2) %g14:p};
//   #MGPN @PLACE(64, 2);
//   #MGPN @ORIENT("R0");
//   #MGPN:1 @TEXT("${net}", key="netname", size=0.6, halign="start", valign="middle", rotate=90, dx=0, dy=0.4);
//   #MGPN:2 @TEXT("${net}", key="netname", size=0.6, halign="end", valign="middle", dx=-0.4, dy=0);
//   %g15 = $GROUND @ATTACH &VREFN => @PLACE(64, -3.2);
//   &VREFN @WIRE {#MGPN:3 (64, 0) %g15:p};
//   %g16 = $GROUND @ATTACH &VSS => @PLACE(67, -1.2);
//   &VSS @WIRE {#MGPN:4 (67, 2) %g16:p};
//   #MGPP @PLACE(64, 12);
//   #MGPP @ORIENT("R0");
//   #MGPP:1 @TEXT("${net}", key="netname", size=0.6, halign="end", valign="middle", rotate=90, dx=0, dy=-0.4);
//   #MGPP:2 @TEXT("${net}", key="netname", size=0.6, halign="end", valign="middle", dx=-0.4, dy=0);
//   %v17 = $SUPPLY @ATTACH &VREFP => @PLACE(64, 17.2);
//   &VREFP @WIRE {#MGPP:3 (64, 14) %v17:p};
//   %v18 = $SUPPLY @ATTACH &VREFP => @PLACE(67, 15.2);
//   &VREFP @WIRE {#MGPP:4 (67, 12) %v18:p};
//   #MGNN @PLACE(160, 2);
//   #MGNN @ORIENT("R0");
//   #MGNN:1 @TEXT("${net}", key="netname", size=0.6, halign="start", valign="middle", rotate=90, dx=0, dy=0.4);
//   #MGNN:2 @TEXT("${net}", key="netname", size=0.6, halign="end", valign="middle", dx=-0.4, dy=0);
//   %g19 = $GROUND @ATTACH &VREFN => @PLACE(160, -3.2);
//   &VREFN @WIRE {#MGNN:3 (160, 0) %g19:p};
//   %g20 = $GROUND @ATTACH &VSS => @PLACE(163, -1.2);
//   &VSS @WIRE {#MGNN:4 (163, 2) %g20:p};
//   #MGNP @PLACE(160, 12);
//   #MGNP @ORIENT("R0");
//   #MGNP:1 @TEXT("${net}", key="netname", size=0.6, halign="end", valign="middle", rotate=90, dx=0, dy=-0.4);
//   #MGNP:2 @TEXT("${net}", key="netname", size=0.6, halign="end", valign="middle", dx=-0.4, dy=0);
//   %v21 = $SUPPLY @ATTACH &VREFP => @PLACE(160, 17.2);
//   &VREFP @WIRE {#MGNP:3 (160, 14) %v21:p};
//   %v22 = $SUPPLY @ATTACH &VREFP => @PLACE(163, 15.2);
//   &VREFP @WIRE {#MGNP:4 (163, 12) %v22:p};
//   #MNOUT @PLACE(200, 0);
//   #MNOUT @ORIENT("R0");
//   #MNOUT:1 @TEXT("${net}", key="netname", size=0.6, halign="start", valign="middle", rotate=90, dx=0, dy=0.4);
//   #MNOUT:2 @TEXT("${net}", key="netname", size=0.6, halign="end", valign="middle", dx=-0.4, dy=0);
//   %g23 = $GROUND @ATTACH &VREFN => @PLACE(200, -5.2);
//   &VREFN @WIRE {#MNOUT:3 (200, -2) %g23:p};
//   %g24 = $GROUND @ATTACH &VSS => @PLACE(203, -3.2);
//   &VSS @WIRE {#MNOUT:4 (203, 0) %g24:p};
//   #MPOUT @PLACE(200, 22);
//   #MPOUT @ORIENT("R0");
//   #MPOUT:1 @TEXT("${net}", key="netname", size=0.6, halign="end", valign="middle", rotate=90, dx=0, dy=-0.4);
//   #MPOUT:2 @TEXT("${net}", key="netname", size=0.6, halign="end", valign="middle", dx=-0.4, dy=0);
//   %v25 = $SUPPLY @ATTACH &VREFP => @PLACE(200, 27.2);
//   &VREFP @WIRE {#MPOUT:3 (200, 24) %v25:p};
//   %v26 = $SUPPLY @ATTACH &VREFP => @PLACE(203, 25.2);
//   &VREFP @WIRE {#MPOUT:4 (203, 22) %v26:p};
//   &GP @WIRE {#MGPN:1 #MGPP:1};
//   &PCOND @WIRE {#MGPN:2 (59, 2) (59, 12) #MGPP:2};
//   &GN @WIRE {#MGNN:1 #MGNP:1};
//   &NOFF @WIRE {#MGNN:2 (155, 2) (155, 12) #MGNP:2};
//   &AP @WIRE {#MPA0:1 #MPA1:3};
//   %pc_bus = (12, 16);
//   $JUNCTION @ATTACH %pc_bus;
//   &PCOND @WIRE {#MNA0:1 (0, 16) %pc_bus (24, 16) #MNA1:1};
//   &PCOND @WIRE {#MPA1:1 %pc_bus};
//   %pc_gate = (59, 7);
//   $JUNCTION @ATTACH %pc_gate;
//   &PCOND @WIRE {%pc_bus (50, 16) (50, 7) %pc_gate};
//   &BN @WIRE {#MNB0:3 #MNB1:1};
//   %no_bus = (108, 22);
//   $JUNCTION @ATTACH %no_bus;
//   &NOFF @WIRE {#MPB0:1 (96, 22) %no_bus (120, 22) #MPB1:1};
//   &NOFF @WIRE {#MNB0:1 %no_bus};
//   %no_gate = (155, 7);
//   $JUNCTION @ATTACH %no_gate;
//   &NOFF @WIRE {%no_bus (146, 22) (146, 7) %no_gate};
//   &BP @WIRE {#MNOUT:1 #MPOUT:1};
//   &GP @WIRE {#MGPN:1 (74, 4) (74, 52) (190, 52) (190, 22) #MPOUT:2};
//   &GN @WIRE {#MGNN:1 (180, 4) (180, 0) #MNOUT:2};
//   %p_hib = $IO_PORT @ATTACH &HIB => @PLACE(5, 26) => @ORIENT("R0");
//   &HIB @WIRE {%p_hib:p #MPA1:2};
//   %p_en = $IO_PORT @ATTACH &EN => @PLACE(89, 30) => @ORIENT("R0");
//   &EN @WIRE {%p_en:p #MPB0:2};
//   %p_enb = $IO_PORT @ATTACH &ENB => @PLACE(5, 40) => @ORIENT("R0");
//   &ENB @WIRE {%p_enb:p #MPA0:2};
//   %p_bp = $IO_PORT @ATTACH &BP => @PLACE(200, 6) => @ORIENT("R270");
//   &BP @WIRE {%p_bp:p #MNOUT:1};
//   (-10, 62) @TEXT("Reference-rail output driver j=6") => @SET-STYLE $title_style
// }
ends mq_cdac_drv6

// Matched half-capacitor pair j=6
subckt mq_cdac_bit6 (DH RL EN ENB TOP VREFP VREFN VSS DVDD)
// CP*: user-specified 5% bottom-plate estimate for every physical MOM unit, not extraction.
// Series tails retain one unit parasitic at MID and one at B.
XHCTL (DH HHIB DVDD VREFN VSS) mq_cdac_ctl_h
XLCTL (RL LHIB DVDD VREFN VSS) mq_cdac_ctl_l
XDH (HHIB EN ENB BH VREFP VREFN VSS DVDD) mq_cdac_drv6
CH (TOP BH) cfmom_2t w=5e-08 s=2.4e-07 nr=6 lr=1.69e-06 stm=2 spm=4 multi=16
CPH (BH VSS) capacitor c=8.018320e-16
XDL (LHIB EN ENB BL VREFP VREFN VSS DVDD) mq_cdac_drv6
CL (TOP BL) cfmom_2t w=5e-08 s=2.4e-07 nr=6 lr=1.69e-06 stm=2 spm=4 multi=16
CPL (BL VSS) capacitor c=8.018320e-16
// @RNL {
//   /* pins connected by net name: the net-name label of rnl-std-fill on every unwired pin, placed below by its key netname */
//   $LABEL_TERMINAL_SET @TEXT("${net}", key="netname", size=0.6);
//   &VSS @ADD-TO $GROUND_NET_SET; &VREFN @ADD-TO $GROUND_NET_SET;
//   &VREFP @ADD-TO $SUPPLY_NET_SET;
//   &DVDD @ADD-TO $SUPPLY_NET_SET;
//   {#CH #CL} @AS $MATCHED;
//   {#XDH #XDL} @AS $MATCHED;
//   #XHCTL @PLACE(-70, 24);
//   #XHCTL @ORIENT("R0");
//   #XHCTL:IN @TEXT("${net}", key="netname", size=0.6, halign="end", valign="middle", dx=-0.4, dy=0);
//   #XHCTL:HIB @TEXT("${net}", key="netname", size=0.6, halign="start", valign="middle", dx=0.4, dy=0);
//   %v1 = $SUPPLY @ATTACH &DVDD => @PLACE(-70, 31.2);
//   &DVDD @WIRE {#XHCTL:DVDD (-70, 28) %v1:p};
//   %g2 = $GROUND @ATTACH &VREFN => @PLACE(-72, 16.8);
//   &VREFN @WIRE {#XHCTL:VREFN (-72, 20) %g2:p};
//   %g3 = $GROUND @ATTACH &VSS => @PLACE(-68, 16.8);
//   &VSS @WIRE {#XHCTL:VSS (-68, 20) %g3:p};
//   #XLCTL @PLACE(-70, -26);
//   #XLCTL @ORIENT("R0");
//   #XLCTL:IN @TEXT("${net}", key="netname", size=0.6, halign="end", valign="middle", dx=-0.4, dy=0);
//   #XLCTL:HIB @TEXT("${net}", key="netname", size=0.6, halign="start", valign="middle", dx=0.4, dy=0);
//   %v4 = $SUPPLY @ATTACH &DVDD => @PLACE(-70, -18.8);
//   &DVDD @WIRE {#XLCTL:DVDD (-70, -22) %v4:p};
//   %g5 = $GROUND @ATTACH &VREFN => @PLACE(-72, -33.2);
//   &VREFN @WIRE {#XLCTL:VREFN (-72, -30) %g5:p};
//   %g6 = $GROUND @ATTACH &VSS => @PLACE(-68, -33.2);
//   &VSS @WIRE {#XLCTL:VSS (-68, -30) %g6:p};
//   #XDH @PLACE(-34, 24);
//   #XDH @ORIENT("R0");
//   #XDH:HIB @TEXT("${net}", key="netname", size=0.6, halign="end", valign="middle", dx=-0.4, dy=0);
//   #XDH:EN @TEXT("${net}", key="netname", size=0.6, halign="end", valign="middle", dx=-0.4, dy=0);
//   #XDH:ENB @TEXT("${net}", key="netname", size=0.6, halign="end", valign="middle", dx=-0.4, dy=0);
//   #XDH:BP @TEXT("${net}", key="netname", size=0.6, halign="start", valign="middle", dx=0.4, dy=0);
//   %v7 = $SUPPLY @ATTACH &VREFP => @PLACE(-36, 32.2);
//   &VREFP @WIRE {#XDH:VREFP (-36, 29) %v7:p};
//   %g8 = $GROUND @ATTACH &VREFN => @PLACE(-36, 15.8);
//   &VREFN @WIRE {#XDH:VREFN (-36, 19) %g8:p};
//   %g9 = $GROUND @ATTACH &VSS => @PLACE(-32, 15.8);
//   &VSS @WIRE {#XDH:VSS (-32, 19) %g9:p};
//   %v10 = $SUPPLY @ATTACH &DVDD => @PLACE(-32, 32.2);
//   &DVDD @WIRE {#XDH:DVDD (-32, 29) %v10:p};
//   #CH @PLACE(14, 24) => @ORIENT("R270");
//   #CH:1 @TEXT("${net}", key="netname", size=0.6, halign="start", valign="middle", dx=0.4, dy=0);
//   #CH:2 @TEXT("${net}", key="netname", size=0.6, halign="end", valign="middle", dx=-0.4, dy=0);
//   #CPH @PLACE(60, 20);
//   #CPH @ORIENT("R0");
//   #CPH:1 @TEXT("${net}", key="netname", size=0.6, halign="start", valign="middle", rotate=90, dx=0, dy=0.4);
//   %g11 = $GROUND @ATTACH &VSS => @PLACE(60, 14.8);
//   &VSS @WIRE {#CPH:2 (60, 18) %g11:p};
//   #XDL @PLACE(-34, -26);
//   #XDL @ORIENT("R0");
//   #XDL:HIB @TEXT("${net}", key="netname", size=0.6, halign="end", valign="middle", dx=-0.4, dy=0);
//   #XDL:EN @TEXT("${net}", key="netname", size=0.6, halign="end", valign="middle", dx=-0.4, dy=0);
//   #XDL:ENB @TEXT("${net}", key="netname", size=0.6, halign="end", valign="middle", dx=-0.4, dy=0);
//   #XDL:BP @TEXT("${net}", key="netname", size=0.6, halign="start", valign="middle", dx=0.4, dy=0);
//   %v12 = $SUPPLY @ATTACH &VREFP => @PLACE(-36, -17.8);
//   &VREFP @WIRE {#XDL:VREFP (-36, -21) %v12:p};
//   %g13 = $GROUND @ATTACH &VREFN => @PLACE(-36, -34.2);
//   &VREFN @WIRE {#XDL:VREFN (-36, -31) %g13:p};
//   %g14 = $GROUND @ATTACH &VSS => @PLACE(-32, -34.2);
//   &VSS @WIRE {#XDL:VSS (-32, -31) %g14:p};
//   %v15 = $SUPPLY @ATTACH &DVDD => @PLACE(-32, -17.8);
//   &DVDD @WIRE {#XDL:DVDD (-32, -21) %v15:p};
//   #CL @PLACE(14, -26) => @ORIENT("R270");
//   #CL:1 @TEXT("${net}", key="netname", size=0.6, halign="start", valign="middle", dx=0.4, dy=0);
//   #CL:2 @TEXT("${net}", key="netname", size=0.6, halign="end", valign="middle", dx=-0.4, dy=0);
//   #CPL @PLACE(60, -30);
//   #CPL @ORIENT("R0");
//   #CPL:1 @TEXT("${net}", key="netname", size=0.6, halign="start", valign="middle", rotate=90, dx=0, dy=0.4);
//   %g16 = $GROUND @ATTACH &VSS => @PLACE(60, -35.2);
//   &VSS @WIRE {#CPL:2 (60, -32) %g16:p};
//   &HHIB @WIRE {#XHCTL:HIB (-52, 24) (-52, 26) #XDH:HIB};
//   %b_H = (-12, 24);
//   $JUNCTION @ATTACH %b_H;
//   &BH @WIRE {#XDH:BP %b_H};
//   &BH @WIRE {%b_H #CH:2};
//   &LHIB @WIRE {#XLCTL:HIB (-52, -26) (-52, -24) #XDL:HIB};
//   %b_L = (-12, -26);
//   $JUNCTION @ATTACH %b_L;
//   &BL @WIRE {#XDL:BP %b_L};
//   &BL @WIRE {%b_L #CL:2};
//   %top_H = (44, 24);
//   $JUNCTION @ATTACH %top_H;
//   %top_L = (44, -26);
//   $JUNCTION @ATTACH %top_L;
//   &TOP @WIRE {#CH:1 %top_H};
//   &TOP @WIRE {#CL:1 %top_L};
//   &TOP @WIRE {%top_H %top_L};
//   %p_dh = $IO_PORT @ATTACH &DH => @PLACE(-81, 24) => @ORIENT("R0");
//   &DH @WIRE {%p_dh:p #XHCTL:IN};
//   %p_rl = $IO_PORT @ATTACH &RL => @PLACE(-81, -26) => @ORIENT("R0");
//   &RL @WIRE {%p_rl:p #XLCTL:IN};
//   %p_en = $IO_PORT @ATTACH &EN => @PLACE(-45, 24) => @ORIENT("R0");
//   &EN @WIRE {%p_en:p #XDH:EN};
//   %p_enb = $IO_PORT @ATTACH &ENB => @PLACE(-45, 22) => @ORIENT("R0");
//   &ENB @WIRE {%p_enb:p #XDH:ENB};
//   %p_top = $IO_PORT @ATTACH &TOP => @PLACE(20, 24) => @ORIENT("MY");
//   &TOP @WIRE {%p_top:p #CH:1};
//   (-10, 46) @TEXT("Matched half-capacitor pair j=6") => @SET-STYLE $title_style
// }
ends mq_cdac_bit6

// Reference-rail output driver j=5
subckt mq_cdac_drv5 (HIB EN ENB BP VREFP VREFN VSS DVDD)
// DVDD prelogic: PCOND = NOR(ENB,HIB); NOFF = NAND(EN,HIB).
// Reference-powered final inverters restore GP and GN to VREFP/VREFN.
// Actual current overlap, settling and device stress require measurement.
MPA0 (AP ENB DVDD DVDD) pch_ulvt_mac w=2.4e-07 l=3e-08 nf=1
MPA1 (PCOND HIB AP DVDD) pch_ulvt_mac w=2.4e-07 l=3e-08 nf=1
MNA0 (PCOND ENB VREFN VSS) nch_ulvt_mac w=1.2e-07 l=3e-08 nf=1
MNA1 (PCOND HIB VREFN VSS) nch_ulvt_mac w=1.2e-07 l=3e-08 nf=1
MPB0 (NOFF EN DVDD DVDD) pch_ulvt_mac w=1.2e-07 l=3e-08 nf=1
MPB1 (NOFF HIB DVDD DVDD) pch_ulvt_mac w=1.2e-07 l=3e-08 nf=1
MNB0 (NOFF EN BN VSS) nch_ulvt_mac w=1.2e-07 l=3e-08 nf=1
MNB1 (BN HIB VREFN VSS) nch_ulvt_mac w=1.2e-07 l=3e-08 nf=1
MGPN (GP PCOND VREFN VSS) nch_mac w=2.4e-07 l=3e-08 nf=1
MGPP (GP PCOND VREFP VREFP) pch_mac w=3.6e-07 l=3e-08 nf=1
MGNN (GN NOFF VREFN VSS) nch_mac w=2.4e-07 l=3e-08 nf=1
MGNP (GN NOFF VREFP VREFP) pch_mac w=1.2e-07 l=3e-08 nf=1
MNOUT (BP GN VREFN VSS) nch_mac w=4.5e-07 l=3e-08 nf=1
MPOUT (BP GP VREFP VREFP) pch_mac w=9e-07 l=3e-08 nf=1
// @RNL {
//   /* pins connected by net name: the net-name label of rnl-std-fill on every unwired pin, placed below by its key netname */
//   $LABEL_TERMINAL_SET @TEXT("${net}", key="netname", size=0.6);
//   &VSS @ADD-TO $GROUND_NET_SET; &VREFN @ADD-TO $GROUND_NET_SET;
//   &VREFP @ADD-TO $SUPPLY_NET_SET;
//   &DVDD @ADD-TO $SUPPLY_NET_SET;
//   {#MPA0 #MPA1 #MNA0 #MNA1} @GROUP;
//   {#MPB0 #MPB1 #MNB0 #MNB1} @GROUP;
//   {#MGPN #MGPP} @GROUP;
//   {#MGNN #MGNP} @GROUP;
//   {#MNOUT #MPOUT} @GROUP;
//   #MPA0 @PLACE(12, 40);
//   #MPA0 @ORIENT("R0");
//   #MPA0:1 @TEXT("${net}", key="netname", size=0.6, halign="end", valign="middle", rotate=90, dx=0, dy=-0.4);
//   #MPA0:2 @TEXT("${net}", key="netname", size=0.6, halign="end", valign="middle", dx=-0.4, dy=0);
//   %v1 = $SUPPLY @ATTACH &DVDD => @PLACE(12, 45.2);
//   &DVDD @WIRE {#MPA0:3 (12, 42) %v1:p};
//   %v2 = $SUPPLY @ATTACH &DVDD => @PLACE(15, 43.2);
//   &DVDD @WIRE {#MPA0:4 (15, 40) %v2:p};
//   #MPA1 @PLACE(12, 26);
//   #MPA1 @ORIENT("R0");
//   #MPA1:1 @TEXT("${net}", key="netname", size=0.6, halign="end", valign="middle", rotate=90, dx=0, dy=-0.4);
//   #MPA1:2 @TEXT("${net}", key="netname", size=0.6, halign="end", valign="middle", dx=-0.4, dy=0);
//   #MPA1:3 @TEXT("${net}", key="netname", size=0.6, halign="start", valign="middle", rotate=90, dx=0, dy=0.4);
//   %v3 = $SUPPLY @ATTACH &DVDD => @PLACE(15, 29.2);
//   &DVDD @WIRE {#MPA1:4 (15, 26) %v3:p};
//   #MNA0 @PLACE(0, 2);
//   #MNA0 @ORIENT("R0");
//   #MNA0:1 @TEXT("${net}", key="netname", size=0.6, halign="start", valign="middle", rotate=90, dx=0, dy=0.4);
//   #MNA0:2 @TEXT("${net}", key="netname", size=0.6, halign="end", valign="middle", dx=-0.4, dy=0);
//   %g4 = $GROUND @ATTACH &VREFN => @PLACE(0, -3.2);
//   &VREFN @WIRE {#MNA0:3 (0, 0) %g4:p};
//   %g5 = $GROUND @ATTACH &VSS => @PLACE(3, -1.2);
//   &VSS @WIRE {#MNA0:4 (3, 2) %g5:p};
//   #MNA1 @PLACE(24, 2);
//   #MNA1 @ORIENT("R0");
//   #MNA1:1 @TEXT("${net}", key="netname", size=0.6, halign="start", valign="middle", rotate=90, dx=0, dy=0.4);
//   #MNA1:2 @TEXT("${net}", key="netname", size=0.6, halign="end", valign="middle", dx=-0.4, dy=0);
//   %g6 = $GROUND @ATTACH &VREFN => @PLACE(24, -3.2);
//   &VREFN @WIRE {#MNA1:3 (24, 0) %g6:p};
//   %g7 = $GROUND @ATTACH &VSS => @PLACE(27, -1.2);
//   &VSS @WIRE {#MNA1:4 (27, 2) %g7:p};
//   #MPB0 @PLACE(96, 30);
//   #MPB0 @ORIENT("R0");
//   #MPB0:1 @TEXT("${net}", key="netname", size=0.6, halign="end", valign="middle", rotate=90, dx=0, dy=-0.4);
//   #MPB0:2 @TEXT("${net}", key="netname", size=0.6, halign="end", valign="middle", dx=-0.4, dy=0);
//   %v8 = $SUPPLY @ATTACH &DVDD => @PLACE(96, 35.2);
//   &DVDD @WIRE {#MPB0:3 (96, 32) %v8:p};
//   %v9 = $SUPPLY @ATTACH &DVDD => @PLACE(99, 33.2);
//   &DVDD @WIRE {#MPB0:4 (99, 30) %v9:p};
//   #MPB1 @PLACE(120, 30);
//   #MPB1 @ORIENT("R0");
//   #MPB1:1 @TEXT("${net}", key="netname", size=0.6, halign="end", valign="middle", rotate=90, dx=0, dy=-0.4);
//   #MPB1:2 @TEXT("${net}", key="netname", size=0.6, halign="end", valign="middle", dx=-0.4, dy=0);
//   %v10 = $SUPPLY @ATTACH &DVDD => @PLACE(120, 35.2);
//   &DVDD @WIRE {#MPB1:3 (120, 32) %v10:p};
//   %v11 = $SUPPLY @ATTACH &DVDD => @PLACE(123, 33.2);
//   &DVDD @WIRE {#MPB1:4 (123, 30) %v11:p};
//   #MNB0 @PLACE(108, 12);
//   #MNB0 @ORIENT("R0");
//   #MNB0:1 @TEXT("${net}", key="netname", size=0.6, halign="start", valign="middle", rotate=90, dx=0, dy=0.4);
//   #MNB0:2 @TEXT("${net}", key="netname", size=0.6, halign="end", valign="middle", dx=-0.4, dy=0);
//   #MNB0:3 @TEXT("${net}", key="netname", size=0.6, halign="end", valign="middle", rotate=90, dx=0, dy=-0.4);
//   %g12 = $GROUND @ATTACH &VSS => @PLACE(111, 8.8);
//   &VSS @WIRE {#MNB0:4 (111, 12) %g12:p};
//   #MNB1 @PLACE(108, -2);
//   #MNB1 @ORIENT("R0");
//   #MNB1:1 @TEXT("${net}", key="netname", size=0.6, halign="start", valign="middle", rotate=90, dx=0, dy=0.4);
//   #MNB1:2 @TEXT("${net}", key="netname", size=0.6, halign="end", valign="middle", dx=-0.4, dy=0);
//   %g13 = $GROUND @ATTACH &VREFN => @PLACE(108, -7.2);
//   &VREFN @WIRE {#MNB1:3 (108, -4) %g13:p};
//   %g14 = $GROUND @ATTACH &VSS => @PLACE(111, -5.2);
//   &VSS @WIRE {#MNB1:4 (111, -2) %g14:p};
//   #MGPN @PLACE(64, 2);
//   #MGPN @ORIENT("R0");
//   #MGPN:1 @TEXT("${net}", key="netname", size=0.6, halign="start", valign="middle", rotate=90, dx=0, dy=0.4);
//   #MGPN:2 @TEXT("${net}", key="netname", size=0.6, halign="end", valign="middle", dx=-0.4, dy=0);
//   %g15 = $GROUND @ATTACH &VREFN => @PLACE(64, -3.2);
//   &VREFN @WIRE {#MGPN:3 (64, 0) %g15:p};
//   %g16 = $GROUND @ATTACH &VSS => @PLACE(67, -1.2);
//   &VSS @WIRE {#MGPN:4 (67, 2) %g16:p};
//   #MGPP @PLACE(64, 12);
//   #MGPP @ORIENT("R0");
//   #MGPP:1 @TEXT("${net}", key="netname", size=0.6, halign="end", valign="middle", rotate=90, dx=0, dy=-0.4);
//   #MGPP:2 @TEXT("${net}", key="netname", size=0.6, halign="end", valign="middle", dx=-0.4, dy=0);
//   %v17 = $SUPPLY @ATTACH &VREFP => @PLACE(64, 17.2);
//   &VREFP @WIRE {#MGPP:3 (64, 14) %v17:p};
//   %v18 = $SUPPLY @ATTACH &VREFP => @PLACE(67, 15.2);
//   &VREFP @WIRE {#MGPP:4 (67, 12) %v18:p};
//   #MGNN @PLACE(160, 2);
//   #MGNN @ORIENT("R0");
//   #MGNN:1 @TEXT("${net}", key="netname", size=0.6, halign="start", valign="middle", rotate=90, dx=0, dy=0.4);
//   #MGNN:2 @TEXT("${net}", key="netname", size=0.6, halign="end", valign="middle", dx=-0.4, dy=0);
//   %g19 = $GROUND @ATTACH &VREFN => @PLACE(160, -3.2);
//   &VREFN @WIRE {#MGNN:3 (160, 0) %g19:p};
//   %g20 = $GROUND @ATTACH &VSS => @PLACE(163, -1.2);
//   &VSS @WIRE {#MGNN:4 (163, 2) %g20:p};
//   #MGNP @PLACE(160, 12);
//   #MGNP @ORIENT("R0");
//   #MGNP:1 @TEXT("${net}", key="netname", size=0.6, halign="end", valign="middle", rotate=90, dx=0, dy=-0.4);
//   #MGNP:2 @TEXT("${net}", key="netname", size=0.6, halign="end", valign="middle", dx=-0.4, dy=0);
//   %v21 = $SUPPLY @ATTACH &VREFP => @PLACE(160, 17.2);
//   &VREFP @WIRE {#MGNP:3 (160, 14) %v21:p};
//   %v22 = $SUPPLY @ATTACH &VREFP => @PLACE(163, 15.2);
//   &VREFP @WIRE {#MGNP:4 (163, 12) %v22:p};
//   #MNOUT @PLACE(200, 0);
//   #MNOUT @ORIENT("R0");
//   #MNOUT:1 @TEXT("${net}", key="netname", size=0.6, halign="start", valign="middle", rotate=90, dx=0, dy=0.4);
//   #MNOUT:2 @TEXT("${net}", key="netname", size=0.6, halign="end", valign="middle", dx=-0.4, dy=0);
//   %g23 = $GROUND @ATTACH &VREFN => @PLACE(200, -5.2);
//   &VREFN @WIRE {#MNOUT:3 (200, -2) %g23:p};
//   %g24 = $GROUND @ATTACH &VSS => @PLACE(203, -3.2);
//   &VSS @WIRE {#MNOUT:4 (203, 0) %g24:p};
//   #MPOUT @PLACE(200, 22);
//   #MPOUT @ORIENT("R0");
//   #MPOUT:1 @TEXT("${net}", key="netname", size=0.6, halign="end", valign="middle", rotate=90, dx=0, dy=-0.4);
//   #MPOUT:2 @TEXT("${net}", key="netname", size=0.6, halign="end", valign="middle", dx=-0.4, dy=0);
//   %v25 = $SUPPLY @ATTACH &VREFP => @PLACE(200, 27.2);
//   &VREFP @WIRE {#MPOUT:3 (200, 24) %v25:p};
//   %v26 = $SUPPLY @ATTACH &VREFP => @PLACE(203, 25.2);
//   &VREFP @WIRE {#MPOUT:4 (203, 22) %v26:p};
//   &GP @WIRE {#MGPN:1 #MGPP:1};
//   &PCOND @WIRE {#MGPN:2 (59, 2) (59, 12) #MGPP:2};
//   &GN @WIRE {#MGNN:1 #MGNP:1};
//   &NOFF @WIRE {#MGNN:2 (155, 2) (155, 12) #MGNP:2};
//   &AP @WIRE {#MPA0:1 #MPA1:3};
//   %pc_bus = (12, 16);
//   $JUNCTION @ATTACH %pc_bus;
//   &PCOND @WIRE {#MNA0:1 (0, 16) %pc_bus (24, 16) #MNA1:1};
//   &PCOND @WIRE {#MPA1:1 %pc_bus};
//   %pc_gate = (59, 7);
//   $JUNCTION @ATTACH %pc_gate;
//   &PCOND @WIRE {%pc_bus (50, 16) (50, 7) %pc_gate};
//   &BN @WIRE {#MNB0:3 #MNB1:1};
//   %no_bus = (108, 22);
//   $JUNCTION @ATTACH %no_bus;
//   &NOFF @WIRE {#MPB0:1 (96, 22) %no_bus (120, 22) #MPB1:1};
//   &NOFF @WIRE {#MNB0:1 %no_bus};
//   %no_gate = (155, 7);
//   $JUNCTION @ATTACH %no_gate;
//   &NOFF @WIRE {%no_bus (146, 22) (146, 7) %no_gate};
//   &BP @WIRE {#MNOUT:1 #MPOUT:1};
//   &GP @WIRE {#MGPN:1 (74, 4) (74, 52) (190, 52) (190, 22) #MPOUT:2};
//   &GN @WIRE {#MGNN:1 (180, 4) (180, 0) #MNOUT:2};
//   %p_hib = $IO_PORT @ATTACH &HIB => @PLACE(5, 26) => @ORIENT("R0");
//   &HIB @WIRE {%p_hib:p #MPA1:2};
//   %p_en = $IO_PORT @ATTACH &EN => @PLACE(89, 30) => @ORIENT("R0");
//   &EN @WIRE {%p_en:p #MPB0:2};
//   %p_enb = $IO_PORT @ATTACH &ENB => @PLACE(5, 40) => @ORIENT("R0");
//   &ENB @WIRE {%p_enb:p #MPA0:2};
//   %p_bp = $IO_PORT @ATTACH &BP => @PLACE(200, 6) => @ORIENT("R270");
//   &BP @WIRE {%p_bp:p #MNOUT:1};
//   (-10, 62) @TEXT("Reference-rail output driver j=5") => @SET-STYLE $title_style
// }
ends mq_cdac_drv5

// Matched half-capacitor pair j=5
subckt mq_cdac_bit5 (VIN VG DH RL EN ENB TOP VREFP VREFN VSS DVDD EQBUS APGATE)
// CP*: user-specified 5% bottom-plate estimate for every physical MOM unit, not extraction.
// Series tails retain one unit parasitic at MID and one at B.
// APGATE PMOS assist connects each bottom plate to VIN.
// Additional ENB NMOS sharing retains a common EQBUS.
XHCTL (DH HHIB DVDD VREFN VSS) mq_cdac_ctl_h
XLCTL (RL LHIB DVDD VREFN VSS) mq_cdac_ctl_l
XDH (HHIB EN ENB BH VREFP VREFN VSS DVDD) mq_cdac_drv5
CH (TOP BH) cfmom_2t w=5e-08 s=2.4e-07 nr=6 lr=1.69e-06 stm=2 spm=4 multi=9
CPH (BH VSS) capacitor c=4.510305e-16
MSH (BH VG VIN VSS) nch_ulvt_mac w=2.1e-07 l=3e-08 nf=1
XDL (LHIB EN ENB BL VREFP VREFN VSS DVDD) mq_cdac_drv5
CL (TOP BL) cfmom_2t w=5e-08 s=2.4e-07 nr=6 lr=1.69e-06 stm=2 spm=4 multi=9
CPL (BL VSS) capacitor c=4.510305e-16
MSL (BL VG VIN VSS) nch_ulvt_mac w=2.1e-07 l=3e-08 nf=1
MEQ1 (BH APGATE VIN VREFP) pch_ulvt_mac w=2.1e-07 l=3e-08 nf=1
MEQ2 (BL APGATE VIN VREFP) pch_ulvt_mac w=2.1e-07 l=3e-08 nf=1
MSHAREH (BH ENB EQBUS VSS) nch_ulvt_mac w=2.1e-07 l=3e-08 nf=1
MSHAREL (BL ENB EQBUS VSS) nch_ulvt_mac w=2.1e-07 l=3e-08 nf=1
// @RNL {
//   /* pins connected by net name: the net-name label of rnl-std-fill on every unwired pin, placed below by its key netname */
//   $LABEL_TERMINAL_SET @TEXT("${net}", key="netname", size=0.6);
//   &VSS @ADD-TO $GROUND_NET_SET; &VREFN @ADD-TO $GROUND_NET_SET;
//   &VREFP @ADD-TO $SUPPLY_NET_SET;
//   &DVDD @ADD-TO $SUPPLY_NET_SET;
//   {#CH #CL} @AS $MATCHED;
//   {#MSH #MSL} @AS $MATCHED;
//   {#MEQ1 #MEQ2} @AS $MATCHED;
//   {#MSHAREH #MSHAREL} @AS $MATCHED;
//   {#XDH #XDL} @AS $MATCHED;
//   #XHCTL @PLACE(-70, 24);
//   #XHCTL @ORIENT("R0");
//   #XHCTL:IN @TEXT("${net}", key="netname", size=0.6, halign="end", valign="middle", dx=-0.4, dy=0);
//   #XHCTL:HIB @TEXT("${net}", key="netname", size=0.6, halign="start", valign="middle", dx=0.4, dy=0);
//   %v1 = $SUPPLY @ATTACH &DVDD => @PLACE(-70, 31.2);
//   &DVDD @WIRE {#XHCTL:DVDD (-70, 28) %v1:p};
//   %g2 = $GROUND @ATTACH &VREFN => @PLACE(-72, 16.8);
//   &VREFN @WIRE {#XHCTL:VREFN (-72, 20) %g2:p};
//   %g3 = $GROUND @ATTACH &VSS => @PLACE(-68, 16.8);
//   &VSS @WIRE {#XHCTL:VSS (-68, 20) %g3:p};
//   #XLCTL @PLACE(-70, -26);
//   #XLCTL @ORIENT("R0");
//   #XLCTL:IN @TEXT("${net}", key="netname", size=0.6, halign="end", valign="middle", dx=-0.4, dy=0);
//   #XLCTL:HIB @TEXT("${net}", key="netname", size=0.6, halign="start", valign="middle", dx=0.4, dy=0);
//   %v4 = $SUPPLY @ATTACH &DVDD => @PLACE(-70, -18.8);
//   &DVDD @WIRE {#XLCTL:DVDD (-70, -22) %v4:p};
//   %g5 = $GROUND @ATTACH &VREFN => @PLACE(-72, -33.2);
//   &VREFN @WIRE {#XLCTL:VREFN (-72, -30) %g5:p};
//   %g6 = $GROUND @ATTACH &VSS => @PLACE(-68, -33.2);
//   &VSS @WIRE {#XLCTL:VSS (-68, -30) %g6:p};
//   #XDH @PLACE(-34, 24);
//   #XDH @ORIENT("R0");
//   #XDH:HIB @TEXT("${net}", key="netname", size=0.6, halign="end", valign="middle", dx=-0.4, dy=0);
//   #XDH:EN @TEXT("${net}", key="netname", size=0.6, halign="end", valign="middle", dx=-0.4, dy=0);
//   #XDH:ENB @TEXT("${net}", key="netname", size=0.6, halign="end", valign="middle", dx=-0.4, dy=0);
//   #XDH:BP @TEXT("${net}", key="netname", size=0.6, halign="start", valign="middle", dx=0.4, dy=0);
//   %v7 = $SUPPLY @ATTACH &VREFP => @PLACE(-36, 32.2);
//   &VREFP @WIRE {#XDH:VREFP (-36, 29) %v7:p};
//   %g8 = $GROUND @ATTACH &VREFN => @PLACE(-36, 15.8);
//   &VREFN @WIRE {#XDH:VREFN (-36, 19) %g8:p};
//   %g9 = $GROUND @ATTACH &VSS => @PLACE(-32, 15.8);
//   &VSS @WIRE {#XDH:VSS (-32, 19) %g9:p};
//   %v10 = $SUPPLY @ATTACH &DVDD => @PLACE(-32, 32.2);
//   &DVDD @WIRE {#XDH:DVDD (-32, 29) %v10:p};
//   #CH @PLACE(14, 24) => @ORIENT("R270");
//   #CH:1 @TEXT("${net}", key="netname", size=0.6, halign="start", valign="middle", dx=0.4, dy=0);
//   #CH:2 @TEXT("${net}", key="netname", size=0.6, halign="end", valign="middle", dx=-0.4, dy=0);
//   #CPH @PLACE(60, 20);
//   #CPH @ORIENT("R0");
//   #CPH:1 @TEXT("${net}", key="netname", size=0.6, halign="start", valign="middle", rotate=90, dx=0, dy=0.4);
//   %g11 = $GROUND @ATTACH &VSS => @PLACE(60, 14.8);
//   &VSS @WIRE {#CPH:2 (60, 18) %g11:p};
//   #MSH @PLACE(2, 8);
//   #MSH @ORIENT("R0");
//   #MSH:1 @TEXT("${net}", key="netname", size=0.6, halign="start", valign="middle", rotate=90, dx=0, dy=0.4);
//   #MSH:2 @TEXT("${net}", key="netname", size=0.6, halign="end", valign="middle", dx=-0.4, dy=0);
//   #MSH:3 @TEXT("${net}", key="netname", size=0.6, halign="end", valign="middle", rotate=90, dx=0, dy=-0.4);
//   %g12 = $GROUND @ATTACH &VSS => @PLACE(5, 4.8);
//   &VSS @WIRE {#MSH:4 (5, 8) %g12:p};
//   #XDL @PLACE(-34, -26);
//   #XDL @ORIENT("R0");
//   #XDL:HIB @TEXT("${net}", key="netname", size=0.6, halign="end", valign="middle", dx=-0.4, dy=0);
//   #XDL:EN @TEXT("${net}", key="netname", size=0.6, halign="end", valign="middle", dx=-0.4, dy=0);
//   #XDL:ENB @TEXT("${net}", key="netname", size=0.6, halign="end", valign="middle", dx=-0.4, dy=0);
//   #XDL:BP @TEXT("${net}", key="netname", size=0.6, halign="start", valign="middle", dx=0.4, dy=0);
//   %v13 = $SUPPLY @ATTACH &VREFP => @PLACE(-36, -17.8);
//   &VREFP @WIRE {#XDL:VREFP (-36, -21) %v13:p};
//   %g14 = $GROUND @ATTACH &VREFN => @PLACE(-36, -34.2);
//   &VREFN @WIRE {#XDL:VREFN (-36, -31) %g14:p};
//   %g15 = $GROUND @ATTACH &VSS => @PLACE(-32, -34.2);
//   &VSS @WIRE {#XDL:VSS (-32, -31) %g15:p};
//   %v16 = $SUPPLY @ATTACH &DVDD => @PLACE(-32, -17.8);
//   &DVDD @WIRE {#XDL:DVDD (-32, -21) %v16:p};
//   #CL @PLACE(14, -26) => @ORIENT("R270");
//   #CL:1 @TEXT("${net}", key="netname", size=0.6, halign="start", valign="middle", dx=0.4, dy=0);
//   #CL:2 @TEXT("${net}", key="netname", size=0.6, halign="end", valign="middle", dx=-0.4, dy=0);
//   #CPL @PLACE(60, -30);
//   #CPL @ORIENT("R0");
//   #CPL:1 @TEXT("${net}", key="netname", size=0.6, halign="start", valign="middle", rotate=90, dx=0, dy=0.4);
//   %g17 = $GROUND @ATTACH &VSS => @PLACE(60, -35.2);
//   &VSS @WIRE {#CPL:2 (60, -32) %g17:p};
//   #MSL @PLACE(2, -42);
//   #MSL @ORIENT("R0");
//   #MSL:1 @TEXT("${net}", key="netname", size=0.6, halign="start", valign="middle", rotate=90, dx=0, dy=0.4);
//   #MSL:2 @TEXT("${net}", key="netname", size=0.6, halign="end", valign="middle", dx=-0.4, dy=0);
//   #MSL:3 @TEXT("${net}", key="netname", size=0.6, halign="end", valign="middle", rotate=90, dx=0, dy=-0.4);
//   %g18 = $GROUND @ATTACH &VSS => @PLACE(5, -45.2);
//   &VSS @WIRE {#MSL:4 (5, -42) %g18:p};
//   #MEQ1 @PLACE(-12, 0);
//   #MEQ1 @ORIENT("R0");
//   #MEQ1:1 @TEXT("${net}", key="netname", size=0.6, halign="end", valign="middle", rotate=90, dx=0, dy=-0.4);
//   #MEQ1:2 @TEXT("${net}", key="netname", size=0.6, halign="end", valign="middle", dx=-0.4, dy=0);
//   #MEQ1:3 @TEXT("${net}", key="netname", size=0.6, halign="start", valign="middle", rotate=90, dx=0, dy=0.4);
//   %v19 = $SUPPLY @ATTACH &VREFP => @PLACE(-9, 3.2);
//   &VREFP @WIRE {#MEQ1:4 (-9, 0) %v19:p};
//   #MEQ2 @PLACE(-12, -50);
//   #MEQ2 @ORIENT("R0");
//   #MEQ2:1 @TEXT("${net}", key="netname", size=0.6, halign="end", valign="middle", rotate=90, dx=0, dy=-0.4);
//   #MEQ2:2 @TEXT("${net}", key="netname", size=0.6, halign="end", valign="middle", dx=-0.4, dy=0);
//   #MEQ2:3 @TEXT("${net}", key="netname", size=0.6, halign="start", valign="middle", rotate=90, dx=0, dy=0.4);
//   %v20 = $SUPPLY @ATTACH &VREFP => @PLACE(-9, -46.8);
//   &VREFP @WIRE {#MEQ2:4 (-9, -50) %v20:p};
//   #MSHAREH @PLACE(56, -2);
//   #MSHAREH @ORIENT("R0");
//   #MSHAREH:1 @TEXT("${net}", key="netname", size=0.6, halign="start", valign="middle", rotate=90, dx=0, dy=0.4);
//   #MSHAREH:2 @TEXT("${net}", key="netname", size=0.6, halign="end", valign="middle", dx=-0.4, dy=0);
//   #MSHAREH:3 @TEXT("${net}", key="netname", size=0.6, halign="end", valign="middle", rotate=90, dx=0, dy=-0.4);
//   %g21 = $GROUND @ATTACH &VSS => @PLACE(59, -5.2);
//   &VSS @WIRE {#MSHAREH:4 (59, -2) %g21:p};
//   #MSHAREL @PLACE(56, -52);
//   #MSHAREL @ORIENT("R0");
//   #MSHAREL:1 @TEXT("${net}", key="netname", size=0.6, halign="start", valign="middle", rotate=90, dx=0, dy=0.4);
//   #MSHAREL:2 @TEXT("${net}", key="netname", size=0.6, halign="end", valign="middle", dx=-0.4, dy=0);
//   #MSHAREL:3 @TEXT("${net}", key="netname", size=0.6, halign="end", valign="middle", rotate=90, dx=0, dy=-0.4);
//   %g22 = $GROUND @ATTACH &VSS => @PLACE(59, -55.2);
//   &VSS @WIRE {#MSHAREL:4 (59, -52) %g22:p};
//   &HHIB @WIRE {#XHCTL:HIB (-52, 24) (-52, 26) #XDH:HIB};
//   %b_H = (-12, 24);
//   $JUNCTION @ATTACH %b_H;
//   &BH @WIRE {#XDH:BP %b_H};
//   &BH @WIRE {%b_H #CH:2};
//   &BH @WIRE {%b_H (-12, 10) #MSH:1};
//   &BH @WIRE {%b_H #MEQ1:1};
//   &LHIB @WIRE {#XLCTL:HIB (-52, -26) (-52, -24) #XDL:HIB};
//   %b_L = (-12, -26);
//   $JUNCTION @ATTACH %b_L;
//   &BL @WIRE {#XDL:BP %b_L};
//   &BL @WIRE {%b_L #CL:2};
//   &BL @WIRE {%b_L (-12, -40) #MSL:1};
//   &BL @WIRE {%b_L #MEQ2:1};
//   &VIN @WIRE {#MSH:3 (6, 6) (6, -44) #MSL:3};
//   &VG @WIRE {#MSH:2 (-5, 8) (-5, -42) #MSL:2};
//   %top_H = (44, 24);
//   $JUNCTION @ATTACH %top_H;
//   %top_L = (44, -26);
//   $JUNCTION @ATTACH %top_L;
//   &TOP @WIRE {#CH:1 %top_H};
//   &TOP @WIRE {#CL:1 %top_L};
//   &TOP @WIRE {%top_H %top_L};
//   %p_vin = $IO_PORT @ATTACH &VIN => @PLACE(2, 2) => @ORIENT("R90");
//   &VIN @WIRE {%p_vin:p #MSH:3};
//   %p_vg = $IO_PORT @ATTACH &VG => @PLACE(-5, 8) => @ORIENT("R0");
//   &VG @WIRE {%p_vg:p #MSH:2};
//   %p_dh = $IO_PORT @ATTACH &DH => @PLACE(-81, 24) => @ORIENT("R0");
//   &DH @WIRE {%p_dh:p #XHCTL:IN};
//   %p_rl = $IO_PORT @ATTACH &RL => @PLACE(-81, -26) => @ORIENT("R0");
//   &RL @WIRE {%p_rl:p #XLCTL:IN};
//   %p_en = $IO_PORT @ATTACH &EN => @PLACE(-45, 24) => @ORIENT("R0");
//   &EN @WIRE {%p_en:p #XDH:EN};
//   %p_enb = $IO_PORT @ATTACH &ENB => @PLACE(-45, 22) => @ORIENT("R0");
//   &ENB @WIRE {%p_enb:p #XDH:ENB};
//   %p_top = $IO_PORT @ATTACH &TOP => @PLACE(20, 24) => @ORIENT("MY");
//   &TOP @WIRE {%p_top:p #CH:1};
//   %p_eqbus = $IO_PORT @ATTACH &EQBUS => @PLACE(56, -8) => @ORIENT("R90");
//   &EQBUS @WIRE {%p_eqbus:p #MSHAREH:3};
//   %p_apgate = $IO_PORT @ATTACH &APGATE => @PLACE(-19, 0) => @ORIENT("R0");
//   &APGATE @WIRE {%p_apgate:p #MEQ1:2};
//   (-10, 46) @TEXT("Matched half-capacitor pair j=5") => @SET-STYLE $title_style
// }
ends mq_cdac_bit5

// Reference-rail output driver j=4
subckt mq_cdac_drv4 (HIB EN ENB BP VREFP VREFN VSS DVDD)
// DVDD prelogic: PCOND = NOR(ENB,HIB); NOFF = NAND(EN,HIB).
// Reference-powered final inverters restore GP and GN to VREFP/VREFN.
// Actual current overlap, settling and device stress require measurement.
MPA0 (AP ENB DVDD DVDD) pch_ulvt_mac w=2.4e-07 l=3e-08 nf=1
MPA1 (PCOND HIB AP DVDD) pch_ulvt_mac w=2.4e-07 l=3e-08 nf=1
MNA0 (PCOND ENB VREFN VSS) nch_ulvt_mac w=1.2e-07 l=3e-08 nf=1
MNA1 (PCOND HIB VREFN VSS) nch_ulvt_mac w=1.2e-07 l=3e-08 nf=1
MPB0 (NOFF EN DVDD DVDD) pch_ulvt_mac w=1.2e-07 l=3e-08 nf=1
MPB1 (NOFF HIB DVDD DVDD) pch_ulvt_mac w=1.2e-07 l=3e-08 nf=1
MNB0 (NOFF EN BN VSS) nch_ulvt_mac w=1.2e-07 l=3e-08 nf=1
MNB1 (BN HIB VREFN VSS) nch_ulvt_mac w=1.2e-07 l=3e-08 nf=1
MGPN (GP PCOND VREFN VSS) nch_mac w=2.4e-07 l=3e-08 nf=1
MGPP (GP PCOND VREFP VREFP) pch_mac w=3.6e-07 l=3e-08 nf=1
MGNN (GN NOFF VREFN VSS) nch_mac w=2.4e-07 l=3e-08 nf=1
MGNP (GN NOFF VREFP VREFP) pch_mac w=1.2e-07 l=3e-08 nf=1
MNOUT (BP GN VREFN VSS) nch_mac w=4.5e-07 l=3e-08 nf=1
MPOUT (BP GP VREFP VREFP) pch_mac w=9e-07 l=3e-08 nf=1
// @RNL {
//   /* pins connected by net name: the net-name label of rnl-std-fill on every unwired pin, placed below by its key netname */
//   $LABEL_TERMINAL_SET @TEXT("${net}", key="netname", size=0.6);
//   &VSS @ADD-TO $GROUND_NET_SET; &VREFN @ADD-TO $GROUND_NET_SET;
//   &VREFP @ADD-TO $SUPPLY_NET_SET;
//   &DVDD @ADD-TO $SUPPLY_NET_SET;
//   {#MPA0 #MPA1 #MNA0 #MNA1} @GROUP;
//   {#MPB0 #MPB1 #MNB0 #MNB1} @GROUP;
//   {#MGPN #MGPP} @GROUP;
//   {#MGNN #MGNP} @GROUP;
//   {#MNOUT #MPOUT} @GROUP;
//   #MPA0 @PLACE(12, 40);
//   #MPA0 @ORIENT("R0");
//   #MPA0:1 @TEXT("${net}", key="netname", size=0.6, halign="end", valign="middle", rotate=90, dx=0, dy=-0.4);
//   #MPA0:2 @TEXT("${net}", key="netname", size=0.6, halign="end", valign="middle", dx=-0.4, dy=0);
//   %v1 = $SUPPLY @ATTACH &DVDD => @PLACE(12, 45.2);
//   &DVDD @WIRE {#MPA0:3 (12, 42) %v1:p};
//   %v2 = $SUPPLY @ATTACH &DVDD => @PLACE(15, 43.2);
//   &DVDD @WIRE {#MPA0:4 (15, 40) %v2:p};
//   #MPA1 @PLACE(12, 26);
//   #MPA1 @ORIENT("R0");
//   #MPA1:1 @TEXT("${net}", key="netname", size=0.6, halign="end", valign="middle", rotate=90, dx=0, dy=-0.4);
//   #MPA1:2 @TEXT("${net}", key="netname", size=0.6, halign="end", valign="middle", dx=-0.4, dy=0);
//   #MPA1:3 @TEXT("${net}", key="netname", size=0.6, halign="start", valign="middle", rotate=90, dx=0, dy=0.4);
//   %v3 = $SUPPLY @ATTACH &DVDD => @PLACE(15, 29.2);
//   &DVDD @WIRE {#MPA1:4 (15, 26) %v3:p};
//   #MNA0 @PLACE(0, 2);
//   #MNA0 @ORIENT("R0");
//   #MNA0:1 @TEXT("${net}", key="netname", size=0.6, halign="start", valign="middle", rotate=90, dx=0, dy=0.4);
//   #MNA0:2 @TEXT("${net}", key="netname", size=0.6, halign="end", valign="middle", dx=-0.4, dy=0);
//   %g4 = $GROUND @ATTACH &VREFN => @PLACE(0, -3.2);
//   &VREFN @WIRE {#MNA0:3 (0, 0) %g4:p};
//   %g5 = $GROUND @ATTACH &VSS => @PLACE(3, -1.2);
//   &VSS @WIRE {#MNA0:4 (3, 2) %g5:p};
//   #MNA1 @PLACE(24, 2);
//   #MNA1 @ORIENT("R0");
//   #MNA1:1 @TEXT("${net}", key="netname", size=0.6, halign="start", valign="middle", rotate=90, dx=0, dy=0.4);
//   #MNA1:2 @TEXT("${net}", key="netname", size=0.6, halign="end", valign="middle", dx=-0.4, dy=0);
//   %g6 = $GROUND @ATTACH &VREFN => @PLACE(24, -3.2);
//   &VREFN @WIRE {#MNA1:3 (24, 0) %g6:p};
//   %g7 = $GROUND @ATTACH &VSS => @PLACE(27, -1.2);
//   &VSS @WIRE {#MNA1:4 (27, 2) %g7:p};
//   #MPB0 @PLACE(96, 30);
//   #MPB0 @ORIENT("R0");
//   #MPB0:1 @TEXT("${net}", key="netname", size=0.6, halign="end", valign="middle", rotate=90, dx=0, dy=-0.4);
//   #MPB0:2 @TEXT("${net}", key="netname", size=0.6, halign="end", valign="middle", dx=-0.4, dy=0);
//   %v8 = $SUPPLY @ATTACH &DVDD => @PLACE(96, 35.2);
//   &DVDD @WIRE {#MPB0:3 (96, 32) %v8:p};
//   %v9 = $SUPPLY @ATTACH &DVDD => @PLACE(99, 33.2);
//   &DVDD @WIRE {#MPB0:4 (99, 30) %v9:p};
//   #MPB1 @PLACE(120, 30);
//   #MPB1 @ORIENT("R0");
//   #MPB1:1 @TEXT("${net}", key="netname", size=0.6, halign="end", valign="middle", rotate=90, dx=0, dy=-0.4);
//   #MPB1:2 @TEXT("${net}", key="netname", size=0.6, halign="end", valign="middle", dx=-0.4, dy=0);
//   %v10 = $SUPPLY @ATTACH &DVDD => @PLACE(120, 35.2);
//   &DVDD @WIRE {#MPB1:3 (120, 32) %v10:p};
//   %v11 = $SUPPLY @ATTACH &DVDD => @PLACE(123, 33.2);
//   &DVDD @WIRE {#MPB1:4 (123, 30) %v11:p};
//   #MNB0 @PLACE(108, 12);
//   #MNB0 @ORIENT("R0");
//   #MNB0:1 @TEXT("${net}", key="netname", size=0.6, halign="start", valign="middle", rotate=90, dx=0, dy=0.4);
//   #MNB0:2 @TEXT("${net}", key="netname", size=0.6, halign="end", valign="middle", dx=-0.4, dy=0);
//   #MNB0:3 @TEXT("${net}", key="netname", size=0.6, halign="end", valign="middle", rotate=90, dx=0, dy=-0.4);
//   %g12 = $GROUND @ATTACH &VSS => @PLACE(111, 8.8);
//   &VSS @WIRE {#MNB0:4 (111, 12) %g12:p};
//   #MNB1 @PLACE(108, -2);
//   #MNB1 @ORIENT("R0");
//   #MNB1:1 @TEXT("${net}", key="netname", size=0.6, halign="start", valign="middle", rotate=90, dx=0, dy=0.4);
//   #MNB1:2 @TEXT("${net}", key="netname", size=0.6, halign="end", valign="middle", dx=-0.4, dy=0);
//   %g13 = $GROUND @ATTACH &VREFN => @PLACE(108, -7.2);
//   &VREFN @WIRE {#MNB1:3 (108, -4) %g13:p};
//   %g14 = $GROUND @ATTACH &VSS => @PLACE(111, -5.2);
//   &VSS @WIRE {#MNB1:4 (111, -2) %g14:p};
//   #MGPN @PLACE(64, 2);
//   #MGPN @ORIENT("R0");
//   #MGPN:1 @TEXT("${net}", key="netname", size=0.6, halign="start", valign="middle", rotate=90, dx=0, dy=0.4);
//   #MGPN:2 @TEXT("${net}", key="netname", size=0.6, halign="end", valign="middle", dx=-0.4, dy=0);
//   %g15 = $GROUND @ATTACH &VREFN => @PLACE(64, -3.2);
//   &VREFN @WIRE {#MGPN:3 (64, 0) %g15:p};
//   %g16 = $GROUND @ATTACH &VSS => @PLACE(67, -1.2);
//   &VSS @WIRE {#MGPN:4 (67, 2) %g16:p};
//   #MGPP @PLACE(64, 12);
//   #MGPP @ORIENT("R0");
//   #MGPP:1 @TEXT("${net}", key="netname", size=0.6, halign="end", valign="middle", rotate=90, dx=0, dy=-0.4);
//   #MGPP:2 @TEXT("${net}", key="netname", size=0.6, halign="end", valign="middle", dx=-0.4, dy=0);
//   %v17 = $SUPPLY @ATTACH &VREFP => @PLACE(64, 17.2);
//   &VREFP @WIRE {#MGPP:3 (64, 14) %v17:p};
//   %v18 = $SUPPLY @ATTACH &VREFP => @PLACE(67, 15.2);
//   &VREFP @WIRE {#MGPP:4 (67, 12) %v18:p};
//   #MGNN @PLACE(160, 2);
//   #MGNN @ORIENT("R0");
//   #MGNN:1 @TEXT("${net}", key="netname", size=0.6, halign="start", valign="middle", rotate=90, dx=0, dy=0.4);
//   #MGNN:2 @TEXT("${net}", key="netname", size=0.6, halign="end", valign="middle", dx=-0.4, dy=0);
//   %g19 = $GROUND @ATTACH &VREFN => @PLACE(160, -3.2);
//   &VREFN @WIRE {#MGNN:3 (160, 0) %g19:p};
//   %g20 = $GROUND @ATTACH &VSS => @PLACE(163, -1.2);
//   &VSS @WIRE {#MGNN:4 (163, 2) %g20:p};
//   #MGNP @PLACE(160, 12);
//   #MGNP @ORIENT("R0");
//   #MGNP:1 @TEXT("${net}", key="netname", size=0.6, halign="end", valign="middle", rotate=90, dx=0, dy=-0.4);
//   #MGNP:2 @TEXT("${net}", key="netname", size=0.6, halign="end", valign="middle", dx=-0.4, dy=0);
//   %v21 = $SUPPLY @ATTACH &VREFP => @PLACE(160, 17.2);
//   &VREFP @WIRE {#MGNP:3 (160, 14) %v21:p};
//   %v22 = $SUPPLY @ATTACH &VREFP => @PLACE(163, 15.2);
//   &VREFP @WIRE {#MGNP:4 (163, 12) %v22:p};
//   #MNOUT @PLACE(200, 0);
//   #MNOUT @ORIENT("R0");
//   #MNOUT:1 @TEXT("${net}", key="netname", size=0.6, halign="start", valign="middle", rotate=90, dx=0, dy=0.4);
//   #MNOUT:2 @TEXT("${net}", key="netname", size=0.6, halign="end", valign="middle", dx=-0.4, dy=0);
//   %g23 = $GROUND @ATTACH &VREFN => @PLACE(200, -5.2);
//   &VREFN @WIRE {#MNOUT:3 (200, -2) %g23:p};
//   %g24 = $GROUND @ATTACH &VSS => @PLACE(203, -3.2);
//   &VSS @WIRE {#MNOUT:4 (203, 0) %g24:p};
//   #MPOUT @PLACE(200, 22);
//   #MPOUT @ORIENT("R0");
//   #MPOUT:1 @TEXT("${net}", key="netname", size=0.6, halign="end", valign="middle", rotate=90, dx=0, dy=-0.4);
//   #MPOUT:2 @TEXT("${net}", key="netname", size=0.6, halign="end", valign="middle", dx=-0.4, dy=0);
//   %v25 = $SUPPLY @ATTACH &VREFP => @PLACE(200, 27.2);
//   &VREFP @WIRE {#MPOUT:3 (200, 24) %v25:p};
//   %v26 = $SUPPLY @ATTACH &VREFP => @PLACE(203, 25.2);
//   &VREFP @WIRE {#MPOUT:4 (203, 22) %v26:p};
//   &GP @WIRE {#MGPN:1 #MGPP:1};
//   &PCOND @WIRE {#MGPN:2 (59, 2) (59, 12) #MGPP:2};
//   &GN @WIRE {#MGNN:1 #MGNP:1};
//   &NOFF @WIRE {#MGNN:2 (155, 2) (155, 12) #MGNP:2};
//   &AP @WIRE {#MPA0:1 #MPA1:3};
//   %pc_bus = (12, 16);
//   $JUNCTION @ATTACH %pc_bus;
//   &PCOND @WIRE {#MNA0:1 (0, 16) %pc_bus (24, 16) #MNA1:1};
//   &PCOND @WIRE {#MPA1:1 %pc_bus};
//   %pc_gate = (59, 7);
//   $JUNCTION @ATTACH %pc_gate;
//   &PCOND @WIRE {%pc_bus (50, 16) (50, 7) %pc_gate};
//   &BN @WIRE {#MNB0:3 #MNB1:1};
//   %no_bus = (108, 22);
//   $JUNCTION @ATTACH %no_bus;
//   &NOFF @WIRE {#MPB0:1 (96, 22) %no_bus (120, 22) #MPB1:1};
//   &NOFF @WIRE {#MNB0:1 %no_bus};
//   %no_gate = (155, 7);
//   $JUNCTION @ATTACH %no_gate;
//   &NOFF @WIRE {%no_bus (146, 22) (146, 7) %no_gate};
//   &BP @WIRE {#MNOUT:1 #MPOUT:1};
//   &GP @WIRE {#MGPN:1 (74, 4) (74, 52) (190, 52) (190, 22) #MPOUT:2};
//   &GN @WIRE {#MGNN:1 (180, 4) (180, 0) #MNOUT:2};
//   %p_hib = $IO_PORT @ATTACH &HIB => @PLACE(5, 26) => @ORIENT("R0");
//   &HIB @WIRE {%p_hib:p #MPA1:2};
//   %p_en = $IO_PORT @ATTACH &EN => @PLACE(89, 30) => @ORIENT("R0");
//   &EN @WIRE {%p_en:p #MPB0:2};
//   %p_enb = $IO_PORT @ATTACH &ENB => @PLACE(5, 40) => @ORIENT("R0");
//   &ENB @WIRE {%p_enb:p #MPA0:2};
//   %p_bp = $IO_PORT @ATTACH &BP => @PLACE(200, 6) => @ORIENT("R270");
//   &BP @WIRE {%p_bp:p #MNOUT:1};
//   (-10, 62) @TEXT("Reference-rail output driver j=4") => @SET-STYLE $title_style
// }
ends mq_cdac_drv4

// Matched half-capacitor pair j=4
subckt mq_cdac_bit4 (VIN VG DH RL EN ENB TOP VREFP VREFN VSS DVDD EQBUS APGATE)
// CP*: user-specified 5% bottom-plate estimate for every physical MOM unit, not extraction.
// Series tails retain one unit parasitic at MID and one at B.
// APGATE PMOS assist connects each bottom plate to VIN.
// Additional ENB NMOS sharing retains a common EQBUS.
XHCTL (DH HHIB DVDD VREFN VSS) mq_cdac_ctl_h
XLCTL (RL LHIB DVDD VREFN VSS) mq_cdac_ctl_l
XDH (HHIB EN ENB BH VREFP VREFN VSS DVDD) mq_cdac_drv4
CH (TOP BH) cfmom_2t w=5e-08 s=2.4e-07 nr=6 lr=1.69e-06 stm=2 spm=4 multi=5
CPH (BH VSS) capacitor c=2.505725e-16
MSH (BH VG VIN VSS) nch_ulvt_mac w=1.2e-07 l=3e-08 nf=1
XDL (LHIB EN ENB BL VREFP VREFN VSS DVDD) mq_cdac_drv4
CL (TOP BL) cfmom_2t w=5e-08 s=2.4e-07 nr=6 lr=1.69e-06 stm=2 spm=4 multi=5
CPL (BL VSS) capacitor c=2.505725e-16
MSL (BL VG VIN VSS) nch_ulvt_mac w=1.2e-07 l=3e-08 nf=1
MEQ1 (BH APGATE VIN VREFP) pch_ulvt_mac w=1.2e-07 l=3e-08 nf=1
MEQ2 (BL APGATE VIN VREFP) pch_ulvt_mac w=1.2e-07 l=3e-08 nf=1
MSHAREH (BH ENB EQBUS VSS) nch_ulvt_mac w=1.2e-07 l=3e-08 nf=1
MSHAREL (BL ENB EQBUS VSS) nch_ulvt_mac w=1.2e-07 l=3e-08 nf=1
// @RNL {
//   /* pins connected by net name: the net-name label of rnl-std-fill on every unwired pin, placed below by its key netname */
//   $LABEL_TERMINAL_SET @TEXT("${net}", key="netname", size=0.6);
//   &VSS @ADD-TO $GROUND_NET_SET; &VREFN @ADD-TO $GROUND_NET_SET;
//   &VREFP @ADD-TO $SUPPLY_NET_SET;
//   &DVDD @ADD-TO $SUPPLY_NET_SET;
//   {#CH #CL} @AS $MATCHED;
//   {#MSH #MSL} @AS $MATCHED;
//   {#MEQ1 #MEQ2} @AS $MATCHED;
//   {#MSHAREH #MSHAREL} @AS $MATCHED;
//   {#XDH #XDL} @AS $MATCHED;
//   #XHCTL @PLACE(-70, 24);
//   #XHCTL @ORIENT("R0");
//   #XHCTL:IN @TEXT("${net}", key="netname", size=0.6, halign="end", valign="middle", dx=-0.4, dy=0);
//   #XHCTL:HIB @TEXT("${net}", key="netname", size=0.6, halign="start", valign="middle", dx=0.4, dy=0);
//   %v1 = $SUPPLY @ATTACH &DVDD => @PLACE(-70, 31.2);
//   &DVDD @WIRE {#XHCTL:DVDD (-70, 28) %v1:p};
//   %g2 = $GROUND @ATTACH &VREFN => @PLACE(-72, 16.8);
//   &VREFN @WIRE {#XHCTL:VREFN (-72, 20) %g2:p};
//   %g3 = $GROUND @ATTACH &VSS => @PLACE(-68, 16.8);
//   &VSS @WIRE {#XHCTL:VSS (-68, 20) %g3:p};
//   #XLCTL @PLACE(-70, -26);
//   #XLCTL @ORIENT("R0");
//   #XLCTL:IN @TEXT("${net}", key="netname", size=0.6, halign="end", valign="middle", dx=-0.4, dy=0);
//   #XLCTL:HIB @TEXT("${net}", key="netname", size=0.6, halign="start", valign="middle", dx=0.4, dy=0);
//   %v4 = $SUPPLY @ATTACH &DVDD => @PLACE(-70, -18.8);
//   &DVDD @WIRE {#XLCTL:DVDD (-70, -22) %v4:p};
//   %g5 = $GROUND @ATTACH &VREFN => @PLACE(-72, -33.2);
//   &VREFN @WIRE {#XLCTL:VREFN (-72, -30) %g5:p};
//   %g6 = $GROUND @ATTACH &VSS => @PLACE(-68, -33.2);
//   &VSS @WIRE {#XLCTL:VSS (-68, -30) %g6:p};
//   #XDH @PLACE(-34, 24);
//   #XDH @ORIENT("R0");
//   #XDH:HIB @TEXT("${net}", key="netname", size=0.6, halign="end", valign="middle", dx=-0.4, dy=0);
//   #XDH:EN @TEXT("${net}", key="netname", size=0.6, halign="end", valign="middle", dx=-0.4, dy=0);
//   #XDH:ENB @TEXT("${net}", key="netname", size=0.6, halign="end", valign="middle", dx=-0.4, dy=0);
//   #XDH:BP @TEXT("${net}", key="netname", size=0.6, halign="start", valign="middle", dx=0.4, dy=0);
//   %v7 = $SUPPLY @ATTACH &VREFP => @PLACE(-36, 32.2);
//   &VREFP @WIRE {#XDH:VREFP (-36, 29) %v7:p};
//   %g8 = $GROUND @ATTACH &VREFN => @PLACE(-36, 15.8);
//   &VREFN @WIRE {#XDH:VREFN (-36, 19) %g8:p};
//   %g9 = $GROUND @ATTACH &VSS => @PLACE(-32, 15.8);
//   &VSS @WIRE {#XDH:VSS (-32, 19) %g9:p};
//   %v10 = $SUPPLY @ATTACH &DVDD => @PLACE(-32, 32.2);
//   &DVDD @WIRE {#XDH:DVDD (-32, 29) %v10:p};
//   #CH @PLACE(14, 24) => @ORIENT("R270");
//   #CH:1 @TEXT("${net}", key="netname", size=0.6, halign="start", valign="middle", dx=0.4, dy=0);
//   #CH:2 @TEXT("${net}", key="netname", size=0.6, halign="end", valign="middle", dx=-0.4, dy=0);
//   #CPH @PLACE(60, 20);
//   #CPH @ORIENT("R0");
//   #CPH:1 @TEXT("${net}", key="netname", size=0.6, halign="start", valign="middle", rotate=90, dx=0, dy=0.4);
//   %g11 = $GROUND @ATTACH &VSS => @PLACE(60, 14.8);
//   &VSS @WIRE {#CPH:2 (60, 18) %g11:p};
//   #MSH @PLACE(2, 8);
//   #MSH @ORIENT("R0");
//   #MSH:1 @TEXT("${net}", key="netname", size=0.6, halign="start", valign="middle", rotate=90, dx=0, dy=0.4);
//   #MSH:2 @TEXT("${net}", key="netname", size=0.6, halign="end", valign="middle", dx=-0.4, dy=0);
//   #MSH:3 @TEXT("${net}", key="netname", size=0.6, halign="end", valign="middle", rotate=90, dx=0, dy=-0.4);
//   %g12 = $GROUND @ATTACH &VSS => @PLACE(5, 4.8);
//   &VSS @WIRE {#MSH:4 (5, 8) %g12:p};
//   #XDL @PLACE(-34, -26);
//   #XDL @ORIENT("R0");
//   #XDL:HIB @TEXT("${net}", key="netname", size=0.6, halign="end", valign="middle", dx=-0.4, dy=0);
//   #XDL:EN @TEXT("${net}", key="netname", size=0.6, halign="end", valign="middle", dx=-0.4, dy=0);
//   #XDL:ENB @TEXT("${net}", key="netname", size=0.6, halign="end", valign="middle", dx=-0.4, dy=0);
//   #XDL:BP @TEXT("${net}", key="netname", size=0.6, halign="start", valign="middle", dx=0.4, dy=0);
//   %v13 = $SUPPLY @ATTACH &VREFP => @PLACE(-36, -17.8);
//   &VREFP @WIRE {#XDL:VREFP (-36, -21) %v13:p};
//   %g14 = $GROUND @ATTACH &VREFN => @PLACE(-36, -34.2);
//   &VREFN @WIRE {#XDL:VREFN (-36, -31) %g14:p};
//   %g15 = $GROUND @ATTACH &VSS => @PLACE(-32, -34.2);
//   &VSS @WIRE {#XDL:VSS (-32, -31) %g15:p};
//   %v16 = $SUPPLY @ATTACH &DVDD => @PLACE(-32, -17.8);
//   &DVDD @WIRE {#XDL:DVDD (-32, -21) %v16:p};
//   #CL @PLACE(14, -26) => @ORIENT("R270");
//   #CL:1 @TEXT("${net}", key="netname", size=0.6, halign="start", valign="middle", dx=0.4, dy=0);
//   #CL:2 @TEXT("${net}", key="netname", size=0.6, halign="end", valign="middle", dx=-0.4, dy=0);
//   #CPL @PLACE(60, -30);
//   #CPL @ORIENT("R0");
//   #CPL:1 @TEXT("${net}", key="netname", size=0.6, halign="start", valign="middle", rotate=90, dx=0, dy=0.4);
//   %g17 = $GROUND @ATTACH &VSS => @PLACE(60, -35.2);
//   &VSS @WIRE {#CPL:2 (60, -32) %g17:p};
//   #MSL @PLACE(2, -42);
//   #MSL @ORIENT("R0");
//   #MSL:1 @TEXT("${net}", key="netname", size=0.6, halign="start", valign="middle", rotate=90, dx=0, dy=0.4);
//   #MSL:2 @TEXT("${net}", key="netname", size=0.6, halign="end", valign="middle", dx=-0.4, dy=0);
//   #MSL:3 @TEXT("${net}", key="netname", size=0.6, halign="end", valign="middle", rotate=90, dx=0, dy=-0.4);
//   %g18 = $GROUND @ATTACH &VSS => @PLACE(5, -45.2);
//   &VSS @WIRE {#MSL:4 (5, -42) %g18:p};
//   #MEQ1 @PLACE(-12, 0);
//   #MEQ1 @ORIENT("R0");
//   #MEQ1:1 @TEXT("${net}", key="netname", size=0.6, halign="end", valign="middle", rotate=90, dx=0, dy=-0.4);
//   #MEQ1:2 @TEXT("${net}", key="netname", size=0.6, halign="end", valign="middle", dx=-0.4, dy=0);
//   #MEQ1:3 @TEXT("${net}", key="netname", size=0.6, halign="start", valign="middle", rotate=90, dx=0, dy=0.4);
//   %v19 = $SUPPLY @ATTACH &VREFP => @PLACE(-9, 3.2);
//   &VREFP @WIRE {#MEQ1:4 (-9, 0) %v19:p};
//   #MEQ2 @PLACE(-12, -50);
//   #MEQ2 @ORIENT("R0");
//   #MEQ2:1 @TEXT("${net}", key="netname", size=0.6, halign="end", valign="middle", rotate=90, dx=0, dy=-0.4);
//   #MEQ2:2 @TEXT("${net}", key="netname", size=0.6, halign="end", valign="middle", dx=-0.4, dy=0);
//   #MEQ2:3 @TEXT("${net}", key="netname", size=0.6, halign="start", valign="middle", rotate=90, dx=0, dy=0.4);
//   %v20 = $SUPPLY @ATTACH &VREFP => @PLACE(-9, -46.8);
//   &VREFP @WIRE {#MEQ2:4 (-9, -50) %v20:p};
//   #MSHAREH @PLACE(56, -2);
//   #MSHAREH @ORIENT("R0");
//   #MSHAREH:1 @TEXT("${net}", key="netname", size=0.6, halign="start", valign="middle", rotate=90, dx=0, dy=0.4);
//   #MSHAREH:2 @TEXT("${net}", key="netname", size=0.6, halign="end", valign="middle", dx=-0.4, dy=0);
//   #MSHAREH:3 @TEXT("${net}", key="netname", size=0.6, halign="end", valign="middle", rotate=90, dx=0, dy=-0.4);
//   %g21 = $GROUND @ATTACH &VSS => @PLACE(59, -5.2);
//   &VSS @WIRE {#MSHAREH:4 (59, -2) %g21:p};
//   #MSHAREL @PLACE(56, -52);
//   #MSHAREL @ORIENT("R0");
//   #MSHAREL:1 @TEXT("${net}", key="netname", size=0.6, halign="start", valign="middle", rotate=90, dx=0, dy=0.4);
//   #MSHAREL:2 @TEXT("${net}", key="netname", size=0.6, halign="end", valign="middle", dx=-0.4, dy=0);
//   #MSHAREL:3 @TEXT("${net}", key="netname", size=0.6, halign="end", valign="middle", rotate=90, dx=0, dy=-0.4);
//   %g22 = $GROUND @ATTACH &VSS => @PLACE(59, -55.2);
//   &VSS @WIRE {#MSHAREL:4 (59, -52) %g22:p};
//   &HHIB @WIRE {#XHCTL:HIB (-52, 24) (-52, 26) #XDH:HIB};
//   %b_H = (-12, 24);
//   $JUNCTION @ATTACH %b_H;
//   &BH @WIRE {#XDH:BP %b_H};
//   &BH @WIRE {%b_H #CH:2};
//   &BH @WIRE {%b_H (-12, 10) #MSH:1};
//   &BH @WIRE {%b_H #MEQ1:1};
//   &LHIB @WIRE {#XLCTL:HIB (-52, -26) (-52, -24) #XDL:HIB};
//   %b_L = (-12, -26);
//   $JUNCTION @ATTACH %b_L;
//   &BL @WIRE {#XDL:BP %b_L};
//   &BL @WIRE {%b_L #CL:2};
//   &BL @WIRE {%b_L (-12, -40) #MSL:1};
//   &BL @WIRE {%b_L #MEQ2:1};
//   &VIN @WIRE {#MSH:3 (6, 6) (6, -44) #MSL:3};
//   &VG @WIRE {#MSH:2 (-5, 8) (-5, -42) #MSL:2};
//   %top_H = (44, 24);
//   $JUNCTION @ATTACH %top_H;
//   %top_L = (44, -26);
//   $JUNCTION @ATTACH %top_L;
//   &TOP @WIRE {#CH:1 %top_H};
//   &TOP @WIRE {#CL:1 %top_L};
//   &TOP @WIRE {%top_H %top_L};
//   %p_vin = $IO_PORT @ATTACH &VIN => @PLACE(2, 2) => @ORIENT("R90");
//   &VIN @WIRE {%p_vin:p #MSH:3};
//   %p_vg = $IO_PORT @ATTACH &VG => @PLACE(-5, 8) => @ORIENT("R0");
//   &VG @WIRE {%p_vg:p #MSH:2};
//   %p_dh = $IO_PORT @ATTACH &DH => @PLACE(-81, 24) => @ORIENT("R0");
//   &DH @WIRE {%p_dh:p #XHCTL:IN};
//   %p_rl = $IO_PORT @ATTACH &RL => @PLACE(-81, -26) => @ORIENT("R0");
//   &RL @WIRE {%p_rl:p #XLCTL:IN};
//   %p_en = $IO_PORT @ATTACH &EN => @PLACE(-45, 24) => @ORIENT("R0");
//   &EN @WIRE {%p_en:p #XDH:EN};
//   %p_enb = $IO_PORT @ATTACH &ENB => @PLACE(-45, 22) => @ORIENT("R0");
//   &ENB @WIRE {%p_enb:p #XDH:ENB};
//   %p_top = $IO_PORT @ATTACH &TOP => @PLACE(20, 24) => @ORIENT("MY");
//   &TOP @WIRE {%p_top:p #CH:1};
//   %p_eqbus = $IO_PORT @ATTACH &EQBUS => @PLACE(56, -8) => @ORIENT("R90");
//   &EQBUS @WIRE {%p_eqbus:p #MSHAREH:3};
//   %p_apgate = $IO_PORT @ATTACH &APGATE => @PLACE(-19, 0) => @ORIENT("R0");
//   &APGATE @WIRE {%p_apgate:p #MEQ1:2};
//   (-10, 46) @TEXT("Matched half-capacitor pair j=4") => @SET-STYLE $title_style
// }
ends mq_cdac_bit4

// Reference-rail output driver j=3
subckt mq_cdac_drv3 (HIB EN ENB BP VREFP VREFN VSS DVDD)
// DVDD prelogic: PCOND = NOR(ENB,HIB); NOFF = NAND(EN,HIB).
// Reference-powered final inverters restore GP and GN to VREFP/VREFN.
// Actual current overlap, settling and device stress require measurement.
MPA0 (AP ENB DVDD DVDD) pch_ulvt_mac w=2.4e-07 l=3e-08 nf=1
MPA1 (PCOND HIB AP DVDD) pch_ulvt_mac w=2.4e-07 l=3e-08 nf=1
MNA0 (PCOND ENB VREFN VSS) nch_ulvt_mac w=1.2e-07 l=3e-08 nf=1
MNA1 (PCOND HIB VREFN VSS) nch_ulvt_mac w=1.2e-07 l=3e-08 nf=1
MPB0 (NOFF EN DVDD DVDD) pch_ulvt_mac w=1.2e-07 l=3e-08 nf=1
MPB1 (NOFF HIB DVDD DVDD) pch_ulvt_mac w=1.2e-07 l=3e-08 nf=1
MNB0 (NOFF EN BN VSS) nch_ulvt_mac w=1.2e-07 l=3e-08 nf=1
MNB1 (BN HIB VREFN VSS) nch_ulvt_mac w=1.2e-07 l=3e-08 nf=1
MGPN (GP PCOND VREFN VSS) nch_mac w=2.4e-07 l=3e-08 nf=1
MGPP (GP PCOND VREFP VREFP) pch_mac w=3.6e-07 l=3e-08 nf=1
MGNN (GN NOFF VREFN VSS) nch_mac w=2.4e-07 l=3e-08 nf=1
MGNP (GN NOFF VREFP VREFP) pch_mac w=1.2e-07 l=3e-08 nf=1
MNOUT (BP GN VREFN VSS) nch_mac w=4.5e-07 l=3e-08 nf=1
MPOUT (BP GP VREFP VREFP) pch_mac w=9e-07 l=3e-08 nf=1
// @RNL {
//   /* pins connected by net name: the net-name label of rnl-std-fill on every unwired pin, placed below by its key netname */
//   $LABEL_TERMINAL_SET @TEXT("${net}", key="netname", size=0.6);
//   &VSS @ADD-TO $GROUND_NET_SET; &VREFN @ADD-TO $GROUND_NET_SET;
//   &VREFP @ADD-TO $SUPPLY_NET_SET;
//   &DVDD @ADD-TO $SUPPLY_NET_SET;
//   {#MPA0 #MPA1 #MNA0 #MNA1} @GROUP;
//   {#MPB0 #MPB1 #MNB0 #MNB1} @GROUP;
//   {#MGPN #MGPP} @GROUP;
//   {#MGNN #MGNP} @GROUP;
//   {#MNOUT #MPOUT} @GROUP;
//   #MPA0 @PLACE(12, 40);
//   #MPA0 @ORIENT("R0");
//   #MPA0:1 @TEXT("${net}", key="netname", size=0.6, halign="end", valign="middle", rotate=90, dx=0, dy=-0.4);
//   #MPA0:2 @TEXT("${net}", key="netname", size=0.6, halign="end", valign="middle", dx=-0.4, dy=0);
//   %v1 = $SUPPLY @ATTACH &DVDD => @PLACE(12, 45.2);
//   &DVDD @WIRE {#MPA0:3 (12, 42) %v1:p};
//   %v2 = $SUPPLY @ATTACH &DVDD => @PLACE(15, 43.2);
//   &DVDD @WIRE {#MPA0:4 (15, 40) %v2:p};
//   #MPA1 @PLACE(12, 26);
//   #MPA1 @ORIENT("R0");
//   #MPA1:1 @TEXT("${net}", key="netname", size=0.6, halign="end", valign="middle", rotate=90, dx=0, dy=-0.4);
//   #MPA1:2 @TEXT("${net}", key="netname", size=0.6, halign="end", valign="middle", dx=-0.4, dy=0);
//   #MPA1:3 @TEXT("${net}", key="netname", size=0.6, halign="start", valign="middle", rotate=90, dx=0, dy=0.4);
//   %v3 = $SUPPLY @ATTACH &DVDD => @PLACE(15, 29.2);
//   &DVDD @WIRE {#MPA1:4 (15, 26) %v3:p};
//   #MNA0 @PLACE(0, 2);
//   #MNA0 @ORIENT("R0");
//   #MNA0:1 @TEXT("${net}", key="netname", size=0.6, halign="start", valign="middle", rotate=90, dx=0, dy=0.4);
//   #MNA0:2 @TEXT("${net}", key="netname", size=0.6, halign="end", valign="middle", dx=-0.4, dy=0);
//   %g4 = $GROUND @ATTACH &VREFN => @PLACE(0, -3.2);
//   &VREFN @WIRE {#MNA0:3 (0, 0) %g4:p};
//   %g5 = $GROUND @ATTACH &VSS => @PLACE(3, -1.2);
//   &VSS @WIRE {#MNA0:4 (3, 2) %g5:p};
//   #MNA1 @PLACE(24, 2);
//   #MNA1 @ORIENT("R0");
//   #MNA1:1 @TEXT("${net}", key="netname", size=0.6, halign="start", valign="middle", rotate=90, dx=0, dy=0.4);
//   #MNA1:2 @TEXT("${net}", key="netname", size=0.6, halign="end", valign="middle", dx=-0.4, dy=0);
//   %g6 = $GROUND @ATTACH &VREFN => @PLACE(24, -3.2);
//   &VREFN @WIRE {#MNA1:3 (24, 0) %g6:p};
//   %g7 = $GROUND @ATTACH &VSS => @PLACE(27, -1.2);
//   &VSS @WIRE {#MNA1:4 (27, 2) %g7:p};
//   #MPB0 @PLACE(96, 30);
//   #MPB0 @ORIENT("R0");
//   #MPB0:1 @TEXT("${net}", key="netname", size=0.6, halign="end", valign="middle", rotate=90, dx=0, dy=-0.4);
//   #MPB0:2 @TEXT("${net}", key="netname", size=0.6, halign="end", valign="middle", dx=-0.4, dy=0);
//   %v8 = $SUPPLY @ATTACH &DVDD => @PLACE(96, 35.2);
//   &DVDD @WIRE {#MPB0:3 (96, 32) %v8:p};
//   %v9 = $SUPPLY @ATTACH &DVDD => @PLACE(99, 33.2);
//   &DVDD @WIRE {#MPB0:4 (99, 30) %v9:p};
//   #MPB1 @PLACE(120, 30);
//   #MPB1 @ORIENT("R0");
//   #MPB1:1 @TEXT("${net}", key="netname", size=0.6, halign="end", valign="middle", rotate=90, dx=0, dy=-0.4);
//   #MPB1:2 @TEXT("${net}", key="netname", size=0.6, halign="end", valign="middle", dx=-0.4, dy=0);
//   %v10 = $SUPPLY @ATTACH &DVDD => @PLACE(120, 35.2);
//   &DVDD @WIRE {#MPB1:3 (120, 32) %v10:p};
//   %v11 = $SUPPLY @ATTACH &DVDD => @PLACE(123, 33.2);
//   &DVDD @WIRE {#MPB1:4 (123, 30) %v11:p};
//   #MNB0 @PLACE(108, 12);
//   #MNB0 @ORIENT("R0");
//   #MNB0:1 @TEXT("${net}", key="netname", size=0.6, halign="start", valign="middle", rotate=90, dx=0, dy=0.4);
//   #MNB0:2 @TEXT("${net}", key="netname", size=0.6, halign="end", valign="middle", dx=-0.4, dy=0);
//   #MNB0:3 @TEXT("${net}", key="netname", size=0.6, halign="end", valign="middle", rotate=90, dx=0, dy=-0.4);
//   %g12 = $GROUND @ATTACH &VSS => @PLACE(111, 8.8);
//   &VSS @WIRE {#MNB0:4 (111, 12) %g12:p};
//   #MNB1 @PLACE(108, -2);
//   #MNB1 @ORIENT("R0");
//   #MNB1:1 @TEXT("${net}", key="netname", size=0.6, halign="start", valign="middle", rotate=90, dx=0, dy=0.4);
//   #MNB1:2 @TEXT("${net}", key="netname", size=0.6, halign="end", valign="middle", dx=-0.4, dy=0);
//   %g13 = $GROUND @ATTACH &VREFN => @PLACE(108, -7.2);
//   &VREFN @WIRE {#MNB1:3 (108, -4) %g13:p};
//   %g14 = $GROUND @ATTACH &VSS => @PLACE(111, -5.2);
//   &VSS @WIRE {#MNB1:4 (111, -2) %g14:p};
//   #MGPN @PLACE(64, 2);
//   #MGPN @ORIENT("R0");
//   #MGPN:1 @TEXT("${net}", key="netname", size=0.6, halign="start", valign="middle", rotate=90, dx=0, dy=0.4);
//   #MGPN:2 @TEXT("${net}", key="netname", size=0.6, halign="end", valign="middle", dx=-0.4, dy=0);
//   %g15 = $GROUND @ATTACH &VREFN => @PLACE(64, -3.2);
//   &VREFN @WIRE {#MGPN:3 (64, 0) %g15:p};
//   %g16 = $GROUND @ATTACH &VSS => @PLACE(67, -1.2);
//   &VSS @WIRE {#MGPN:4 (67, 2) %g16:p};
//   #MGPP @PLACE(64, 12);
//   #MGPP @ORIENT("R0");
//   #MGPP:1 @TEXT("${net}", key="netname", size=0.6, halign="end", valign="middle", rotate=90, dx=0, dy=-0.4);
//   #MGPP:2 @TEXT("${net}", key="netname", size=0.6, halign="end", valign="middle", dx=-0.4, dy=0);
//   %v17 = $SUPPLY @ATTACH &VREFP => @PLACE(64, 17.2);
//   &VREFP @WIRE {#MGPP:3 (64, 14) %v17:p};
//   %v18 = $SUPPLY @ATTACH &VREFP => @PLACE(67, 15.2);
//   &VREFP @WIRE {#MGPP:4 (67, 12) %v18:p};
//   #MGNN @PLACE(160, 2);
//   #MGNN @ORIENT("R0");
//   #MGNN:1 @TEXT("${net}", key="netname", size=0.6, halign="start", valign="middle", rotate=90, dx=0, dy=0.4);
//   #MGNN:2 @TEXT("${net}", key="netname", size=0.6, halign="end", valign="middle", dx=-0.4, dy=0);
//   %g19 = $GROUND @ATTACH &VREFN => @PLACE(160, -3.2);
//   &VREFN @WIRE {#MGNN:3 (160, 0) %g19:p};
//   %g20 = $GROUND @ATTACH &VSS => @PLACE(163, -1.2);
//   &VSS @WIRE {#MGNN:4 (163, 2) %g20:p};
//   #MGNP @PLACE(160, 12);
//   #MGNP @ORIENT("R0");
//   #MGNP:1 @TEXT("${net}", key="netname", size=0.6, halign="end", valign="middle", rotate=90, dx=0, dy=-0.4);
//   #MGNP:2 @TEXT("${net}", key="netname", size=0.6, halign="end", valign="middle", dx=-0.4, dy=0);
//   %v21 = $SUPPLY @ATTACH &VREFP => @PLACE(160, 17.2);
//   &VREFP @WIRE {#MGNP:3 (160, 14) %v21:p};
//   %v22 = $SUPPLY @ATTACH &VREFP => @PLACE(163, 15.2);
//   &VREFP @WIRE {#MGNP:4 (163, 12) %v22:p};
//   #MNOUT @PLACE(200, 0);
//   #MNOUT @ORIENT("R0");
//   #MNOUT:1 @TEXT("${net}", key="netname", size=0.6, halign="start", valign="middle", rotate=90, dx=0, dy=0.4);
//   #MNOUT:2 @TEXT("${net}", key="netname", size=0.6, halign="end", valign="middle", dx=-0.4, dy=0);
//   %g23 = $GROUND @ATTACH &VREFN => @PLACE(200, -5.2);
//   &VREFN @WIRE {#MNOUT:3 (200, -2) %g23:p};
//   %g24 = $GROUND @ATTACH &VSS => @PLACE(203, -3.2);
//   &VSS @WIRE {#MNOUT:4 (203, 0) %g24:p};
//   #MPOUT @PLACE(200, 22);
//   #MPOUT @ORIENT("R0");
//   #MPOUT:1 @TEXT("${net}", key="netname", size=0.6, halign="end", valign="middle", rotate=90, dx=0, dy=-0.4);
//   #MPOUT:2 @TEXT("${net}", key="netname", size=0.6, halign="end", valign="middle", dx=-0.4, dy=0);
//   %v25 = $SUPPLY @ATTACH &VREFP => @PLACE(200, 27.2);
//   &VREFP @WIRE {#MPOUT:3 (200, 24) %v25:p};
//   %v26 = $SUPPLY @ATTACH &VREFP => @PLACE(203, 25.2);
//   &VREFP @WIRE {#MPOUT:4 (203, 22) %v26:p};
//   &GP @WIRE {#MGPN:1 #MGPP:1};
//   &PCOND @WIRE {#MGPN:2 (59, 2) (59, 12) #MGPP:2};
//   &GN @WIRE {#MGNN:1 #MGNP:1};
//   &NOFF @WIRE {#MGNN:2 (155, 2) (155, 12) #MGNP:2};
//   &AP @WIRE {#MPA0:1 #MPA1:3};
//   %pc_bus = (12, 16);
//   $JUNCTION @ATTACH %pc_bus;
//   &PCOND @WIRE {#MNA0:1 (0, 16) %pc_bus (24, 16) #MNA1:1};
//   &PCOND @WIRE {#MPA1:1 %pc_bus};
//   %pc_gate = (59, 7);
//   $JUNCTION @ATTACH %pc_gate;
//   &PCOND @WIRE {%pc_bus (50, 16) (50, 7) %pc_gate};
//   &BN @WIRE {#MNB0:3 #MNB1:1};
//   %no_bus = (108, 22);
//   $JUNCTION @ATTACH %no_bus;
//   &NOFF @WIRE {#MPB0:1 (96, 22) %no_bus (120, 22) #MPB1:1};
//   &NOFF @WIRE {#MNB0:1 %no_bus};
//   %no_gate = (155, 7);
//   $JUNCTION @ATTACH %no_gate;
//   &NOFF @WIRE {%no_bus (146, 22) (146, 7) %no_gate};
//   &BP @WIRE {#MNOUT:1 #MPOUT:1};
//   &GP @WIRE {#MGPN:1 (74, 4) (74, 52) (190, 52) (190, 22) #MPOUT:2};
//   &GN @WIRE {#MGNN:1 (180, 4) (180, 0) #MNOUT:2};
//   %p_hib = $IO_PORT @ATTACH &HIB => @PLACE(5, 26) => @ORIENT("R0");
//   &HIB @WIRE {%p_hib:p #MPA1:2};
//   %p_en = $IO_PORT @ATTACH &EN => @PLACE(89, 30) => @ORIENT("R0");
//   &EN @WIRE {%p_en:p #MPB0:2};
//   %p_enb = $IO_PORT @ATTACH &ENB => @PLACE(5, 40) => @ORIENT("R0");
//   &ENB @WIRE {%p_enb:p #MPA0:2};
//   %p_bp = $IO_PORT @ATTACH &BP => @PLACE(200, 6) => @ORIENT("R270");
//   &BP @WIRE {%p_bp:p #MNOUT:1};
//   (-10, 62) @TEXT("Reference-rail output driver j=3") => @SET-STYLE $title_style
// }
ends mq_cdac_drv3

// Matched half-capacitor pair j=3
subckt mq_cdac_bit3 (VIN VG DH RL EN ENB TOP VREFP VREFN VSS DVDD EQBUS APGATE)
// CP*: user-specified 5% bottom-plate estimate for every physical MOM unit, not extraction.
// Series tails retain one unit parasitic at MID and one at B.
// APGATE PMOS assist connects each bottom plate to VIN.
// Additional ENB NMOS sharing retains a common EQBUS.
XHCTL (DH HHIB DVDD VREFN VSS) mq_cdac_ctl_h
XLCTL (RL LHIB DVDD VREFN VSS) mq_cdac_ctl_l
XDH (HHIB EN ENB BH VREFP VREFN VSS DVDD) mq_cdac_drv3
CH (TOP BH) cfmom_2t w=5e-08 s=2.4e-07 nr=6 lr=1.69e-06 stm=2 spm=4 multi=3
CPH (BH VSS) capacitor c=1.503435e-16
MSH (BH VG VIN VSS) nch_ulvt_mac w=1.2e-07 l=3e-08 nf=1
XDL (LHIB EN ENB BL VREFP VREFN VSS DVDD) mq_cdac_drv3
CL (TOP BL) cfmom_2t w=5e-08 s=2.4e-07 nr=6 lr=1.69e-06 stm=2 spm=4 multi=3
CPL (BL VSS) capacitor c=1.503435e-16
MSL (BL VG VIN VSS) nch_ulvt_mac w=1.2e-07 l=3e-08 nf=1
MEQ1 (BH APGATE VIN VREFP) pch_ulvt_mac w=1.2e-07 l=3e-08 nf=1
MEQ2 (BL APGATE VIN VREFP) pch_ulvt_mac w=1.2e-07 l=3e-08 nf=1
MSHAREH (BH ENB EQBUS VSS) nch_ulvt_mac w=1.2e-07 l=3e-08 nf=1
MSHAREL (BL ENB EQBUS VSS) nch_ulvt_mac w=1.2e-07 l=3e-08 nf=1
// @RNL {
//   /* pins connected by net name: the net-name label of rnl-std-fill on every unwired pin, placed below by its key netname */
//   $LABEL_TERMINAL_SET @TEXT("${net}", key="netname", size=0.6);
//   &VSS @ADD-TO $GROUND_NET_SET; &VREFN @ADD-TO $GROUND_NET_SET;
//   &VREFP @ADD-TO $SUPPLY_NET_SET;
//   &DVDD @ADD-TO $SUPPLY_NET_SET;
//   {#CH #CL} @AS $MATCHED;
//   {#MSH #MSL} @AS $MATCHED;
//   {#MEQ1 #MEQ2} @AS $MATCHED;
//   {#MSHAREH #MSHAREL} @AS $MATCHED;
//   {#XDH #XDL} @AS $MATCHED;
//   #XHCTL @PLACE(-70, 24);
//   #XHCTL @ORIENT("R0");
//   #XHCTL:IN @TEXT("${net}", key="netname", size=0.6, halign="end", valign="middle", dx=-0.4, dy=0);
//   #XHCTL:HIB @TEXT("${net}", key="netname", size=0.6, halign="start", valign="middle", dx=0.4, dy=0);
//   %v1 = $SUPPLY @ATTACH &DVDD => @PLACE(-70, 31.2);
//   &DVDD @WIRE {#XHCTL:DVDD (-70, 28) %v1:p};
//   %g2 = $GROUND @ATTACH &VREFN => @PLACE(-72, 16.8);
//   &VREFN @WIRE {#XHCTL:VREFN (-72, 20) %g2:p};
//   %g3 = $GROUND @ATTACH &VSS => @PLACE(-68, 16.8);
//   &VSS @WIRE {#XHCTL:VSS (-68, 20) %g3:p};
//   #XLCTL @PLACE(-70, -26);
//   #XLCTL @ORIENT("R0");
//   #XLCTL:IN @TEXT("${net}", key="netname", size=0.6, halign="end", valign="middle", dx=-0.4, dy=0);
//   #XLCTL:HIB @TEXT("${net}", key="netname", size=0.6, halign="start", valign="middle", dx=0.4, dy=0);
//   %v4 = $SUPPLY @ATTACH &DVDD => @PLACE(-70, -18.8);
//   &DVDD @WIRE {#XLCTL:DVDD (-70, -22) %v4:p};
//   %g5 = $GROUND @ATTACH &VREFN => @PLACE(-72, -33.2);
//   &VREFN @WIRE {#XLCTL:VREFN (-72, -30) %g5:p};
//   %g6 = $GROUND @ATTACH &VSS => @PLACE(-68, -33.2);
//   &VSS @WIRE {#XLCTL:VSS (-68, -30) %g6:p};
//   #XDH @PLACE(-34, 24);
//   #XDH @ORIENT("R0");
//   #XDH:HIB @TEXT("${net}", key="netname", size=0.6, halign="end", valign="middle", dx=-0.4, dy=0);
//   #XDH:EN @TEXT("${net}", key="netname", size=0.6, halign="end", valign="middle", dx=-0.4, dy=0);
//   #XDH:ENB @TEXT("${net}", key="netname", size=0.6, halign="end", valign="middle", dx=-0.4, dy=0);
//   #XDH:BP @TEXT("${net}", key="netname", size=0.6, halign="start", valign="middle", dx=0.4, dy=0);
//   %v7 = $SUPPLY @ATTACH &VREFP => @PLACE(-36, 32.2);
//   &VREFP @WIRE {#XDH:VREFP (-36, 29) %v7:p};
//   %g8 = $GROUND @ATTACH &VREFN => @PLACE(-36, 15.8);
//   &VREFN @WIRE {#XDH:VREFN (-36, 19) %g8:p};
//   %g9 = $GROUND @ATTACH &VSS => @PLACE(-32, 15.8);
//   &VSS @WIRE {#XDH:VSS (-32, 19) %g9:p};
//   %v10 = $SUPPLY @ATTACH &DVDD => @PLACE(-32, 32.2);
//   &DVDD @WIRE {#XDH:DVDD (-32, 29) %v10:p};
//   #CH @PLACE(14, 24) => @ORIENT("R270");
//   #CH:1 @TEXT("${net}", key="netname", size=0.6, halign="start", valign="middle", dx=0.4, dy=0);
//   #CH:2 @TEXT("${net}", key="netname", size=0.6, halign="end", valign="middle", dx=-0.4, dy=0);
//   #CPH @PLACE(60, 20);
//   #CPH @ORIENT("R0");
//   #CPH:1 @TEXT("${net}", key="netname", size=0.6, halign="start", valign="middle", rotate=90, dx=0, dy=0.4);
//   %g11 = $GROUND @ATTACH &VSS => @PLACE(60, 14.8);
//   &VSS @WIRE {#CPH:2 (60, 18) %g11:p};
//   #MSH @PLACE(2, 8);
//   #MSH @ORIENT("R0");
//   #MSH:1 @TEXT("${net}", key="netname", size=0.6, halign="start", valign="middle", rotate=90, dx=0, dy=0.4);
//   #MSH:2 @TEXT("${net}", key="netname", size=0.6, halign="end", valign="middle", dx=-0.4, dy=0);
//   #MSH:3 @TEXT("${net}", key="netname", size=0.6, halign="end", valign="middle", rotate=90, dx=0, dy=-0.4);
//   %g12 = $GROUND @ATTACH &VSS => @PLACE(5, 4.8);
//   &VSS @WIRE {#MSH:4 (5, 8) %g12:p};
//   #XDL @PLACE(-34, -26);
//   #XDL @ORIENT("R0");
//   #XDL:HIB @TEXT("${net}", key="netname", size=0.6, halign="end", valign="middle", dx=-0.4, dy=0);
//   #XDL:EN @TEXT("${net}", key="netname", size=0.6, halign="end", valign="middle", dx=-0.4, dy=0);
//   #XDL:ENB @TEXT("${net}", key="netname", size=0.6, halign="end", valign="middle", dx=-0.4, dy=0);
//   #XDL:BP @TEXT("${net}", key="netname", size=0.6, halign="start", valign="middle", dx=0.4, dy=0);
//   %v13 = $SUPPLY @ATTACH &VREFP => @PLACE(-36, -17.8);
//   &VREFP @WIRE {#XDL:VREFP (-36, -21) %v13:p};
//   %g14 = $GROUND @ATTACH &VREFN => @PLACE(-36, -34.2);
//   &VREFN @WIRE {#XDL:VREFN (-36, -31) %g14:p};
//   %g15 = $GROUND @ATTACH &VSS => @PLACE(-32, -34.2);
//   &VSS @WIRE {#XDL:VSS (-32, -31) %g15:p};
//   %v16 = $SUPPLY @ATTACH &DVDD => @PLACE(-32, -17.8);
//   &DVDD @WIRE {#XDL:DVDD (-32, -21) %v16:p};
//   #CL @PLACE(14, -26) => @ORIENT("R270");
//   #CL:1 @TEXT("${net}", key="netname", size=0.6, halign="start", valign="middle", dx=0.4, dy=0);
//   #CL:2 @TEXT("${net}", key="netname", size=0.6, halign="end", valign="middle", dx=-0.4, dy=0);
//   #CPL @PLACE(60, -30);
//   #CPL @ORIENT("R0");
//   #CPL:1 @TEXT("${net}", key="netname", size=0.6, halign="start", valign="middle", rotate=90, dx=0, dy=0.4);
//   %g17 = $GROUND @ATTACH &VSS => @PLACE(60, -35.2);
//   &VSS @WIRE {#CPL:2 (60, -32) %g17:p};
//   #MSL @PLACE(2, -42);
//   #MSL @ORIENT("R0");
//   #MSL:1 @TEXT("${net}", key="netname", size=0.6, halign="start", valign="middle", rotate=90, dx=0, dy=0.4);
//   #MSL:2 @TEXT("${net}", key="netname", size=0.6, halign="end", valign="middle", dx=-0.4, dy=0);
//   #MSL:3 @TEXT("${net}", key="netname", size=0.6, halign="end", valign="middle", rotate=90, dx=0, dy=-0.4);
//   %g18 = $GROUND @ATTACH &VSS => @PLACE(5, -45.2);
//   &VSS @WIRE {#MSL:4 (5, -42) %g18:p};
//   #MEQ1 @PLACE(-12, 0);
//   #MEQ1 @ORIENT("R0");
//   #MEQ1:1 @TEXT("${net}", key="netname", size=0.6, halign="end", valign="middle", rotate=90, dx=0, dy=-0.4);
//   #MEQ1:2 @TEXT("${net}", key="netname", size=0.6, halign="end", valign="middle", dx=-0.4, dy=0);
//   #MEQ1:3 @TEXT("${net}", key="netname", size=0.6, halign="start", valign="middle", rotate=90, dx=0, dy=0.4);
//   %v19 = $SUPPLY @ATTACH &VREFP => @PLACE(-9, 3.2);
//   &VREFP @WIRE {#MEQ1:4 (-9, 0) %v19:p};
//   #MEQ2 @PLACE(-12, -50);
//   #MEQ2 @ORIENT("R0");
//   #MEQ2:1 @TEXT("${net}", key="netname", size=0.6, halign="end", valign="middle", rotate=90, dx=0, dy=-0.4);
//   #MEQ2:2 @TEXT("${net}", key="netname", size=0.6, halign="end", valign="middle", dx=-0.4, dy=0);
//   #MEQ2:3 @TEXT("${net}", key="netname", size=0.6, halign="start", valign="middle", rotate=90, dx=0, dy=0.4);
//   %v20 = $SUPPLY @ATTACH &VREFP => @PLACE(-9, -46.8);
//   &VREFP @WIRE {#MEQ2:4 (-9, -50) %v20:p};
//   #MSHAREH @PLACE(56, -2);
//   #MSHAREH @ORIENT("R0");
//   #MSHAREH:1 @TEXT("${net}", key="netname", size=0.6, halign="start", valign="middle", rotate=90, dx=0, dy=0.4);
//   #MSHAREH:2 @TEXT("${net}", key="netname", size=0.6, halign="end", valign="middle", dx=-0.4, dy=0);
//   #MSHAREH:3 @TEXT("${net}", key="netname", size=0.6, halign="end", valign="middle", rotate=90, dx=0, dy=-0.4);
//   %g21 = $GROUND @ATTACH &VSS => @PLACE(59, -5.2);
//   &VSS @WIRE {#MSHAREH:4 (59, -2) %g21:p};
//   #MSHAREL @PLACE(56, -52);
//   #MSHAREL @ORIENT("R0");
//   #MSHAREL:1 @TEXT("${net}", key="netname", size=0.6, halign="start", valign="middle", rotate=90, dx=0, dy=0.4);
//   #MSHAREL:2 @TEXT("${net}", key="netname", size=0.6, halign="end", valign="middle", dx=-0.4, dy=0);
//   #MSHAREL:3 @TEXT("${net}", key="netname", size=0.6, halign="end", valign="middle", rotate=90, dx=0, dy=-0.4);
//   %g22 = $GROUND @ATTACH &VSS => @PLACE(59, -55.2);
//   &VSS @WIRE {#MSHAREL:4 (59, -52) %g22:p};
//   &HHIB @WIRE {#XHCTL:HIB (-52, 24) (-52, 26) #XDH:HIB};
//   %b_H = (-12, 24);
//   $JUNCTION @ATTACH %b_H;
//   &BH @WIRE {#XDH:BP %b_H};
//   &BH @WIRE {%b_H #CH:2};
//   &BH @WIRE {%b_H (-12, 10) #MSH:1};
//   &BH @WIRE {%b_H #MEQ1:1};
//   &LHIB @WIRE {#XLCTL:HIB (-52, -26) (-52, -24) #XDL:HIB};
//   %b_L = (-12, -26);
//   $JUNCTION @ATTACH %b_L;
//   &BL @WIRE {#XDL:BP %b_L};
//   &BL @WIRE {%b_L #CL:2};
//   &BL @WIRE {%b_L (-12, -40) #MSL:1};
//   &BL @WIRE {%b_L #MEQ2:1};
//   &VIN @WIRE {#MSH:3 (6, 6) (6, -44) #MSL:3};
//   &VG @WIRE {#MSH:2 (-5, 8) (-5, -42) #MSL:2};
//   %top_H = (44, 24);
//   $JUNCTION @ATTACH %top_H;
//   %top_L = (44, -26);
//   $JUNCTION @ATTACH %top_L;
//   &TOP @WIRE {#CH:1 %top_H};
//   &TOP @WIRE {#CL:1 %top_L};
//   &TOP @WIRE {%top_H %top_L};
//   %p_vin = $IO_PORT @ATTACH &VIN => @PLACE(2, 2) => @ORIENT("R90");
//   &VIN @WIRE {%p_vin:p #MSH:3};
//   %p_vg = $IO_PORT @ATTACH &VG => @PLACE(-5, 8) => @ORIENT("R0");
//   &VG @WIRE {%p_vg:p #MSH:2};
//   %p_dh = $IO_PORT @ATTACH &DH => @PLACE(-81, 24) => @ORIENT("R0");
//   &DH @WIRE {%p_dh:p #XHCTL:IN};
//   %p_rl = $IO_PORT @ATTACH &RL => @PLACE(-81, -26) => @ORIENT("R0");
//   &RL @WIRE {%p_rl:p #XLCTL:IN};
//   %p_en = $IO_PORT @ATTACH &EN => @PLACE(-45, 24) => @ORIENT("R0");
//   &EN @WIRE {%p_en:p #XDH:EN};
//   %p_enb = $IO_PORT @ATTACH &ENB => @PLACE(-45, 22) => @ORIENT("R0");
//   &ENB @WIRE {%p_enb:p #XDH:ENB};
//   %p_top = $IO_PORT @ATTACH &TOP => @PLACE(20, 24) => @ORIENT("MY");
//   &TOP @WIRE {%p_top:p #CH:1};
//   %p_eqbus = $IO_PORT @ATTACH &EQBUS => @PLACE(56, -8) => @ORIENT("R90");
//   &EQBUS @WIRE {%p_eqbus:p #MSHAREH:3};
//   %p_apgate = $IO_PORT @ATTACH &APGATE => @PLACE(-19, 0) => @ORIENT("R0");
//   &APGATE @WIRE {%p_apgate:p #MEQ1:2};
//   (-10, 46) @TEXT("Matched half-capacitor pair j=3") => @SET-STYLE $title_style
// }
ends mq_cdac_bit3

// Reference-rail output driver j=2
subckt mq_cdac_drv2 (HIB EN ENB BP VREFP VREFN VSS DVDD)
// DVDD prelogic: PCOND = NOR(ENB,HIB); NOFF = NAND(EN,HIB).
// Reference-powered final inverters restore GP and GN to VREFP/VREFN.
// Actual current overlap, settling and device stress require measurement.
MPA0 (AP ENB DVDD DVDD) pch_ulvt_mac w=2.4e-07 l=3e-08 nf=1
MPA1 (PCOND HIB AP DVDD) pch_ulvt_mac w=2.4e-07 l=3e-08 nf=1
MNA0 (PCOND ENB VREFN VSS) nch_ulvt_mac w=1.2e-07 l=3e-08 nf=1
MNA1 (PCOND HIB VREFN VSS) nch_ulvt_mac w=1.2e-07 l=3e-08 nf=1
MPB0 (NOFF EN DVDD DVDD) pch_ulvt_mac w=1.2e-07 l=3e-08 nf=1
MPB1 (NOFF HIB DVDD DVDD) pch_ulvt_mac w=1.2e-07 l=3e-08 nf=1
MNB0 (NOFF EN BN VSS) nch_ulvt_mac w=1.2e-07 l=3e-08 nf=1
MNB1 (BN HIB VREFN VSS) nch_ulvt_mac w=1.2e-07 l=3e-08 nf=1
MGPN (GP PCOND VREFN VSS) nch_mac w=2.4e-07 l=3e-08 nf=1
MGPP (GP PCOND VREFP VREFP) pch_mac w=3.6e-07 l=3e-08 nf=1
MGNN (GN NOFF VREFN VSS) nch_mac w=2.4e-07 l=3e-08 nf=1
MGNP (GN NOFF VREFP VREFP) pch_mac w=1.2e-07 l=3e-08 nf=1
MNOUT (BP GN VREFN VSS) nch_mac w=4.5e-07 l=3e-08 nf=1
MPOUT (BP GP VREFP VREFP) pch_mac w=9e-07 l=3e-08 nf=1
// @RNL {
//   /* pins connected by net name: the net-name label of rnl-std-fill on every unwired pin, placed below by its key netname */
//   $LABEL_TERMINAL_SET @TEXT("${net}", key="netname", size=0.6);
//   &VSS @ADD-TO $GROUND_NET_SET; &VREFN @ADD-TO $GROUND_NET_SET;
//   &VREFP @ADD-TO $SUPPLY_NET_SET;
//   &DVDD @ADD-TO $SUPPLY_NET_SET;
//   {#MPA0 #MPA1 #MNA0 #MNA1} @GROUP;
//   {#MPB0 #MPB1 #MNB0 #MNB1} @GROUP;
//   {#MGPN #MGPP} @GROUP;
//   {#MGNN #MGNP} @GROUP;
//   {#MNOUT #MPOUT} @GROUP;
//   #MPA0 @PLACE(12, 40);
//   #MPA0 @ORIENT("R0");
//   #MPA0:1 @TEXT("${net}", key="netname", size=0.6, halign="end", valign="middle", rotate=90, dx=0, dy=-0.4);
//   #MPA0:2 @TEXT("${net}", key="netname", size=0.6, halign="end", valign="middle", dx=-0.4, dy=0);
//   %v1 = $SUPPLY @ATTACH &DVDD => @PLACE(12, 45.2);
//   &DVDD @WIRE {#MPA0:3 (12, 42) %v1:p};
//   %v2 = $SUPPLY @ATTACH &DVDD => @PLACE(15, 43.2);
//   &DVDD @WIRE {#MPA0:4 (15, 40) %v2:p};
//   #MPA1 @PLACE(12, 26);
//   #MPA1 @ORIENT("R0");
//   #MPA1:1 @TEXT("${net}", key="netname", size=0.6, halign="end", valign="middle", rotate=90, dx=0, dy=-0.4);
//   #MPA1:2 @TEXT("${net}", key="netname", size=0.6, halign="end", valign="middle", dx=-0.4, dy=0);
//   #MPA1:3 @TEXT("${net}", key="netname", size=0.6, halign="start", valign="middle", rotate=90, dx=0, dy=0.4);
//   %v3 = $SUPPLY @ATTACH &DVDD => @PLACE(15, 29.2);
//   &DVDD @WIRE {#MPA1:4 (15, 26) %v3:p};
//   #MNA0 @PLACE(0, 2);
//   #MNA0 @ORIENT("R0");
//   #MNA0:1 @TEXT("${net}", key="netname", size=0.6, halign="start", valign="middle", rotate=90, dx=0, dy=0.4);
//   #MNA0:2 @TEXT("${net}", key="netname", size=0.6, halign="end", valign="middle", dx=-0.4, dy=0);
//   %g4 = $GROUND @ATTACH &VREFN => @PLACE(0, -3.2);
//   &VREFN @WIRE {#MNA0:3 (0, 0) %g4:p};
//   %g5 = $GROUND @ATTACH &VSS => @PLACE(3, -1.2);
//   &VSS @WIRE {#MNA0:4 (3, 2) %g5:p};
//   #MNA1 @PLACE(24, 2);
//   #MNA1 @ORIENT("R0");
//   #MNA1:1 @TEXT("${net}", key="netname", size=0.6, halign="start", valign="middle", rotate=90, dx=0, dy=0.4);
//   #MNA1:2 @TEXT("${net}", key="netname", size=0.6, halign="end", valign="middle", dx=-0.4, dy=0);
//   %g6 = $GROUND @ATTACH &VREFN => @PLACE(24, -3.2);
//   &VREFN @WIRE {#MNA1:3 (24, 0) %g6:p};
//   %g7 = $GROUND @ATTACH &VSS => @PLACE(27, -1.2);
//   &VSS @WIRE {#MNA1:4 (27, 2) %g7:p};
//   #MPB0 @PLACE(96, 30);
//   #MPB0 @ORIENT("R0");
//   #MPB0:1 @TEXT("${net}", key="netname", size=0.6, halign="end", valign="middle", rotate=90, dx=0, dy=-0.4);
//   #MPB0:2 @TEXT("${net}", key="netname", size=0.6, halign="end", valign="middle", dx=-0.4, dy=0);
//   %v8 = $SUPPLY @ATTACH &DVDD => @PLACE(96, 35.2);
//   &DVDD @WIRE {#MPB0:3 (96, 32) %v8:p};
//   %v9 = $SUPPLY @ATTACH &DVDD => @PLACE(99, 33.2);
//   &DVDD @WIRE {#MPB0:4 (99, 30) %v9:p};
//   #MPB1 @PLACE(120, 30);
//   #MPB1 @ORIENT("R0");
//   #MPB1:1 @TEXT("${net}", key="netname", size=0.6, halign="end", valign="middle", rotate=90, dx=0, dy=-0.4);
//   #MPB1:2 @TEXT("${net}", key="netname", size=0.6, halign="end", valign="middle", dx=-0.4, dy=0);
//   %v10 = $SUPPLY @ATTACH &DVDD => @PLACE(120, 35.2);
//   &DVDD @WIRE {#MPB1:3 (120, 32) %v10:p};
//   %v11 = $SUPPLY @ATTACH &DVDD => @PLACE(123, 33.2);
//   &DVDD @WIRE {#MPB1:4 (123, 30) %v11:p};
//   #MNB0 @PLACE(108, 12);
//   #MNB0 @ORIENT("R0");
//   #MNB0:1 @TEXT("${net}", key="netname", size=0.6, halign="start", valign="middle", rotate=90, dx=0, dy=0.4);
//   #MNB0:2 @TEXT("${net}", key="netname", size=0.6, halign="end", valign="middle", dx=-0.4, dy=0);
//   #MNB0:3 @TEXT("${net}", key="netname", size=0.6, halign="end", valign="middle", rotate=90, dx=0, dy=-0.4);
//   %g12 = $GROUND @ATTACH &VSS => @PLACE(111, 8.8);
//   &VSS @WIRE {#MNB0:4 (111, 12) %g12:p};
//   #MNB1 @PLACE(108, -2);
//   #MNB1 @ORIENT("R0");
//   #MNB1:1 @TEXT("${net}", key="netname", size=0.6, halign="start", valign="middle", rotate=90, dx=0, dy=0.4);
//   #MNB1:2 @TEXT("${net}", key="netname", size=0.6, halign="end", valign="middle", dx=-0.4, dy=0);
//   %g13 = $GROUND @ATTACH &VREFN => @PLACE(108, -7.2);
//   &VREFN @WIRE {#MNB1:3 (108, -4) %g13:p};
//   %g14 = $GROUND @ATTACH &VSS => @PLACE(111, -5.2);
//   &VSS @WIRE {#MNB1:4 (111, -2) %g14:p};
//   #MGPN @PLACE(64, 2);
//   #MGPN @ORIENT("R0");
//   #MGPN:1 @TEXT("${net}", key="netname", size=0.6, halign="start", valign="middle", rotate=90, dx=0, dy=0.4);
//   #MGPN:2 @TEXT("${net}", key="netname", size=0.6, halign="end", valign="middle", dx=-0.4, dy=0);
//   %g15 = $GROUND @ATTACH &VREFN => @PLACE(64, -3.2);
//   &VREFN @WIRE {#MGPN:3 (64, 0) %g15:p};
//   %g16 = $GROUND @ATTACH &VSS => @PLACE(67, -1.2);
//   &VSS @WIRE {#MGPN:4 (67, 2) %g16:p};
//   #MGPP @PLACE(64, 12);
//   #MGPP @ORIENT("R0");
//   #MGPP:1 @TEXT("${net}", key="netname", size=0.6, halign="end", valign="middle", rotate=90, dx=0, dy=-0.4);
//   #MGPP:2 @TEXT("${net}", key="netname", size=0.6, halign="end", valign="middle", dx=-0.4, dy=0);
//   %v17 = $SUPPLY @ATTACH &VREFP => @PLACE(64, 17.2);
//   &VREFP @WIRE {#MGPP:3 (64, 14) %v17:p};
//   %v18 = $SUPPLY @ATTACH &VREFP => @PLACE(67, 15.2);
//   &VREFP @WIRE {#MGPP:4 (67, 12) %v18:p};
//   #MGNN @PLACE(160, 2);
//   #MGNN @ORIENT("R0");
//   #MGNN:1 @TEXT("${net}", key="netname", size=0.6, halign="start", valign="middle", rotate=90, dx=0, dy=0.4);
//   #MGNN:2 @TEXT("${net}", key="netname", size=0.6, halign="end", valign="middle", dx=-0.4, dy=0);
//   %g19 = $GROUND @ATTACH &VREFN => @PLACE(160, -3.2);
//   &VREFN @WIRE {#MGNN:3 (160, 0) %g19:p};
//   %g20 = $GROUND @ATTACH &VSS => @PLACE(163, -1.2);
//   &VSS @WIRE {#MGNN:4 (163, 2) %g20:p};
//   #MGNP @PLACE(160, 12);
//   #MGNP @ORIENT("R0");
//   #MGNP:1 @TEXT("${net}", key="netname", size=0.6, halign="end", valign="middle", rotate=90, dx=0, dy=-0.4);
//   #MGNP:2 @TEXT("${net}", key="netname", size=0.6, halign="end", valign="middle", dx=-0.4, dy=0);
//   %v21 = $SUPPLY @ATTACH &VREFP => @PLACE(160, 17.2);
//   &VREFP @WIRE {#MGNP:3 (160, 14) %v21:p};
//   %v22 = $SUPPLY @ATTACH &VREFP => @PLACE(163, 15.2);
//   &VREFP @WIRE {#MGNP:4 (163, 12) %v22:p};
//   #MNOUT @PLACE(200, 0);
//   #MNOUT @ORIENT("R0");
//   #MNOUT:1 @TEXT("${net}", key="netname", size=0.6, halign="start", valign="middle", rotate=90, dx=0, dy=0.4);
//   #MNOUT:2 @TEXT("${net}", key="netname", size=0.6, halign="end", valign="middle", dx=-0.4, dy=0);
//   %g23 = $GROUND @ATTACH &VREFN => @PLACE(200, -5.2);
//   &VREFN @WIRE {#MNOUT:3 (200, -2) %g23:p};
//   %g24 = $GROUND @ATTACH &VSS => @PLACE(203, -3.2);
//   &VSS @WIRE {#MNOUT:4 (203, 0) %g24:p};
//   #MPOUT @PLACE(200, 22);
//   #MPOUT @ORIENT("R0");
//   #MPOUT:1 @TEXT("${net}", key="netname", size=0.6, halign="end", valign="middle", rotate=90, dx=0, dy=-0.4);
//   #MPOUT:2 @TEXT("${net}", key="netname", size=0.6, halign="end", valign="middle", dx=-0.4, dy=0);
//   %v25 = $SUPPLY @ATTACH &VREFP => @PLACE(200, 27.2);
//   &VREFP @WIRE {#MPOUT:3 (200, 24) %v25:p};
//   %v26 = $SUPPLY @ATTACH &VREFP => @PLACE(203, 25.2);
//   &VREFP @WIRE {#MPOUT:4 (203, 22) %v26:p};
//   &GP @WIRE {#MGPN:1 #MGPP:1};
//   &PCOND @WIRE {#MGPN:2 (59, 2) (59, 12) #MGPP:2};
//   &GN @WIRE {#MGNN:1 #MGNP:1};
//   &NOFF @WIRE {#MGNN:2 (155, 2) (155, 12) #MGNP:2};
//   &AP @WIRE {#MPA0:1 #MPA1:3};
//   %pc_bus = (12, 16);
//   $JUNCTION @ATTACH %pc_bus;
//   &PCOND @WIRE {#MNA0:1 (0, 16) %pc_bus (24, 16) #MNA1:1};
//   &PCOND @WIRE {#MPA1:1 %pc_bus};
//   %pc_gate = (59, 7);
//   $JUNCTION @ATTACH %pc_gate;
//   &PCOND @WIRE {%pc_bus (50, 16) (50, 7) %pc_gate};
//   &BN @WIRE {#MNB0:3 #MNB1:1};
//   %no_bus = (108, 22);
//   $JUNCTION @ATTACH %no_bus;
//   &NOFF @WIRE {#MPB0:1 (96, 22) %no_bus (120, 22) #MPB1:1};
//   &NOFF @WIRE {#MNB0:1 %no_bus};
//   %no_gate = (155, 7);
//   $JUNCTION @ATTACH %no_gate;
//   &NOFF @WIRE {%no_bus (146, 22) (146, 7) %no_gate};
//   &BP @WIRE {#MNOUT:1 #MPOUT:1};
//   &GP @WIRE {#MGPN:1 (74, 4) (74, 52) (190, 52) (190, 22) #MPOUT:2};
//   &GN @WIRE {#MGNN:1 (180, 4) (180, 0) #MNOUT:2};
//   %p_hib = $IO_PORT @ATTACH &HIB => @PLACE(5, 26) => @ORIENT("R0");
//   &HIB @WIRE {%p_hib:p #MPA1:2};
//   %p_en = $IO_PORT @ATTACH &EN => @PLACE(89, 30) => @ORIENT("R0");
//   &EN @WIRE {%p_en:p #MPB0:2};
//   %p_enb = $IO_PORT @ATTACH &ENB => @PLACE(5, 40) => @ORIENT("R0");
//   &ENB @WIRE {%p_enb:p #MPA0:2};
//   %p_bp = $IO_PORT @ATTACH &BP => @PLACE(200, 6) => @ORIENT("R270");
//   &BP @WIRE {%p_bp:p #MNOUT:1};
//   (-10, 62) @TEXT("Reference-rail output driver j=2") => @SET-STYLE $title_style
// }
ends mq_cdac_drv2

// Matched half-capacitor pair j=2
subckt mq_cdac_bit2 (VIN VG DH RL EN ENB TOP VREFP VREFN VSS PHI_S DVDD PHI_SB EQBUS APGATE)
// CP*: user-specified 5% bottom-plate estimate for every physical MOM unit, not extraction.
// Series tails retain one unit parasitic at MID and one at B.
// APGATE PMOS assist connects each bottom plate to VIN.
// MID-to-VIN transmission gates provide physical initialization during PHI_S.
// Additional ENB NMOS sharing retains a common EQBUS.
XHCTL (DH HHIB DVDD VREFN VSS) mq_cdac_ctl_h
XLCTL (RL LHIB DVDD VREFN VSS) mq_cdac_ctl_l
XDH (HHIB EN ENB BH VREFP VREFN VSS DVDD) mq_cdac_drv2
CH (TOP BH) cfmom_2t w=5e-08 s=2.4e-07 nr=6 lr=1.69e-06 stm=2 spm=4 multi=1
CPH (BH VSS) capacitor c=5.01145e-17
CHA (TOP MIDH) cfmom_2t w=5e-08 s=2.4e-07 nr=6 lr=1.69e-06 stm=2 spm=4 multi=1
CPHA (MIDH VSS) capacitor c=5.01145e-17
CHB (MIDH BH) cfmom_2t w=5e-08 s=2.4e-07 nr=6 lr=1.69e-06 stm=2 spm=4 multi=1
CPHB (BH VSS) capacitor c=5.01145e-17
MSH (BH VG VIN VSS) nch_ulvt_mac w=1.2e-07 l=3e-08 nf=1
XDL (LHIB EN ENB BL VREFP VREFN VSS DVDD) mq_cdac_drv2
CL (TOP BL) cfmom_2t w=5e-08 s=2.4e-07 nr=6 lr=1.69e-06 stm=2 spm=4 multi=1
CPL (BL VSS) capacitor c=5.01145e-17
CLA (TOP MIDL) cfmom_2t w=5e-08 s=2.4e-07 nr=6 lr=1.69e-06 stm=2 spm=4 multi=1
CPLA (MIDL VSS) capacitor c=5.01145e-17
CLB (MIDL BL) cfmom_2t w=5e-08 s=2.4e-07 nr=6 lr=1.69e-06 stm=2 spm=4 multi=1
CPLB (BL VSS) capacitor c=5.01145e-17
MSL (BL VG VIN VSS) nch_ulvt_mac w=1.2e-07 l=3e-08 nf=1
MEQ1 (BH APGATE VIN VREFP) pch_ulvt_mac w=1.2e-07 l=3e-08 nf=1
MEQ2 (BL APGATE VIN VREFP) pch_ulvt_mac w=1.2e-07 l=3e-08 nf=1
MMIDNH (MIDH PHI_S VIN VSS) nch_ulvt_mac w=1.2e-07 l=3e-08 nf=1
MMIDPH (MIDH PHI_SB VIN VREFP) pch_mac w=1.2e-07 l=3e-08 nf=1
MMIDNL (MIDL PHI_S VIN VSS) nch_ulvt_mac w=1.2e-07 l=3e-08 nf=1
MMIDPL (MIDL PHI_SB VIN VREFP) pch_mac w=1.2e-07 l=3e-08 nf=1
MSHAREH (BH ENB EQBUS VSS) nch_ulvt_mac w=1.2e-07 l=3e-08 nf=1
MSHAREL (BL ENB EQBUS VSS) nch_ulvt_mac w=1.2e-07 l=3e-08 nf=1
// @RNL {
//   /* pins connected by net name: the net-name label of rnl-std-fill on every unwired pin, placed below by its key netname */
//   $LABEL_TERMINAL_SET @TEXT("${net}", key="netname", size=0.6);
//   &VSS @ADD-TO $GROUND_NET_SET; &VREFN @ADD-TO $GROUND_NET_SET;
//   &VREFP @ADD-TO $SUPPLY_NET_SET;
//   &DVDD @ADD-TO $SUPPLY_NET_SET;
//   {#CH #CL} @AS $MATCHED;
//   {#CHA #CHB #CLA #CLB} @AS $MATCHED;
//   {#CHA #CHB #CLA #CLB} @GROUP;
//   {#MSH #MSL} @AS $MATCHED;
//   {#MEQ1 #MEQ2} @AS $MATCHED;
//   {#MMIDNH #MMIDNL} @AS $MATCHED;
//   {#MMIDPH #MMIDPL} @AS $MATCHED;
//   {#MSHAREH #MSHAREL} @AS $MATCHED;
//   {#XDH #XDL} @AS $MATCHED;
//   #XHCTL @PLACE(-70, 24);
//   #XHCTL @ORIENT("R0");
//   #XHCTL:IN @TEXT("${net}", key="netname", size=0.6, halign="end", valign="middle", dx=-0.4, dy=0);
//   #XHCTL:HIB @TEXT("${net}", key="netname", size=0.6, halign="start", valign="middle", dx=0.4, dy=0);
//   %v1 = $SUPPLY @ATTACH &DVDD => @PLACE(-70, 31.2);
//   &DVDD @WIRE {#XHCTL:DVDD (-70, 28) %v1:p};
//   %g2 = $GROUND @ATTACH &VREFN => @PLACE(-72, 16.8);
//   &VREFN @WIRE {#XHCTL:VREFN (-72, 20) %g2:p};
//   %g3 = $GROUND @ATTACH &VSS => @PLACE(-68, 16.8);
//   &VSS @WIRE {#XHCTL:VSS (-68, 20) %g3:p};
//   #XLCTL @PLACE(-70, -26);
//   #XLCTL @ORIENT("R0");
//   #XLCTL:IN @TEXT("${net}", key="netname", size=0.6, halign="end", valign="middle", dx=-0.4, dy=0);
//   #XLCTL:HIB @TEXT("${net}", key="netname", size=0.6, halign="start", valign="middle", dx=0.4, dy=0);
//   %v4 = $SUPPLY @ATTACH &DVDD => @PLACE(-70, -18.8);
//   &DVDD @WIRE {#XLCTL:DVDD (-70, -22) %v4:p};
//   %g5 = $GROUND @ATTACH &VREFN => @PLACE(-72, -33.2);
//   &VREFN @WIRE {#XLCTL:VREFN (-72, -30) %g5:p};
//   %g6 = $GROUND @ATTACH &VSS => @PLACE(-68, -33.2);
//   &VSS @WIRE {#XLCTL:VSS (-68, -30) %g6:p};
//   #XDH @PLACE(-34, 24);
//   #XDH @ORIENT("R0");
//   #XDH:HIB @TEXT("${net}", key="netname", size=0.6, halign="end", valign="middle", dx=-0.4, dy=0);
//   #XDH:EN @TEXT("${net}", key="netname", size=0.6, halign="end", valign="middle", dx=-0.4, dy=0);
//   #XDH:ENB @TEXT("${net}", key="netname", size=0.6, halign="end", valign="middle", dx=-0.4, dy=0);
//   #XDH:BP @TEXT("${net}", key="netname", size=0.6, halign="start", valign="middle", dx=0.4, dy=0);
//   %v7 = $SUPPLY @ATTACH &VREFP => @PLACE(-36, 32.2);
//   &VREFP @WIRE {#XDH:VREFP (-36, 29) %v7:p};
//   %g8 = $GROUND @ATTACH &VREFN => @PLACE(-36, 15.8);
//   &VREFN @WIRE {#XDH:VREFN (-36, 19) %g8:p};
//   %g9 = $GROUND @ATTACH &VSS => @PLACE(-32, 15.8);
//   &VSS @WIRE {#XDH:VSS (-32, 19) %g9:p};
//   %v10 = $SUPPLY @ATTACH &DVDD => @PLACE(-32, 32.2);
//   &DVDD @WIRE {#XDH:DVDD (-32, 29) %v10:p};
//   #CH @PLACE(14, 24) => @ORIENT("R270");
//   #CH:1 @TEXT("${net}", key="netname", size=0.6, halign="start", valign="middle", dx=0.4, dy=0);
//   #CH:2 @TEXT("${net}", key="netname", size=0.6, halign="end", valign="middle", dx=-0.4, dy=0);
//   #CPH @PLACE(60, 20);
//   #CPH @ORIENT("R0");
//   #CPH:1 @TEXT("${net}", key="netname", size=0.6, halign="start", valign="middle", rotate=90, dx=0, dy=0.4);
//   %g11 = $GROUND @ATTACH &VSS => @PLACE(60, 14.8);
//   &VSS @WIRE {#CPH:2 (60, 18) %g11:p};
//   #CHA @PLACE(30, 38) => @ORIENT("R270");
//   #CHA:1 @TEXT("${net}", key="netname", size=0.6, halign="start", valign="middle", dx=0.4, dy=0);
//   #CHA:2 @TEXT("${net}", key="netname", size=0.6, halign="end", valign="middle", dx=-0.4, dy=0);
//   #CPHA @PLACE(76, 20);
//   #CPHA @ORIENT("R0");
//   #CPHA:1 @TEXT("${net}", key="netname", size=0.6, halign="start", valign="middle", rotate=90, dx=0, dy=0.4);
//   %g12 = $GROUND @ATTACH &VSS => @PLACE(76, 14.8);
//   &VSS @WIRE {#CPHA:2 (76, 18) %g12:p};
//   #CHB @PLACE(10, 38) => @ORIENT("R270");
//   #CHB:1 @TEXT("${net}", key="netname", size=0.6, halign="start", valign="middle", dx=0.4, dy=0);
//   #CHB:2 @TEXT("${net}", key="netname", size=0.6, halign="end", valign="middle", dx=-0.4, dy=0);
//   #CPHB @PLACE(92, 20);
//   #CPHB @ORIENT("R0");
//   #CPHB:1 @TEXT("${net}", key="netname", size=0.6, halign="start", valign="middle", rotate=90, dx=0, dy=0.4);
//   %g13 = $GROUND @ATTACH &VSS => @PLACE(92, 14.8);
//   &VSS @WIRE {#CPHB:2 (92, 18) %g13:p};
//   #MSH @PLACE(2, 8);
//   #MSH @ORIENT("R0");
//   #MSH:1 @TEXT("${net}", key="netname", size=0.6, halign="start", valign="middle", rotate=90, dx=0, dy=0.4);
//   #MSH:2 @TEXT("${net}", key="netname", size=0.6, halign="end", valign="middle", dx=-0.4, dy=0);
//   #MSH:3 @TEXT("${net}", key="netname", size=0.6, halign="end", valign="middle", rotate=90, dx=0, dy=-0.4);
//   %g14 = $GROUND @ATTACH &VSS => @PLACE(5, 4.8);
//   &VSS @WIRE {#MSH:4 (5, 8) %g14:p};
//   #XDL @PLACE(-34, -26);
//   #XDL @ORIENT("R0");
//   #XDL:HIB @TEXT("${net}", key="netname", size=0.6, halign="end", valign="middle", dx=-0.4, dy=0);
//   #XDL:EN @TEXT("${net}", key="netname", size=0.6, halign="end", valign="middle", dx=-0.4, dy=0);
//   #XDL:ENB @TEXT("${net}", key="netname", size=0.6, halign="end", valign="middle", dx=-0.4, dy=0);
//   #XDL:BP @TEXT("${net}", key="netname", size=0.6, halign="start", valign="middle", dx=0.4, dy=0);
//   %v15 = $SUPPLY @ATTACH &VREFP => @PLACE(-36, -17.8);
//   &VREFP @WIRE {#XDL:VREFP (-36, -21) %v15:p};
//   %g16 = $GROUND @ATTACH &VREFN => @PLACE(-36, -34.2);
//   &VREFN @WIRE {#XDL:VREFN (-36, -31) %g16:p};
//   %g17 = $GROUND @ATTACH &VSS => @PLACE(-32, -34.2);
//   &VSS @WIRE {#XDL:VSS (-32, -31) %g17:p};
//   %v18 = $SUPPLY @ATTACH &DVDD => @PLACE(-32, -17.8);
//   &DVDD @WIRE {#XDL:DVDD (-32, -21) %v18:p};
//   #CL @PLACE(14, -26) => @ORIENT("R270");
//   #CL:1 @TEXT("${net}", key="netname", size=0.6, halign="start", valign="middle", dx=0.4, dy=0);
//   #CL:2 @TEXT("${net}", key="netname", size=0.6, halign="end", valign="middle", dx=-0.4, dy=0);
//   #CPL @PLACE(60, -30);
//   #CPL @ORIENT("R0");
//   #CPL:1 @TEXT("${net}", key="netname", size=0.6, halign="start", valign="middle", rotate=90, dx=0, dy=0.4);
//   %g19 = $GROUND @ATTACH &VSS => @PLACE(60, -35.2);
//   &VSS @WIRE {#CPL:2 (60, -32) %g19:p};
//   #CLA @PLACE(30, -12) => @ORIENT("R270");
//   #CLA:1 @TEXT("${net}", key="netname", size=0.6, halign="start", valign="middle", dx=0.4, dy=0);
//   #CLA:2 @TEXT("${net}", key="netname", size=0.6, halign="end", valign="middle", dx=-0.4, dy=0);
//   #CPLA @PLACE(76, -30);
//   #CPLA @ORIENT("R0");
//   #CPLA:1 @TEXT("${net}", key="netname", size=0.6, halign="start", valign="middle", rotate=90, dx=0, dy=0.4);
//   %g20 = $GROUND @ATTACH &VSS => @PLACE(76, -35.2);
//   &VSS @WIRE {#CPLA:2 (76, -32) %g20:p};
//   #CLB @PLACE(10, -12) => @ORIENT("R270");
//   #CLB:1 @TEXT("${net}", key="netname", size=0.6, halign="start", valign="middle", dx=0.4, dy=0);
//   #CLB:2 @TEXT("${net}", key="netname", size=0.6, halign="end", valign="middle", dx=-0.4, dy=0);
//   #CPLB @PLACE(92, -30);
//   #CPLB @ORIENT("R0");
//   #CPLB:1 @TEXT("${net}", key="netname", size=0.6, halign="start", valign="middle", rotate=90, dx=0, dy=0.4);
//   %g21 = $GROUND @ATTACH &VSS => @PLACE(92, -35.2);
//   &VSS @WIRE {#CPLB:2 (92, -32) %g21:p};
//   #MSL @PLACE(2, -42);
//   #MSL @ORIENT("R0");
//   #MSL:1 @TEXT("${net}", key="netname", size=0.6, halign="start", valign="middle", rotate=90, dx=0, dy=0.4);
//   #MSL:2 @TEXT("${net}", key="netname", size=0.6, halign="end", valign="middle", dx=-0.4, dy=0);
//   #MSL:3 @TEXT("${net}", key="netname", size=0.6, halign="end", valign="middle", rotate=90, dx=0, dy=-0.4);
//   %g22 = $GROUND @ATTACH &VSS => @PLACE(5, -45.2);
//   &VSS @WIRE {#MSL:4 (5, -42) %g22:p};
//   #MEQ1 @PLACE(-12, 0);
//   #MEQ1 @ORIENT("R0");
//   #MEQ1:1 @TEXT("${net}", key="netname", size=0.6, halign="end", valign="middle", rotate=90, dx=0, dy=-0.4);
//   #MEQ1:2 @TEXT("${net}", key="netname", size=0.6, halign="end", valign="middle", dx=-0.4, dy=0);
//   #MEQ1:3 @TEXT("${net}", key="netname", size=0.6, halign="start", valign="middle", rotate=90, dx=0, dy=0.4);
//   %v23 = $SUPPLY @ATTACH &VREFP => @PLACE(-9, 3.2);
//   &VREFP @WIRE {#MEQ1:4 (-9, 0) %v23:p};
//   #MEQ2 @PLACE(-12, -50);
//   #MEQ2 @ORIENT("R0");
//   #MEQ2:1 @TEXT("${net}", key="netname", size=0.6, halign="end", valign="middle", rotate=90, dx=0, dy=-0.4);
//   #MEQ2:2 @TEXT("${net}", key="netname", size=0.6, halign="end", valign="middle", dx=-0.4, dy=0);
//   #MEQ2:3 @TEXT("${net}", key="netname", size=0.6, halign="start", valign="middle", rotate=90, dx=0, dy=0.4);
//   %v24 = $SUPPLY @ATTACH &VREFP => @PLACE(-9, -46.8);
//   &VREFP @WIRE {#MEQ2:4 (-9, -50) %v24:p};
//   #MMIDNH @PLACE(115, 14);
//   #MMIDNH @ORIENT("R0");
//   #MMIDNH:1 @TEXT("${net}", key="netname", size=0.6, halign="start", valign="middle", rotate=90, dx=0, dy=0.4);
//   #MMIDNH:2 @TEXT("${net}", key="netname", size=0.6, halign="end", valign="middle", dx=-0.4, dy=0);
//   #MMIDNH:3 @TEXT("${net}", key="netname", size=0.6, halign="end", valign="middle", rotate=90, dx=0, dy=-0.4);
//   %g25 = $GROUND @ATTACH &VSS => @PLACE(118, 10.8);
//   &VSS @WIRE {#MMIDNH:4 (118, 14) %g25:p};
//   #MMIDPH @PLACE(115, 32);
//   #MMIDPH @ORIENT("R0");
//   #MMIDPH:1 @TEXT("${net}", key="netname", size=0.6, halign="end", valign="middle", rotate=90, dx=0, dy=-0.4);
//   #MMIDPH:2 @TEXT("${net}", key="netname", size=0.6, halign="end", valign="middle", dx=-0.4, dy=0);
//   #MMIDPH:3 @TEXT("${net}", key="netname", size=0.6, halign="start", valign="middle", rotate=90, dx=0, dy=0.4);
//   %v26 = $SUPPLY @ATTACH &VREFP => @PLACE(118, 35.2);
//   &VREFP @WIRE {#MMIDPH:4 (118, 32) %v26:p};
//   #MMIDNL @PLACE(115, -36);
//   #MMIDNL @ORIENT("R0");
//   #MMIDNL:1 @TEXT("${net}", key="netname", size=0.6, halign="start", valign="middle", rotate=90, dx=0, dy=0.4);
//   #MMIDNL:2 @TEXT("${net}", key="netname", size=0.6, halign="end", valign="middle", dx=-0.4, dy=0);
//   #MMIDNL:3 @TEXT("${net}", key="netname", size=0.6, halign="end", valign="middle", rotate=90, dx=0, dy=-0.4);
//   %g27 = $GROUND @ATTACH &VSS => @PLACE(118, -39.2);
//   &VSS @WIRE {#MMIDNL:4 (118, -36) %g27:p};
//   #MMIDPL @PLACE(115, -18);
//   #MMIDPL @ORIENT("R0");
//   #MMIDPL:1 @TEXT("${net}", key="netname", size=0.6, halign="end", valign="middle", rotate=90, dx=0, dy=-0.4);
//   #MMIDPL:2 @TEXT("${net}", key="netname", size=0.6, halign="end", valign="middle", dx=-0.4, dy=0);
//   #MMIDPL:3 @TEXT("${net}", key="netname", size=0.6, halign="start", valign="middle", rotate=90, dx=0, dy=0.4);
//   %v28 = $SUPPLY @ATTACH &VREFP => @PLACE(118, -14.8);
//   &VREFP @WIRE {#MMIDPL:4 (118, -18) %v28:p};
//   #MSHAREH @PLACE(56, -2);
//   #MSHAREH @ORIENT("R0");
//   #MSHAREH:1 @TEXT("${net}", key="netname", size=0.6, halign="start", valign="middle", rotate=90, dx=0, dy=0.4);
//   #MSHAREH:2 @TEXT("${net}", key="netname", size=0.6, halign="end", valign="middle", dx=-0.4, dy=0);
//   #MSHAREH:3 @TEXT("${net}", key="netname", size=0.6, halign="end", valign="middle", rotate=90, dx=0, dy=-0.4);
//   %g29 = $GROUND @ATTACH &VSS => @PLACE(59, -5.2);
//   &VSS @WIRE {#MSHAREH:4 (59, -2) %g29:p};
//   #MSHAREL @PLACE(56, -52);
//   #MSHAREL @ORIENT("R0");
//   #MSHAREL:1 @TEXT("${net}", key="netname", size=0.6, halign="start", valign="middle", rotate=90, dx=0, dy=0.4);
//   #MSHAREL:2 @TEXT("${net}", key="netname", size=0.6, halign="end", valign="middle", dx=-0.4, dy=0);
//   #MSHAREL:3 @TEXT("${net}", key="netname", size=0.6, halign="end", valign="middle", rotate=90, dx=0, dy=-0.4);
//   %g30 = $GROUND @ATTACH &VSS => @PLACE(59, -55.2);
//   &VSS @WIRE {#MSHAREL:4 (59, -52) %g30:p};
//   &HHIB @WIRE {#XHCTL:HIB (-52, 24) (-52, 26) #XDH:HIB};
//   %b_H = (-12, 24);
//   $JUNCTION @ATTACH %b_H;
//   &BH @WIRE {#XDH:BP %b_H};
//   &BH @WIRE {%b_H #CH:2};
//   &MIDH @WIRE {#CHB:1 #CHA:2};
//   &BH @WIRE {%b_H (-12, 38) #CHB:2};
//   &BH @WIRE {%b_H (-12, 10) #MSH:1};
//   &BH @WIRE {%b_H #MEQ1:1};
//   &LHIB @WIRE {#XLCTL:HIB (-52, -26) (-52, -24) #XDL:HIB};
//   %b_L = (-12, -26);
//   $JUNCTION @ATTACH %b_L;
//   &BL @WIRE {#XDL:BP %b_L};
//   &BL @WIRE {%b_L #CL:2};
//   &MIDL @WIRE {#CLB:1 #CLA:2};
//   &BL @WIRE {%b_L (-12, -12) #CLB:2};
//   &BL @WIRE {%b_L (-12, -40) #MSL:1};
//   &BL @WIRE {%b_L #MEQ2:1};
//   &VIN @WIRE {#MSH:3 (6, 6) (6, -44) #MSL:3};
//   &VG @WIRE {#MSH:2 (-5, 8) (-5, -42) #MSL:2};
//   %top_H = (44, 24);
//   $JUNCTION @ATTACH %top_H;
//   %top_L = (44, -26);
//   $JUNCTION @ATTACH %top_L;
//   &TOP @WIRE {#CHA:1 (44, 38) %top_H};
//   &TOP @WIRE {#CH:1 %top_H};
//   &TOP @WIRE {#CLA:1 (44, -12) %top_L};
//   &TOP @WIRE {#CL:1 %top_L};
//   &TOP @WIRE {%top_H %top_L};
//   &MIDH @WIRE {#MMIDNH:1 #MMIDPH:1};
//   &MIDL @WIRE {#MMIDNL:1 #MMIDPL:1};
//   %p_vin = $IO_PORT @ATTACH &VIN => @PLACE(2, 2) => @ORIENT("R90");
//   &VIN @WIRE {%p_vin:p #MSH:3};
//   %p_vg = $IO_PORT @ATTACH &VG => @PLACE(-5, 8) => @ORIENT("R0");
//   &VG @WIRE {%p_vg:p #MSH:2};
//   %p_dh = $IO_PORT @ATTACH &DH => @PLACE(-81, 24) => @ORIENT("R0");
//   &DH @WIRE {%p_dh:p #XHCTL:IN};
//   %p_rl = $IO_PORT @ATTACH &RL => @PLACE(-81, -26) => @ORIENT("R0");
//   &RL @WIRE {%p_rl:p #XLCTL:IN};
//   %p_en = $IO_PORT @ATTACH &EN => @PLACE(-45, 24) => @ORIENT("R0");
//   &EN @WIRE {%p_en:p #XDH:EN};
//   %p_enb = $IO_PORT @ATTACH &ENB => @PLACE(-45, 22) => @ORIENT("R0");
//   &ENB @WIRE {%p_enb:p #XDH:ENB};
//   %p_top = $IO_PORT @ATTACH &TOP => @PLACE(20, 24) => @ORIENT("MY");
//   &TOP @WIRE {%p_top:p #CH:1};
//   %p_phi_s = $IO_PORT @ATTACH &PHI_S => @PLACE(108, 14) => @ORIENT("R0");
//   &PHI_S @WIRE {%p_phi_s:p #MMIDNH:2};
//   %p_phi_sb = $IO_PORT @ATTACH &PHI_SB => @PLACE(108, 32) => @ORIENT("R0");
//   &PHI_SB @WIRE {%p_phi_sb:p #MMIDPH:2};
//   %p_eqbus = $IO_PORT @ATTACH &EQBUS => @PLACE(56, -8) => @ORIENT("R90");
//   &EQBUS @WIRE {%p_eqbus:p #MSHAREH:3};
//   %p_apgate = $IO_PORT @ATTACH &APGATE => @PLACE(-19, 0) => @ORIENT("R0");
//   &APGATE @WIRE {%p_apgate:p #MEQ1:2};
//   (-10, 60) @TEXT("Matched half-capacitor pair j=2") => @SET-STYLE $title_style
// }
ends mq_cdac_bit2

// Reference-rail output driver j=1
subckt mq_cdac_drv1 (HIB EN ENB BP VREFP VREFN VSS DVDD)
// DVDD prelogic: PCOND = NOR(ENB,HIB); NOFF = NAND(EN,HIB).
// Reference-powered final inverters restore GP and GN to VREFP/VREFN.
// Actual current overlap, settling and device stress require measurement.
MPA0 (AP ENB DVDD DVDD) pch_ulvt_mac w=2.4e-07 l=3e-08 nf=1
MPA1 (PCOND HIB AP DVDD) pch_ulvt_mac w=2.4e-07 l=3e-08 nf=1
MNA0 (PCOND ENB VREFN VSS) nch_ulvt_mac w=1.2e-07 l=3e-08 nf=1
MNA1 (PCOND HIB VREFN VSS) nch_ulvt_mac w=1.2e-07 l=3e-08 nf=1
MPB0 (NOFF EN DVDD DVDD) pch_ulvt_mac w=1.2e-07 l=3e-08 nf=1
MPB1 (NOFF HIB DVDD DVDD) pch_ulvt_mac w=1.2e-07 l=3e-08 nf=1
MNB0 (NOFF EN BN VSS) nch_ulvt_mac w=1.2e-07 l=3e-08 nf=1
MNB1 (BN HIB VREFN VSS) nch_ulvt_mac w=1.2e-07 l=3e-08 nf=1
MGPN (GP PCOND VREFN VSS) nch_mac w=2.4e-07 l=3e-08 nf=1
MGPP (GP PCOND VREFP VREFP) pch_mac w=3.6e-07 l=3e-08 nf=1
MGNN (GN NOFF VREFN VSS) nch_mac w=2.4e-07 l=3e-08 nf=1
MGNP (GN NOFF VREFP VREFP) pch_mac w=1.2e-07 l=3e-08 nf=1
MNOUT (BP GN VREFN VSS) nch_mac w=1.2e-07 l=3e-08 nf=1
MPOUT (BP GP VREFP VREFP) pch_mac w=2.4e-07 l=3e-08 nf=1
// @RNL {
//   /* pins connected by net name: the net-name label of rnl-std-fill on every unwired pin, placed below by its key netname */
//   $LABEL_TERMINAL_SET @TEXT("${net}", key="netname", size=0.6);
//   &VSS @ADD-TO $GROUND_NET_SET; &VREFN @ADD-TO $GROUND_NET_SET;
//   &VREFP @ADD-TO $SUPPLY_NET_SET;
//   &DVDD @ADD-TO $SUPPLY_NET_SET;
//   {#MPA0 #MPA1 #MNA0 #MNA1} @GROUP;
//   {#MPB0 #MPB1 #MNB0 #MNB1} @GROUP;
//   {#MGPN #MGPP} @GROUP;
//   {#MGNN #MGNP} @GROUP;
//   {#MNOUT #MPOUT} @GROUP;
//   #MPA0 @PLACE(12, 40);
//   #MPA0 @ORIENT("R0");
//   #MPA0:1 @TEXT("${net}", key="netname", size=0.6, halign="end", valign="middle", rotate=90, dx=0, dy=-0.4);
//   #MPA0:2 @TEXT("${net}", key="netname", size=0.6, halign="end", valign="middle", dx=-0.4, dy=0);
//   %v1 = $SUPPLY @ATTACH &DVDD => @PLACE(12, 45.2);
//   &DVDD @WIRE {#MPA0:3 (12, 42) %v1:p};
//   %v2 = $SUPPLY @ATTACH &DVDD => @PLACE(15, 43.2);
//   &DVDD @WIRE {#MPA0:4 (15, 40) %v2:p};
//   #MPA1 @PLACE(12, 26);
//   #MPA1 @ORIENT("R0");
//   #MPA1:1 @TEXT("${net}", key="netname", size=0.6, halign="end", valign="middle", rotate=90, dx=0, dy=-0.4);
//   #MPA1:2 @TEXT("${net}", key="netname", size=0.6, halign="end", valign="middle", dx=-0.4, dy=0);
//   #MPA1:3 @TEXT("${net}", key="netname", size=0.6, halign="start", valign="middle", rotate=90, dx=0, dy=0.4);
//   %v3 = $SUPPLY @ATTACH &DVDD => @PLACE(15, 29.2);
//   &DVDD @WIRE {#MPA1:4 (15, 26) %v3:p};
//   #MNA0 @PLACE(0, 2);
//   #MNA0 @ORIENT("R0");
//   #MNA0:1 @TEXT("${net}", key="netname", size=0.6, halign="start", valign="middle", rotate=90, dx=0, dy=0.4);
//   #MNA0:2 @TEXT("${net}", key="netname", size=0.6, halign="end", valign="middle", dx=-0.4, dy=0);
//   %g4 = $GROUND @ATTACH &VREFN => @PLACE(0, -3.2);
//   &VREFN @WIRE {#MNA0:3 (0, 0) %g4:p};
//   %g5 = $GROUND @ATTACH &VSS => @PLACE(3, -1.2);
//   &VSS @WIRE {#MNA0:4 (3, 2) %g5:p};
//   #MNA1 @PLACE(24, 2);
//   #MNA1 @ORIENT("R0");
//   #MNA1:1 @TEXT("${net}", key="netname", size=0.6, halign="start", valign="middle", rotate=90, dx=0, dy=0.4);
//   #MNA1:2 @TEXT("${net}", key="netname", size=0.6, halign="end", valign="middle", dx=-0.4, dy=0);
//   %g6 = $GROUND @ATTACH &VREFN => @PLACE(24, -3.2);
//   &VREFN @WIRE {#MNA1:3 (24, 0) %g6:p};
//   %g7 = $GROUND @ATTACH &VSS => @PLACE(27, -1.2);
//   &VSS @WIRE {#MNA1:4 (27, 2) %g7:p};
//   #MPB0 @PLACE(96, 30);
//   #MPB0 @ORIENT("R0");
//   #MPB0:1 @TEXT("${net}", key="netname", size=0.6, halign="end", valign="middle", rotate=90, dx=0, dy=-0.4);
//   #MPB0:2 @TEXT("${net}", key="netname", size=0.6, halign="end", valign="middle", dx=-0.4, dy=0);
//   %v8 = $SUPPLY @ATTACH &DVDD => @PLACE(96, 35.2);
//   &DVDD @WIRE {#MPB0:3 (96, 32) %v8:p};
//   %v9 = $SUPPLY @ATTACH &DVDD => @PLACE(99, 33.2);
//   &DVDD @WIRE {#MPB0:4 (99, 30) %v9:p};
//   #MPB1 @PLACE(120, 30);
//   #MPB1 @ORIENT("R0");
//   #MPB1:1 @TEXT("${net}", key="netname", size=0.6, halign="end", valign="middle", rotate=90, dx=0, dy=-0.4);
//   #MPB1:2 @TEXT("${net}", key="netname", size=0.6, halign="end", valign="middle", dx=-0.4, dy=0);
//   %v10 = $SUPPLY @ATTACH &DVDD => @PLACE(120, 35.2);
//   &DVDD @WIRE {#MPB1:3 (120, 32) %v10:p};
//   %v11 = $SUPPLY @ATTACH &DVDD => @PLACE(123, 33.2);
//   &DVDD @WIRE {#MPB1:4 (123, 30) %v11:p};
//   #MNB0 @PLACE(108, 12);
//   #MNB0 @ORIENT("R0");
//   #MNB0:1 @TEXT("${net}", key="netname", size=0.6, halign="start", valign="middle", rotate=90, dx=0, dy=0.4);
//   #MNB0:2 @TEXT("${net}", key="netname", size=0.6, halign="end", valign="middle", dx=-0.4, dy=0);
//   #MNB0:3 @TEXT("${net}", key="netname", size=0.6, halign="end", valign="middle", rotate=90, dx=0, dy=-0.4);
//   %g12 = $GROUND @ATTACH &VSS => @PLACE(111, 8.8);
//   &VSS @WIRE {#MNB0:4 (111, 12) %g12:p};
//   #MNB1 @PLACE(108, -2);
//   #MNB1 @ORIENT("R0");
//   #MNB1:1 @TEXT("${net}", key="netname", size=0.6, halign="start", valign="middle", rotate=90, dx=0, dy=0.4);
//   #MNB1:2 @TEXT("${net}", key="netname", size=0.6, halign="end", valign="middle", dx=-0.4, dy=0);
//   %g13 = $GROUND @ATTACH &VREFN => @PLACE(108, -7.2);
//   &VREFN @WIRE {#MNB1:3 (108, -4) %g13:p};
//   %g14 = $GROUND @ATTACH &VSS => @PLACE(111, -5.2);
//   &VSS @WIRE {#MNB1:4 (111, -2) %g14:p};
//   #MGPN @PLACE(64, 2);
//   #MGPN @ORIENT("R0");
//   #MGPN:1 @TEXT("${net}", key="netname", size=0.6, halign="start", valign="middle", rotate=90, dx=0, dy=0.4);
//   #MGPN:2 @TEXT("${net}", key="netname", size=0.6, halign="end", valign="middle", dx=-0.4, dy=0);
//   %g15 = $GROUND @ATTACH &VREFN => @PLACE(64, -3.2);
//   &VREFN @WIRE {#MGPN:3 (64, 0) %g15:p};
//   %g16 = $GROUND @ATTACH &VSS => @PLACE(67, -1.2);
//   &VSS @WIRE {#MGPN:4 (67, 2) %g16:p};
//   #MGPP @PLACE(64, 12);
//   #MGPP @ORIENT("R0");
//   #MGPP:1 @TEXT("${net}", key="netname", size=0.6, halign="end", valign="middle", rotate=90, dx=0, dy=-0.4);
//   #MGPP:2 @TEXT("${net}", key="netname", size=0.6, halign="end", valign="middle", dx=-0.4, dy=0);
//   %v17 = $SUPPLY @ATTACH &VREFP => @PLACE(64, 17.2);
//   &VREFP @WIRE {#MGPP:3 (64, 14) %v17:p};
//   %v18 = $SUPPLY @ATTACH &VREFP => @PLACE(67, 15.2);
//   &VREFP @WIRE {#MGPP:4 (67, 12) %v18:p};
//   #MGNN @PLACE(160, 2);
//   #MGNN @ORIENT("R0");
//   #MGNN:1 @TEXT("${net}", key="netname", size=0.6, halign="start", valign="middle", rotate=90, dx=0, dy=0.4);
//   #MGNN:2 @TEXT("${net}", key="netname", size=0.6, halign="end", valign="middle", dx=-0.4, dy=0);
//   %g19 = $GROUND @ATTACH &VREFN => @PLACE(160, -3.2);
//   &VREFN @WIRE {#MGNN:3 (160, 0) %g19:p};
//   %g20 = $GROUND @ATTACH &VSS => @PLACE(163, -1.2);
//   &VSS @WIRE {#MGNN:4 (163, 2) %g20:p};
//   #MGNP @PLACE(160, 12);
//   #MGNP @ORIENT("R0");
//   #MGNP:1 @TEXT("${net}", key="netname", size=0.6, halign="end", valign="middle", rotate=90, dx=0, dy=-0.4);
//   #MGNP:2 @TEXT("${net}", key="netname", size=0.6, halign="end", valign="middle", dx=-0.4, dy=0);
//   %v21 = $SUPPLY @ATTACH &VREFP => @PLACE(160, 17.2);
//   &VREFP @WIRE {#MGNP:3 (160, 14) %v21:p};
//   %v22 = $SUPPLY @ATTACH &VREFP => @PLACE(163, 15.2);
//   &VREFP @WIRE {#MGNP:4 (163, 12) %v22:p};
//   #MNOUT @PLACE(200, 0);
//   #MNOUT @ORIENT("R0");
//   #MNOUT:1 @TEXT("${net}", key="netname", size=0.6, halign="start", valign="middle", rotate=90, dx=0, dy=0.4);
//   #MNOUT:2 @TEXT("${net}", key="netname", size=0.6, halign="end", valign="middle", dx=-0.4, dy=0);
//   %g23 = $GROUND @ATTACH &VREFN => @PLACE(200, -5.2);
//   &VREFN @WIRE {#MNOUT:3 (200, -2) %g23:p};
//   %g24 = $GROUND @ATTACH &VSS => @PLACE(203, -3.2);
//   &VSS @WIRE {#MNOUT:4 (203, 0) %g24:p};
//   #MPOUT @PLACE(200, 22);
//   #MPOUT @ORIENT("R0");
//   #MPOUT:1 @TEXT("${net}", key="netname", size=0.6, halign="end", valign="middle", rotate=90, dx=0, dy=-0.4);
//   #MPOUT:2 @TEXT("${net}", key="netname", size=0.6, halign="end", valign="middle", dx=-0.4, dy=0);
//   %v25 = $SUPPLY @ATTACH &VREFP => @PLACE(200, 27.2);
//   &VREFP @WIRE {#MPOUT:3 (200, 24) %v25:p};
//   %v26 = $SUPPLY @ATTACH &VREFP => @PLACE(203, 25.2);
//   &VREFP @WIRE {#MPOUT:4 (203, 22) %v26:p};
//   &GP @WIRE {#MGPN:1 #MGPP:1};
//   &PCOND @WIRE {#MGPN:2 (59, 2) (59, 12) #MGPP:2};
//   &GN @WIRE {#MGNN:1 #MGNP:1};
//   &NOFF @WIRE {#MGNN:2 (155, 2) (155, 12) #MGNP:2};
//   &AP @WIRE {#MPA0:1 #MPA1:3};
//   %pc_bus = (12, 16);
//   $JUNCTION @ATTACH %pc_bus;
//   &PCOND @WIRE {#MNA0:1 (0, 16) %pc_bus (24, 16) #MNA1:1};
//   &PCOND @WIRE {#MPA1:1 %pc_bus};
//   %pc_gate = (59, 7);
//   $JUNCTION @ATTACH %pc_gate;
//   &PCOND @WIRE {%pc_bus (50, 16) (50, 7) %pc_gate};
//   &BN @WIRE {#MNB0:3 #MNB1:1};
//   %no_bus = (108, 22);
//   $JUNCTION @ATTACH %no_bus;
//   &NOFF @WIRE {#MPB0:1 (96, 22) %no_bus (120, 22) #MPB1:1};
//   &NOFF @WIRE {#MNB0:1 %no_bus};
//   %no_gate = (155, 7);
//   $JUNCTION @ATTACH %no_gate;
//   &NOFF @WIRE {%no_bus (146, 22) (146, 7) %no_gate};
//   &BP @WIRE {#MNOUT:1 #MPOUT:1};
//   &GP @WIRE {#MGPN:1 (74, 4) (74, 52) (190, 52) (190, 22) #MPOUT:2};
//   &GN @WIRE {#MGNN:1 (180, 4) (180, 0) #MNOUT:2};
//   %p_hib = $IO_PORT @ATTACH &HIB => @PLACE(5, 26) => @ORIENT("R0");
//   &HIB @WIRE {%p_hib:p #MPA1:2};
//   %p_en = $IO_PORT @ATTACH &EN => @PLACE(89, 30) => @ORIENT("R0");
//   &EN @WIRE {%p_en:p #MPB0:2};
//   %p_enb = $IO_PORT @ATTACH &ENB => @PLACE(5, 40) => @ORIENT("R0");
//   &ENB @WIRE {%p_enb:p #MPA0:2};
//   %p_bp = $IO_PORT @ATTACH &BP => @PLACE(200, 6) => @ORIENT("R270");
//   &BP @WIRE {%p_bp:p #MNOUT:1};
//   (-10, 62) @TEXT("Reference-rail output driver j=1") => @SET-STYLE $title_style
// }
ends mq_cdac_drv1

// Matched half-capacitor pair j=1
subckt mq_cdac_bit1 (VIN VG DH RL EN ENB TOP VREFP VREFN VSS DVDD EQBUS APGATE)
// CP*: user-specified 5% bottom-plate estimate for every physical MOM unit, not extraction.
// Series tails retain one unit parasitic at MID and one at B.
// APGATE PMOS assist connects each bottom plate to VIN.
// Additional ENB NMOS sharing retains a common EQBUS.
XHCTL (DH HHIB DVDD VREFN VSS) mq_cdac_ctl_h
XLCTL (RL LHIB DVDD VREFN VSS) mq_cdac_ctl_l
XDH (HHIB EN ENB BH VREFP VREFN VSS DVDD) mq_cdac_drv1
CH (TOP BH) cfmom_2t w=5e-08 s=2.4e-07 nr=6 lr=1.69e-06 stm=2 spm=4 multi=1
CPH (BH VSS) capacitor c=5.01145e-17
MSH (BH VG VIN VSS) nch_ulvt_mac w=1.2e-07 l=3e-08 nf=1
XDL (LHIB EN ENB BL VREFP VREFN VSS DVDD) mq_cdac_drv1
CL (TOP BL) cfmom_2t w=5e-08 s=2.4e-07 nr=6 lr=1.69e-06 stm=2 spm=4 multi=1
CPL (BL VSS) capacitor c=5.01145e-17
MSL (BL VG VIN VSS) nch_ulvt_mac w=1.2e-07 l=3e-08 nf=1
MEQ1 (BH APGATE VIN VREFP) pch_ulvt_mac w=1.2e-07 l=3e-08 nf=1
MEQ2 (BL APGATE VIN VREFP) pch_ulvt_mac w=1.2e-07 l=3e-08 nf=1
MSHAREH (BH ENB EQBUS VSS) nch_ulvt_mac w=1.2e-07 l=3e-08 nf=1
MSHAREL (BL ENB EQBUS VSS) nch_ulvt_mac w=1.2e-07 l=3e-08 nf=1
// @RNL {
//   /* pins connected by net name: the net-name label of rnl-std-fill on every unwired pin, placed below by its key netname */
//   $LABEL_TERMINAL_SET @TEXT("${net}", key="netname", size=0.6);
//   &VSS @ADD-TO $GROUND_NET_SET; &VREFN @ADD-TO $GROUND_NET_SET;
//   &VREFP @ADD-TO $SUPPLY_NET_SET;
//   &DVDD @ADD-TO $SUPPLY_NET_SET;
//   {#CH #CL} @AS $MATCHED;
//   {#MSH #MSL} @AS $MATCHED;
//   {#MEQ1 #MEQ2} @AS $MATCHED;
//   {#MSHAREH #MSHAREL} @AS $MATCHED;
//   {#XDH #XDL} @AS $MATCHED;
//   #XHCTL @PLACE(-70, 24);
//   #XHCTL @ORIENT("R0");
//   #XHCTL:IN @TEXT("${net}", key="netname", size=0.6, halign="end", valign="middle", dx=-0.4, dy=0);
//   #XHCTL:HIB @TEXT("${net}", key="netname", size=0.6, halign="start", valign="middle", dx=0.4, dy=0);
//   %v1 = $SUPPLY @ATTACH &DVDD => @PLACE(-70, 31.2);
//   &DVDD @WIRE {#XHCTL:DVDD (-70, 28) %v1:p};
//   %g2 = $GROUND @ATTACH &VREFN => @PLACE(-72, 16.8);
//   &VREFN @WIRE {#XHCTL:VREFN (-72, 20) %g2:p};
//   %g3 = $GROUND @ATTACH &VSS => @PLACE(-68, 16.8);
//   &VSS @WIRE {#XHCTL:VSS (-68, 20) %g3:p};
//   #XLCTL @PLACE(-70, -26);
//   #XLCTL @ORIENT("R0");
//   #XLCTL:IN @TEXT("${net}", key="netname", size=0.6, halign="end", valign="middle", dx=-0.4, dy=0);
//   #XLCTL:HIB @TEXT("${net}", key="netname", size=0.6, halign="start", valign="middle", dx=0.4, dy=0);
//   %v4 = $SUPPLY @ATTACH &DVDD => @PLACE(-70, -18.8);
//   &DVDD @WIRE {#XLCTL:DVDD (-70, -22) %v4:p};
//   %g5 = $GROUND @ATTACH &VREFN => @PLACE(-72, -33.2);
//   &VREFN @WIRE {#XLCTL:VREFN (-72, -30) %g5:p};
//   %g6 = $GROUND @ATTACH &VSS => @PLACE(-68, -33.2);
//   &VSS @WIRE {#XLCTL:VSS (-68, -30) %g6:p};
//   #XDH @PLACE(-34, 24);
//   #XDH @ORIENT("R0");
//   #XDH:HIB @TEXT("${net}", key="netname", size=0.6, halign="end", valign="middle", dx=-0.4, dy=0);
//   #XDH:EN @TEXT("${net}", key="netname", size=0.6, halign="end", valign="middle", dx=-0.4, dy=0);
//   #XDH:ENB @TEXT("${net}", key="netname", size=0.6, halign="end", valign="middle", dx=-0.4, dy=0);
//   #XDH:BP @TEXT("${net}", key="netname", size=0.6, halign="start", valign="middle", dx=0.4, dy=0);
//   %v7 = $SUPPLY @ATTACH &VREFP => @PLACE(-36, 32.2);
//   &VREFP @WIRE {#XDH:VREFP (-36, 29) %v7:p};
//   %g8 = $GROUND @ATTACH &VREFN => @PLACE(-36, 15.8);
//   &VREFN @WIRE {#XDH:VREFN (-36, 19) %g8:p};
//   %g9 = $GROUND @ATTACH &VSS => @PLACE(-32, 15.8);
//   &VSS @WIRE {#XDH:VSS (-32, 19) %g9:p};
//   %v10 = $SUPPLY @ATTACH &DVDD => @PLACE(-32, 32.2);
//   &DVDD @WIRE {#XDH:DVDD (-32, 29) %v10:p};
//   #CH @PLACE(14, 24) => @ORIENT("R270");
//   #CH:1 @TEXT("${net}", key="netname", size=0.6, halign="start", valign="middle", dx=0.4, dy=0);
//   #CH:2 @TEXT("${net}", key="netname", size=0.6, halign="end", valign="middle", dx=-0.4, dy=0);
//   #CPH @PLACE(60, 20);
//   #CPH @ORIENT("R0");
//   #CPH:1 @TEXT("${net}", key="netname", size=0.6, halign="start", valign="middle", rotate=90, dx=0, dy=0.4);
//   %g11 = $GROUND @ATTACH &VSS => @PLACE(60, 14.8);
//   &VSS @WIRE {#CPH:2 (60, 18) %g11:p};
//   #MSH @PLACE(2, 8);
//   #MSH @ORIENT("R0");
//   #MSH:1 @TEXT("${net}", key="netname", size=0.6, halign="start", valign="middle", rotate=90, dx=0, dy=0.4);
//   #MSH:2 @TEXT("${net}", key="netname", size=0.6, halign="end", valign="middle", dx=-0.4, dy=0);
//   #MSH:3 @TEXT("${net}", key="netname", size=0.6, halign="end", valign="middle", rotate=90, dx=0, dy=-0.4);
//   %g12 = $GROUND @ATTACH &VSS => @PLACE(5, 4.8);
//   &VSS @WIRE {#MSH:4 (5, 8) %g12:p};
//   #XDL @PLACE(-34, -26);
//   #XDL @ORIENT("R0");
//   #XDL:HIB @TEXT("${net}", key="netname", size=0.6, halign="end", valign="middle", dx=-0.4, dy=0);
//   #XDL:EN @TEXT("${net}", key="netname", size=0.6, halign="end", valign="middle", dx=-0.4, dy=0);
//   #XDL:ENB @TEXT("${net}", key="netname", size=0.6, halign="end", valign="middle", dx=-0.4, dy=0);
//   #XDL:BP @TEXT("${net}", key="netname", size=0.6, halign="start", valign="middle", dx=0.4, dy=0);
//   %v13 = $SUPPLY @ATTACH &VREFP => @PLACE(-36, -17.8);
//   &VREFP @WIRE {#XDL:VREFP (-36, -21) %v13:p};
//   %g14 = $GROUND @ATTACH &VREFN => @PLACE(-36, -34.2);
//   &VREFN @WIRE {#XDL:VREFN (-36, -31) %g14:p};
//   %g15 = $GROUND @ATTACH &VSS => @PLACE(-32, -34.2);
//   &VSS @WIRE {#XDL:VSS (-32, -31) %g15:p};
//   %v16 = $SUPPLY @ATTACH &DVDD => @PLACE(-32, -17.8);
//   &DVDD @WIRE {#XDL:DVDD (-32, -21) %v16:p};
//   #CL @PLACE(14, -26) => @ORIENT("R270");
//   #CL:1 @TEXT("${net}", key="netname", size=0.6, halign="start", valign="middle", dx=0.4, dy=0);
//   #CL:2 @TEXT("${net}", key="netname", size=0.6, halign="end", valign="middle", dx=-0.4, dy=0);
//   #CPL @PLACE(60, -30);
//   #CPL @ORIENT("R0");
//   #CPL:1 @TEXT("${net}", key="netname", size=0.6, halign="start", valign="middle", rotate=90, dx=0, dy=0.4);
//   %g17 = $GROUND @ATTACH &VSS => @PLACE(60, -35.2);
//   &VSS @WIRE {#CPL:2 (60, -32) %g17:p};
//   #MSL @PLACE(2, -42);
//   #MSL @ORIENT("R0");
//   #MSL:1 @TEXT("${net}", key="netname", size=0.6, halign="start", valign="middle", rotate=90, dx=0, dy=0.4);
//   #MSL:2 @TEXT("${net}", key="netname", size=0.6, halign="end", valign="middle", dx=-0.4, dy=0);
//   #MSL:3 @TEXT("${net}", key="netname", size=0.6, halign="end", valign="middle", rotate=90, dx=0, dy=-0.4);
//   %g18 = $GROUND @ATTACH &VSS => @PLACE(5, -45.2);
//   &VSS @WIRE {#MSL:4 (5, -42) %g18:p};
//   #MEQ1 @PLACE(-12, 0);
//   #MEQ1 @ORIENT("R0");
//   #MEQ1:1 @TEXT("${net}", key="netname", size=0.6, halign="end", valign="middle", rotate=90, dx=0, dy=-0.4);
//   #MEQ1:2 @TEXT("${net}", key="netname", size=0.6, halign="end", valign="middle", dx=-0.4, dy=0);
//   #MEQ1:3 @TEXT("${net}", key="netname", size=0.6, halign="start", valign="middle", rotate=90, dx=0, dy=0.4);
//   %v19 = $SUPPLY @ATTACH &VREFP => @PLACE(-9, 3.2);
//   &VREFP @WIRE {#MEQ1:4 (-9, 0) %v19:p};
//   #MEQ2 @PLACE(-12, -50);
//   #MEQ2 @ORIENT("R0");
//   #MEQ2:1 @TEXT("${net}", key="netname", size=0.6, halign="end", valign="middle", rotate=90, dx=0, dy=-0.4);
//   #MEQ2:2 @TEXT("${net}", key="netname", size=0.6, halign="end", valign="middle", dx=-0.4, dy=0);
//   #MEQ2:3 @TEXT("${net}", key="netname", size=0.6, halign="start", valign="middle", rotate=90, dx=0, dy=0.4);
//   %v20 = $SUPPLY @ATTACH &VREFP => @PLACE(-9, -46.8);
//   &VREFP @WIRE {#MEQ2:4 (-9, -50) %v20:p};
//   #MSHAREH @PLACE(56, -2);
//   #MSHAREH @ORIENT("R0");
//   #MSHAREH:1 @TEXT("${net}", key="netname", size=0.6, halign="start", valign="middle", rotate=90, dx=0, dy=0.4);
//   #MSHAREH:2 @TEXT("${net}", key="netname", size=0.6, halign="end", valign="middle", dx=-0.4, dy=0);
//   #MSHAREH:3 @TEXT("${net}", key="netname", size=0.6, halign="end", valign="middle", rotate=90, dx=0, dy=-0.4);
//   %g21 = $GROUND @ATTACH &VSS => @PLACE(59, -5.2);
//   &VSS @WIRE {#MSHAREH:4 (59, -2) %g21:p};
//   #MSHAREL @PLACE(56, -52);
//   #MSHAREL @ORIENT("R0");
//   #MSHAREL:1 @TEXT("${net}", key="netname", size=0.6, halign="start", valign="middle", rotate=90, dx=0, dy=0.4);
//   #MSHAREL:2 @TEXT("${net}", key="netname", size=0.6, halign="end", valign="middle", dx=-0.4, dy=0);
//   #MSHAREL:3 @TEXT("${net}", key="netname", size=0.6, halign="end", valign="middle", rotate=90, dx=0, dy=-0.4);
//   %g22 = $GROUND @ATTACH &VSS => @PLACE(59, -55.2);
//   &VSS @WIRE {#MSHAREL:4 (59, -52) %g22:p};
//   &HHIB @WIRE {#XHCTL:HIB (-52, 24) (-52, 26) #XDH:HIB};
//   %b_H = (-12, 24);
//   $JUNCTION @ATTACH %b_H;
//   &BH @WIRE {#XDH:BP %b_H};
//   &BH @WIRE {%b_H #CH:2};
//   &BH @WIRE {%b_H (-12, 10) #MSH:1};
//   &BH @WIRE {%b_H #MEQ1:1};
//   &LHIB @WIRE {#XLCTL:HIB (-52, -26) (-52, -24) #XDL:HIB};
//   %b_L = (-12, -26);
//   $JUNCTION @ATTACH %b_L;
//   &BL @WIRE {#XDL:BP %b_L};
//   &BL @WIRE {%b_L #CL:2};
//   &BL @WIRE {%b_L (-12, -40) #MSL:1};
//   &BL @WIRE {%b_L #MEQ2:1};
//   &VIN @WIRE {#MSH:3 (6, 6) (6, -44) #MSL:3};
//   &VG @WIRE {#MSH:2 (-5, 8) (-5, -42) #MSL:2};
//   %top_H = (44, 24);
//   $JUNCTION @ATTACH %top_H;
//   %top_L = (44, -26);
//   $JUNCTION @ATTACH %top_L;
//   &TOP @WIRE {#CH:1 %top_H};
//   &TOP @WIRE {#CL:1 %top_L};
//   &TOP @WIRE {%top_H %top_L};
//   %p_vin = $IO_PORT @ATTACH &VIN => @PLACE(2, 2) => @ORIENT("R90");
//   &VIN @WIRE {%p_vin:p #MSH:3};
//   %p_vg = $IO_PORT @ATTACH &VG => @PLACE(-5, 8) => @ORIENT("R0");
//   &VG @WIRE {%p_vg:p #MSH:2};
//   %p_dh = $IO_PORT @ATTACH &DH => @PLACE(-81, 24) => @ORIENT("R0");
//   &DH @WIRE {%p_dh:p #XHCTL:IN};
//   %p_rl = $IO_PORT @ATTACH &RL => @PLACE(-81, -26) => @ORIENT("R0");
//   &RL @WIRE {%p_rl:p #XLCTL:IN};
//   %p_en = $IO_PORT @ATTACH &EN => @PLACE(-45, 24) => @ORIENT("R0");
//   &EN @WIRE {%p_en:p #XDH:EN};
//   %p_enb = $IO_PORT @ATTACH &ENB => @PLACE(-45, 22) => @ORIENT("R0");
//   &ENB @WIRE {%p_enb:p #XDH:ENB};
//   %p_top = $IO_PORT @ATTACH &TOP => @PLACE(20, 24) => @ORIENT("MY");
//   &TOP @WIRE {%p_top:p #CH:1};
//   %p_eqbus = $IO_PORT @ATTACH &EQBUS => @PLACE(56, -8) => @ORIENT("R90");
//   &EQBUS @WIRE {%p_eqbus:p #MSHAREH:3};
//   %p_apgate = $IO_PORT @ATTACH &APGATE => @PLACE(-19, 0) => @ORIENT("R0");
//   &APGATE @WIRE {%p_apgate:p #MEQ1:2};
//   (-10, 46) @TEXT("Matched half-capacitor pair j=1") => @SET-STYLE $title_style
// }
ends mq_cdac_bit1

// Reference-rail output driver j=0
subckt mq_cdac_drv0 (HIB EN ENB BP VREFP VREFN VSS DVDD)
// DVDD prelogic: PCOND = NOR(ENB,HIB); NOFF = NAND(EN,HIB).
// Reference-powered final inverters restore GP and GN to VREFP/VREFN.
// Actual current overlap, settling and device stress require measurement.
MPA0 (AP ENB DVDD DVDD) pch_ulvt_mac w=2.4e-07 l=3e-08 nf=1
MPA1 (PCOND HIB AP DVDD) pch_ulvt_mac w=2.4e-07 l=3e-08 nf=1
MNA0 (PCOND ENB VREFN VSS) nch_ulvt_mac w=1.2e-07 l=3e-08 nf=1
MNA1 (PCOND HIB VREFN VSS) nch_ulvt_mac w=1.2e-07 l=3e-08 nf=1
MPB0 (NOFF EN DVDD DVDD) pch_ulvt_mac w=1.2e-07 l=3e-08 nf=1
MPB1 (NOFF HIB DVDD DVDD) pch_ulvt_mac w=1.2e-07 l=3e-08 nf=1
MNB0 (NOFF EN BN VSS) nch_ulvt_mac w=1.2e-07 l=3e-08 nf=1
MNB1 (BN HIB VREFN VSS) nch_ulvt_mac w=1.2e-07 l=3e-08 nf=1
MGPN (GP PCOND VREFN VSS) nch_mac w=2.4e-07 l=3e-08 nf=1
MGPP (GP PCOND VREFP VREFP) pch_mac w=3.6e-07 l=3e-08 nf=1
MGNN (GN NOFF VREFN VSS) nch_mac w=2.4e-07 l=3e-08 nf=1
MGNP (GN NOFF VREFP VREFP) pch_mac w=1.2e-07 l=3e-08 nf=1
MNOUT (BP GN VREFN VSS) nch_mac w=1.2e-07 l=3e-08 nf=1
MPOUT (BP GP VREFP VREFP) pch_mac w=2.4e-07 l=3e-08 nf=1
// @RNL {
//   /* pins connected by net name: the net-name label of rnl-std-fill on every unwired pin, placed below by its key netname */
//   $LABEL_TERMINAL_SET @TEXT("${net}", key="netname", size=0.6);
//   &VSS @ADD-TO $GROUND_NET_SET; &VREFN @ADD-TO $GROUND_NET_SET;
//   &VREFP @ADD-TO $SUPPLY_NET_SET;
//   &DVDD @ADD-TO $SUPPLY_NET_SET;
//   {#MPA0 #MPA1 #MNA0 #MNA1} @GROUP;
//   {#MPB0 #MPB1 #MNB0 #MNB1} @GROUP;
//   {#MGPN #MGPP} @GROUP;
//   {#MGNN #MGNP} @GROUP;
//   {#MNOUT #MPOUT} @GROUP;
//   #MPA0 @PLACE(12, 40);
//   #MPA0 @ORIENT("R0");
//   #MPA0:1 @TEXT("${net}", key="netname", size=0.6, halign="end", valign="middle", rotate=90, dx=0, dy=-0.4);
//   #MPA0:2 @TEXT("${net}", key="netname", size=0.6, halign="end", valign="middle", dx=-0.4, dy=0);
//   %v1 = $SUPPLY @ATTACH &DVDD => @PLACE(12, 45.2);
//   &DVDD @WIRE {#MPA0:3 (12, 42) %v1:p};
//   %v2 = $SUPPLY @ATTACH &DVDD => @PLACE(15, 43.2);
//   &DVDD @WIRE {#MPA0:4 (15, 40) %v2:p};
//   #MPA1 @PLACE(12, 26);
//   #MPA1 @ORIENT("R0");
//   #MPA1:1 @TEXT("${net}", key="netname", size=0.6, halign="end", valign="middle", rotate=90, dx=0, dy=-0.4);
//   #MPA1:2 @TEXT("${net}", key="netname", size=0.6, halign="end", valign="middle", dx=-0.4, dy=0);
//   #MPA1:3 @TEXT("${net}", key="netname", size=0.6, halign="start", valign="middle", rotate=90, dx=0, dy=0.4);
//   %v3 = $SUPPLY @ATTACH &DVDD => @PLACE(15, 29.2);
//   &DVDD @WIRE {#MPA1:4 (15, 26) %v3:p};
//   #MNA0 @PLACE(0, 2);
//   #MNA0 @ORIENT("R0");
//   #MNA0:1 @TEXT("${net}", key="netname", size=0.6, halign="start", valign="middle", rotate=90, dx=0, dy=0.4);
//   #MNA0:2 @TEXT("${net}", key="netname", size=0.6, halign="end", valign="middle", dx=-0.4, dy=0);
//   %g4 = $GROUND @ATTACH &VREFN => @PLACE(0, -3.2);
//   &VREFN @WIRE {#MNA0:3 (0, 0) %g4:p};
//   %g5 = $GROUND @ATTACH &VSS => @PLACE(3, -1.2);
//   &VSS @WIRE {#MNA0:4 (3, 2) %g5:p};
//   #MNA1 @PLACE(24, 2);
//   #MNA1 @ORIENT("R0");
//   #MNA1:1 @TEXT("${net}", key="netname", size=0.6, halign="start", valign="middle", rotate=90, dx=0, dy=0.4);
//   #MNA1:2 @TEXT("${net}", key="netname", size=0.6, halign="end", valign="middle", dx=-0.4, dy=0);
//   %g6 = $GROUND @ATTACH &VREFN => @PLACE(24, -3.2);
//   &VREFN @WIRE {#MNA1:3 (24, 0) %g6:p};
//   %g7 = $GROUND @ATTACH &VSS => @PLACE(27, -1.2);
//   &VSS @WIRE {#MNA1:4 (27, 2) %g7:p};
//   #MPB0 @PLACE(96, 30);
//   #MPB0 @ORIENT("R0");
//   #MPB0:1 @TEXT("${net}", key="netname", size=0.6, halign="end", valign="middle", rotate=90, dx=0, dy=-0.4);
//   #MPB0:2 @TEXT("${net}", key="netname", size=0.6, halign="end", valign="middle", dx=-0.4, dy=0);
//   %v8 = $SUPPLY @ATTACH &DVDD => @PLACE(96, 35.2);
//   &DVDD @WIRE {#MPB0:3 (96, 32) %v8:p};
//   %v9 = $SUPPLY @ATTACH &DVDD => @PLACE(99, 33.2);
//   &DVDD @WIRE {#MPB0:4 (99, 30) %v9:p};
//   #MPB1 @PLACE(120, 30);
//   #MPB1 @ORIENT("R0");
//   #MPB1:1 @TEXT("${net}", key="netname", size=0.6, halign="end", valign="middle", rotate=90, dx=0, dy=-0.4);
//   #MPB1:2 @TEXT("${net}", key="netname", size=0.6, halign="end", valign="middle", dx=-0.4, dy=0);
//   %v10 = $SUPPLY @ATTACH &DVDD => @PLACE(120, 35.2);
//   &DVDD @WIRE {#MPB1:3 (120, 32) %v10:p};
//   %v11 = $SUPPLY @ATTACH &DVDD => @PLACE(123, 33.2);
//   &DVDD @WIRE {#MPB1:4 (123, 30) %v11:p};
//   #MNB0 @PLACE(108, 12);
//   #MNB0 @ORIENT("R0");
//   #MNB0:1 @TEXT("${net}", key="netname", size=0.6, halign="start", valign="middle", rotate=90, dx=0, dy=0.4);
//   #MNB0:2 @TEXT("${net}", key="netname", size=0.6, halign="end", valign="middle", dx=-0.4, dy=0);
//   #MNB0:3 @TEXT("${net}", key="netname", size=0.6, halign="end", valign="middle", rotate=90, dx=0, dy=-0.4);
//   %g12 = $GROUND @ATTACH &VSS => @PLACE(111, 8.8);
//   &VSS @WIRE {#MNB0:4 (111, 12) %g12:p};
//   #MNB1 @PLACE(108, -2);
//   #MNB1 @ORIENT("R0");
//   #MNB1:1 @TEXT("${net}", key="netname", size=0.6, halign="start", valign="middle", rotate=90, dx=0, dy=0.4);
//   #MNB1:2 @TEXT("${net}", key="netname", size=0.6, halign="end", valign="middle", dx=-0.4, dy=0);
//   %g13 = $GROUND @ATTACH &VREFN => @PLACE(108, -7.2);
//   &VREFN @WIRE {#MNB1:3 (108, -4) %g13:p};
//   %g14 = $GROUND @ATTACH &VSS => @PLACE(111, -5.2);
//   &VSS @WIRE {#MNB1:4 (111, -2) %g14:p};
//   #MGPN @PLACE(64, 2);
//   #MGPN @ORIENT("R0");
//   #MGPN:1 @TEXT("${net}", key="netname", size=0.6, halign="start", valign="middle", rotate=90, dx=0, dy=0.4);
//   #MGPN:2 @TEXT("${net}", key="netname", size=0.6, halign="end", valign="middle", dx=-0.4, dy=0);
//   %g15 = $GROUND @ATTACH &VREFN => @PLACE(64, -3.2);
//   &VREFN @WIRE {#MGPN:3 (64, 0) %g15:p};
//   %g16 = $GROUND @ATTACH &VSS => @PLACE(67, -1.2);
//   &VSS @WIRE {#MGPN:4 (67, 2) %g16:p};
//   #MGPP @PLACE(64, 12);
//   #MGPP @ORIENT("R0");
//   #MGPP:1 @TEXT("${net}", key="netname", size=0.6, halign="end", valign="middle", rotate=90, dx=0, dy=-0.4);
//   #MGPP:2 @TEXT("${net}", key="netname", size=0.6, halign="end", valign="middle", dx=-0.4, dy=0);
//   %v17 = $SUPPLY @ATTACH &VREFP => @PLACE(64, 17.2);
//   &VREFP @WIRE {#MGPP:3 (64, 14) %v17:p};
//   %v18 = $SUPPLY @ATTACH &VREFP => @PLACE(67, 15.2);
//   &VREFP @WIRE {#MGPP:4 (67, 12) %v18:p};
//   #MGNN @PLACE(160, 2);
//   #MGNN @ORIENT("R0");
//   #MGNN:1 @TEXT("${net}", key="netname", size=0.6, halign="start", valign="middle", rotate=90, dx=0, dy=0.4);
//   #MGNN:2 @TEXT("${net}", key="netname", size=0.6, halign="end", valign="middle", dx=-0.4, dy=0);
//   %g19 = $GROUND @ATTACH &VREFN => @PLACE(160, -3.2);
//   &VREFN @WIRE {#MGNN:3 (160, 0) %g19:p};
//   %g20 = $GROUND @ATTACH &VSS => @PLACE(163, -1.2);
//   &VSS @WIRE {#MGNN:4 (163, 2) %g20:p};
//   #MGNP @PLACE(160, 12);
//   #MGNP @ORIENT("R0");
//   #MGNP:1 @TEXT("${net}", key="netname", size=0.6, halign="end", valign="middle", rotate=90, dx=0, dy=-0.4);
//   #MGNP:2 @TEXT("${net}", key="netname", size=0.6, halign="end", valign="middle", dx=-0.4, dy=0);
//   %v21 = $SUPPLY @ATTACH &VREFP => @PLACE(160, 17.2);
//   &VREFP @WIRE {#MGNP:3 (160, 14) %v21:p};
//   %v22 = $SUPPLY @ATTACH &VREFP => @PLACE(163, 15.2);
//   &VREFP @WIRE {#MGNP:4 (163, 12) %v22:p};
//   #MNOUT @PLACE(200, 0);
//   #MNOUT @ORIENT("R0");
//   #MNOUT:1 @TEXT("${net}", key="netname", size=0.6, halign="start", valign="middle", rotate=90, dx=0, dy=0.4);
//   #MNOUT:2 @TEXT("${net}", key="netname", size=0.6, halign="end", valign="middle", dx=-0.4, dy=0);
//   %g23 = $GROUND @ATTACH &VREFN => @PLACE(200, -5.2);
//   &VREFN @WIRE {#MNOUT:3 (200, -2) %g23:p};
//   %g24 = $GROUND @ATTACH &VSS => @PLACE(203, -3.2);
//   &VSS @WIRE {#MNOUT:4 (203, 0) %g24:p};
//   #MPOUT @PLACE(200, 22);
//   #MPOUT @ORIENT("R0");
//   #MPOUT:1 @TEXT("${net}", key="netname", size=0.6, halign="end", valign="middle", rotate=90, dx=0, dy=-0.4);
//   #MPOUT:2 @TEXT("${net}", key="netname", size=0.6, halign="end", valign="middle", dx=-0.4, dy=0);
//   %v25 = $SUPPLY @ATTACH &VREFP => @PLACE(200, 27.2);
//   &VREFP @WIRE {#MPOUT:3 (200, 24) %v25:p};
//   %v26 = $SUPPLY @ATTACH &VREFP => @PLACE(203, 25.2);
//   &VREFP @WIRE {#MPOUT:4 (203, 22) %v26:p};
//   &GP @WIRE {#MGPN:1 #MGPP:1};
//   &PCOND @WIRE {#MGPN:2 (59, 2) (59, 12) #MGPP:2};
//   &GN @WIRE {#MGNN:1 #MGNP:1};
//   &NOFF @WIRE {#MGNN:2 (155, 2) (155, 12) #MGNP:2};
//   &AP @WIRE {#MPA0:1 #MPA1:3};
//   %pc_bus = (12, 16);
//   $JUNCTION @ATTACH %pc_bus;
//   &PCOND @WIRE {#MNA0:1 (0, 16) %pc_bus (24, 16) #MNA1:1};
//   &PCOND @WIRE {#MPA1:1 %pc_bus};
//   %pc_gate = (59, 7);
//   $JUNCTION @ATTACH %pc_gate;
//   &PCOND @WIRE {%pc_bus (50, 16) (50, 7) %pc_gate};
//   &BN @WIRE {#MNB0:3 #MNB1:1};
//   %no_bus = (108, 22);
//   $JUNCTION @ATTACH %no_bus;
//   &NOFF @WIRE {#MPB0:1 (96, 22) %no_bus (120, 22) #MPB1:1};
//   &NOFF @WIRE {#MNB0:1 %no_bus};
//   %no_gate = (155, 7);
//   $JUNCTION @ATTACH %no_gate;
//   &NOFF @WIRE {%no_bus (146, 22) (146, 7) %no_gate};
//   &BP @WIRE {#MNOUT:1 #MPOUT:1};
//   &GP @WIRE {#MGPN:1 (74, 4) (74, 52) (190, 52) (190, 22) #MPOUT:2};
//   &GN @WIRE {#MGNN:1 (180, 4) (180, 0) #MNOUT:2};
//   %p_hib = $IO_PORT @ATTACH &HIB => @PLACE(5, 26) => @ORIENT("R0");
//   &HIB @WIRE {%p_hib:p #MPA1:2};
//   %p_en = $IO_PORT @ATTACH &EN => @PLACE(89, 30) => @ORIENT("R0");
//   &EN @WIRE {%p_en:p #MPB0:2};
//   %p_enb = $IO_PORT @ATTACH &ENB => @PLACE(5, 40) => @ORIENT("R0");
//   &ENB @WIRE {%p_enb:p #MPA0:2};
//   %p_bp = $IO_PORT @ATTACH &BP => @PLACE(200, 6) => @ORIENT("R270");
//   &BP @WIRE {%p_bp:p #MNOUT:1};
//   (-10, 62) @TEXT("Reference-rail output driver j=0") => @SET-STYLE $title_style
// }
ends mq_cdac_drv0

// Matched half-capacitor pair j=0
subckt mq_cdac_bit0 (VIN VG DH RL EN ENB TOP VREFP VREFN VSS PHI_S DVDD PHI_SB EQBUS APGATE)
// CP*: user-specified 5% bottom-plate estimate for every physical MOM unit, not extraction.
// Series tails retain one unit parasitic at MID and one at B.
// APGATE PMOS assist connects each bottom plate to VIN.
// MID-to-VIN transmission gates provide physical initialization during PHI_S.
// Additional ENB NMOS sharing retains a common EQBUS.
XHCTL (DH HHIB DVDD VREFN VSS) mq_cdac_ctl_h
XLCTL (RL LHIB DVDD VREFN VSS) mq_cdac_ctl_l
XDH (HHIB EN ENB BH VREFP VREFN VSS DVDD) mq_cdac_drv0
CHA (TOP MIDH) cfmom_2t w=5e-08 s=2.4e-07 nr=6 lr=1.69e-06 stm=2 spm=4 multi=1
CPHA (MIDH VSS) capacitor c=5.01145e-17
CHB (MIDH BH) cfmom_2t w=5e-08 s=2.4e-07 nr=6 lr=1.69e-06 stm=2 spm=4 multi=1
CPHB (BH VSS) capacitor c=5.01145e-17
MSH (BH VG VIN VSS) nch_ulvt_mac w=1.2e-07 l=3e-08 nf=1
XDL (LHIB EN ENB BL VREFP VREFN VSS DVDD) mq_cdac_drv0
CLA (TOP MIDL) cfmom_2t w=5e-08 s=2.4e-07 nr=6 lr=1.69e-06 stm=2 spm=4 multi=1
CPLA (MIDL VSS) capacitor c=5.01145e-17
CLB (MIDL BL) cfmom_2t w=5e-08 s=2.4e-07 nr=6 lr=1.69e-06 stm=2 spm=4 multi=1
CPLB (BL VSS) capacitor c=5.01145e-17
MSL (BL VG VIN VSS) nch_ulvt_mac w=1.2e-07 l=3e-08 nf=1
MEQ1 (BH APGATE VIN VREFP) pch_ulvt_mac w=1.2e-07 l=3e-08 nf=1
MEQ2 (BL APGATE VIN VREFP) pch_ulvt_mac w=1.2e-07 l=3e-08 nf=1
MMIDNH (MIDH PHI_S VIN VSS) nch_ulvt_mac w=1.2e-07 l=3e-08 nf=1
MMIDPH (MIDH PHI_SB VIN VREFP) pch_mac w=1.2e-07 l=3e-08 nf=1
MMIDNL (MIDL PHI_S VIN VSS) nch_ulvt_mac w=1.2e-07 l=3e-08 nf=1
MMIDPL (MIDL PHI_SB VIN VREFP) pch_mac w=1.2e-07 l=3e-08 nf=1
MSHAREH (BH ENB EQBUS VSS) nch_ulvt_mac w=1.2e-07 l=3e-08 nf=1
MSHAREL (BL ENB EQBUS VSS) nch_ulvt_mac w=1.2e-07 l=3e-08 nf=1
// @RNL {
//   /* pins connected by net name: the net-name label of rnl-std-fill on every unwired pin, placed below by its key netname */
//   $LABEL_TERMINAL_SET @TEXT("${net}", key="netname", size=0.6);
//   &VSS @ADD-TO $GROUND_NET_SET; &VREFN @ADD-TO $GROUND_NET_SET;
//   &VREFP @ADD-TO $SUPPLY_NET_SET;
//   &DVDD @ADD-TO $SUPPLY_NET_SET;
//   {#CHA #CHB #CLA #CLB} @AS $MATCHED;
//   {#CHA #CHB #CLA #CLB} @GROUP;
//   {#MSH #MSL} @AS $MATCHED;
//   {#MEQ1 #MEQ2} @AS $MATCHED;
//   {#MMIDNH #MMIDNL} @AS $MATCHED;
//   {#MMIDPH #MMIDPL} @AS $MATCHED;
//   {#MSHAREH #MSHAREL} @AS $MATCHED;
//   {#XDH #XDL} @AS $MATCHED;
//   #XHCTL @PLACE(-70, 24);
//   #XHCTL @ORIENT("R0");
//   #XHCTL:IN @TEXT("${net}", key="netname", size=0.6, halign="end", valign="middle", dx=-0.4, dy=0);
//   #XHCTL:HIB @TEXT("${net}", key="netname", size=0.6, halign="start", valign="middle", dx=0.4, dy=0);
//   %v1 = $SUPPLY @ATTACH &DVDD => @PLACE(-70, 31.2);
//   &DVDD @WIRE {#XHCTL:DVDD (-70, 28) %v1:p};
//   %g2 = $GROUND @ATTACH &VREFN => @PLACE(-72, 16.8);
//   &VREFN @WIRE {#XHCTL:VREFN (-72, 20) %g2:p};
//   %g3 = $GROUND @ATTACH &VSS => @PLACE(-68, 16.8);
//   &VSS @WIRE {#XHCTL:VSS (-68, 20) %g3:p};
//   #XLCTL @PLACE(-70, -26);
//   #XLCTL @ORIENT("R0");
//   #XLCTL:IN @TEXT("${net}", key="netname", size=0.6, halign="end", valign="middle", dx=-0.4, dy=0);
//   #XLCTL:HIB @TEXT("${net}", key="netname", size=0.6, halign="start", valign="middle", dx=0.4, dy=0);
//   %v4 = $SUPPLY @ATTACH &DVDD => @PLACE(-70, -18.8);
//   &DVDD @WIRE {#XLCTL:DVDD (-70, -22) %v4:p};
//   %g5 = $GROUND @ATTACH &VREFN => @PLACE(-72, -33.2);
//   &VREFN @WIRE {#XLCTL:VREFN (-72, -30) %g5:p};
//   %g6 = $GROUND @ATTACH &VSS => @PLACE(-68, -33.2);
//   &VSS @WIRE {#XLCTL:VSS (-68, -30) %g6:p};
//   #XDH @PLACE(-34, 24);
//   #XDH @ORIENT("R0");
//   #XDH:HIB @TEXT("${net}", key="netname", size=0.6, halign="end", valign="middle", dx=-0.4, dy=0);
//   #XDH:EN @TEXT("${net}", key="netname", size=0.6, halign="end", valign="middle", dx=-0.4, dy=0);
//   #XDH:ENB @TEXT("${net}", key="netname", size=0.6, halign="end", valign="middle", dx=-0.4, dy=0);
//   #XDH:BP @TEXT("${net}", key="netname", size=0.6, halign="start", valign="middle", dx=0.4, dy=0);
//   %v7 = $SUPPLY @ATTACH &VREFP => @PLACE(-36, 32.2);
//   &VREFP @WIRE {#XDH:VREFP (-36, 29) %v7:p};
//   %g8 = $GROUND @ATTACH &VREFN => @PLACE(-36, 15.8);
//   &VREFN @WIRE {#XDH:VREFN (-36, 19) %g8:p};
//   %g9 = $GROUND @ATTACH &VSS => @PLACE(-32, 15.8);
//   &VSS @WIRE {#XDH:VSS (-32, 19) %g9:p};
//   %v10 = $SUPPLY @ATTACH &DVDD => @PLACE(-32, 32.2);
//   &DVDD @WIRE {#XDH:DVDD (-32, 29) %v10:p};
//   #CHA @PLACE(30, 38) => @ORIENT("R270");
//   #CHA:1 @TEXT("${net}", key="netname", size=0.6, halign="start", valign="middle", dx=0.4, dy=0);
//   #CHA:2 @TEXT("${net}", key="netname", size=0.6, halign="end", valign="middle", dx=-0.4, dy=0);
//   #CPHA @PLACE(76, 20);
//   #CPHA @ORIENT("R0");
//   #CPHA:1 @TEXT("${net}", key="netname", size=0.6, halign="start", valign="middle", rotate=90, dx=0, dy=0.4);
//   %g11 = $GROUND @ATTACH &VSS => @PLACE(76, 14.8);
//   &VSS @WIRE {#CPHA:2 (76, 18) %g11:p};
//   #CHB @PLACE(10, 38) => @ORIENT("R270");
//   #CHB:1 @TEXT("${net}", key="netname", size=0.6, halign="start", valign="middle", dx=0.4, dy=0);
//   #CHB:2 @TEXT("${net}", key="netname", size=0.6, halign="end", valign="middle", dx=-0.4, dy=0);
//   #CPHB @PLACE(92, 20);
//   #CPHB @ORIENT("R0");
//   #CPHB:1 @TEXT("${net}", key="netname", size=0.6, halign="start", valign="middle", rotate=90, dx=0, dy=0.4);
//   %g12 = $GROUND @ATTACH &VSS => @PLACE(92, 14.8);
//   &VSS @WIRE {#CPHB:2 (92, 18) %g12:p};
//   #MSH @PLACE(2, 8);
//   #MSH @ORIENT("R0");
//   #MSH:1 @TEXT("${net}", key="netname", size=0.6, halign="start", valign="middle", rotate=90, dx=0, dy=0.4);
//   #MSH:2 @TEXT("${net}", key="netname", size=0.6, halign="end", valign="middle", dx=-0.4, dy=0);
//   #MSH:3 @TEXT("${net}", key="netname", size=0.6, halign="end", valign="middle", rotate=90, dx=0, dy=-0.4);
//   %g13 = $GROUND @ATTACH &VSS => @PLACE(5, 4.8);
//   &VSS @WIRE {#MSH:4 (5, 8) %g13:p};
//   #XDL @PLACE(-34, -26);
//   #XDL @ORIENT("R0");
//   #XDL:HIB @TEXT("${net}", key="netname", size=0.6, halign="end", valign="middle", dx=-0.4, dy=0);
//   #XDL:EN @TEXT("${net}", key="netname", size=0.6, halign="end", valign="middle", dx=-0.4, dy=0);
//   #XDL:ENB @TEXT("${net}", key="netname", size=0.6, halign="end", valign="middle", dx=-0.4, dy=0);
//   #XDL:BP @TEXT("${net}", key="netname", size=0.6, halign="start", valign="middle", dx=0.4, dy=0);
//   %v14 = $SUPPLY @ATTACH &VREFP => @PLACE(-36, -17.8);
//   &VREFP @WIRE {#XDL:VREFP (-36, -21) %v14:p};
//   %g15 = $GROUND @ATTACH &VREFN => @PLACE(-36, -34.2);
//   &VREFN @WIRE {#XDL:VREFN (-36, -31) %g15:p};
//   %g16 = $GROUND @ATTACH &VSS => @PLACE(-32, -34.2);
//   &VSS @WIRE {#XDL:VSS (-32, -31) %g16:p};
//   %v17 = $SUPPLY @ATTACH &DVDD => @PLACE(-32, -17.8);
//   &DVDD @WIRE {#XDL:DVDD (-32, -21) %v17:p};
//   #CLA @PLACE(30, -12) => @ORIENT("R270");
//   #CLA:1 @TEXT("${net}", key="netname", size=0.6, halign="start", valign="middle", dx=0.4, dy=0);
//   #CLA:2 @TEXT("${net}", key="netname", size=0.6, halign="end", valign="middle", dx=-0.4, dy=0);
//   #CPLA @PLACE(76, -30);
//   #CPLA @ORIENT("R0");
//   #CPLA:1 @TEXT("${net}", key="netname", size=0.6, halign="start", valign="middle", rotate=90, dx=0, dy=0.4);
//   %g18 = $GROUND @ATTACH &VSS => @PLACE(76, -35.2);
//   &VSS @WIRE {#CPLA:2 (76, -32) %g18:p};
//   #CLB @PLACE(10, -12) => @ORIENT("R270");
//   #CLB:1 @TEXT("${net}", key="netname", size=0.6, halign="start", valign="middle", dx=0.4, dy=0);
//   #CLB:2 @TEXT("${net}", key="netname", size=0.6, halign="end", valign="middle", dx=-0.4, dy=0);
//   #CPLB @PLACE(92, -30);
//   #CPLB @ORIENT("R0");
//   #CPLB:1 @TEXT("${net}", key="netname", size=0.6, halign="start", valign="middle", rotate=90, dx=0, dy=0.4);
//   %g19 = $GROUND @ATTACH &VSS => @PLACE(92, -35.2);
//   &VSS @WIRE {#CPLB:2 (92, -32) %g19:p};
//   #MSL @PLACE(2, -42);
//   #MSL @ORIENT("R0");
//   #MSL:1 @TEXT("${net}", key="netname", size=0.6, halign="start", valign="middle", rotate=90, dx=0, dy=0.4);
//   #MSL:2 @TEXT("${net}", key="netname", size=0.6, halign="end", valign="middle", dx=-0.4, dy=0);
//   #MSL:3 @TEXT("${net}", key="netname", size=0.6, halign="end", valign="middle", rotate=90, dx=0, dy=-0.4);
//   %g20 = $GROUND @ATTACH &VSS => @PLACE(5, -45.2);
//   &VSS @WIRE {#MSL:4 (5, -42) %g20:p};
//   #MEQ1 @PLACE(-12, 0);
//   #MEQ1 @ORIENT("R0");
//   #MEQ1:1 @TEXT("${net}", key="netname", size=0.6, halign="end", valign="middle", rotate=90, dx=0, dy=-0.4);
//   #MEQ1:2 @TEXT("${net}", key="netname", size=0.6, halign="end", valign="middle", dx=-0.4, dy=0);
//   #MEQ1:3 @TEXT("${net}", key="netname", size=0.6, halign="start", valign="middle", rotate=90, dx=0, dy=0.4);
//   %v21 = $SUPPLY @ATTACH &VREFP => @PLACE(-9, 3.2);
//   &VREFP @WIRE {#MEQ1:4 (-9, 0) %v21:p};
//   #MEQ2 @PLACE(-12, -50);
//   #MEQ2 @ORIENT("R0");
//   #MEQ2:1 @TEXT("${net}", key="netname", size=0.6, halign="end", valign="middle", rotate=90, dx=0, dy=-0.4);
//   #MEQ2:2 @TEXT("${net}", key="netname", size=0.6, halign="end", valign="middle", dx=-0.4, dy=0);
//   #MEQ2:3 @TEXT("${net}", key="netname", size=0.6, halign="start", valign="middle", rotate=90, dx=0, dy=0.4);
//   %v22 = $SUPPLY @ATTACH &VREFP => @PLACE(-9, -46.8);
//   &VREFP @WIRE {#MEQ2:4 (-9, -50) %v22:p};
//   #MMIDNH @PLACE(115, 14);
//   #MMIDNH @ORIENT("R0");
//   #MMIDNH:1 @TEXT("${net}", key="netname", size=0.6, halign="start", valign="middle", rotate=90, dx=0, dy=0.4);
//   #MMIDNH:2 @TEXT("${net}", key="netname", size=0.6, halign="end", valign="middle", dx=-0.4, dy=0);
//   #MMIDNH:3 @TEXT("${net}", key="netname", size=0.6, halign="end", valign="middle", rotate=90, dx=0, dy=-0.4);
//   %g23 = $GROUND @ATTACH &VSS => @PLACE(118, 10.8);
//   &VSS @WIRE {#MMIDNH:4 (118, 14) %g23:p};
//   #MMIDPH @PLACE(115, 32);
//   #MMIDPH @ORIENT("R0");
//   #MMIDPH:1 @TEXT("${net}", key="netname", size=0.6, halign="end", valign="middle", rotate=90, dx=0, dy=-0.4);
//   #MMIDPH:2 @TEXT("${net}", key="netname", size=0.6, halign="end", valign="middle", dx=-0.4, dy=0);
//   #MMIDPH:3 @TEXT("${net}", key="netname", size=0.6, halign="start", valign="middle", rotate=90, dx=0, dy=0.4);
//   %v24 = $SUPPLY @ATTACH &VREFP => @PLACE(118, 35.2);
//   &VREFP @WIRE {#MMIDPH:4 (118, 32) %v24:p};
//   #MMIDNL @PLACE(115, -36);
//   #MMIDNL @ORIENT("R0");
//   #MMIDNL:1 @TEXT("${net}", key="netname", size=0.6, halign="start", valign="middle", rotate=90, dx=0, dy=0.4);
//   #MMIDNL:2 @TEXT("${net}", key="netname", size=0.6, halign="end", valign="middle", dx=-0.4, dy=0);
//   #MMIDNL:3 @TEXT("${net}", key="netname", size=0.6, halign="end", valign="middle", rotate=90, dx=0, dy=-0.4);
//   %g25 = $GROUND @ATTACH &VSS => @PLACE(118, -39.2);
//   &VSS @WIRE {#MMIDNL:4 (118, -36) %g25:p};
//   #MMIDPL @PLACE(115, -18);
//   #MMIDPL @ORIENT("R0");
//   #MMIDPL:1 @TEXT("${net}", key="netname", size=0.6, halign="end", valign="middle", rotate=90, dx=0, dy=-0.4);
//   #MMIDPL:2 @TEXT("${net}", key="netname", size=0.6, halign="end", valign="middle", dx=-0.4, dy=0);
//   #MMIDPL:3 @TEXT("${net}", key="netname", size=0.6, halign="start", valign="middle", rotate=90, dx=0, dy=0.4);
//   %v26 = $SUPPLY @ATTACH &VREFP => @PLACE(118, -14.8);
//   &VREFP @WIRE {#MMIDPL:4 (118, -18) %v26:p};
//   #MSHAREH @PLACE(56, -2);
//   #MSHAREH @ORIENT("R0");
//   #MSHAREH:1 @TEXT("${net}", key="netname", size=0.6, halign="start", valign="middle", rotate=90, dx=0, dy=0.4);
//   #MSHAREH:2 @TEXT("${net}", key="netname", size=0.6, halign="end", valign="middle", dx=-0.4, dy=0);
//   #MSHAREH:3 @TEXT("${net}", key="netname", size=0.6, halign="end", valign="middle", rotate=90, dx=0, dy=-0.4);
//   %g27 = $GROUND @ATTACH &VSS => @PLACE(59, -5.2);
//   &VSS @WIRE {#MSHAREH:4 (59, -2) %g27:p};
//   #MSHAREL @PLACE(56, -52);
//   #MSHAREL @ORIENT("R0");
//   #MSHAREL:1 @TEXT("${net}", key="netname", size=0.6, halign="start", valign="middle", rotate=90, dx=0, dy=0.4);
//   #MSHAREL:2 @TEXT("${net}", key="netname", size=0.6, halign="end", valign="middle", dx=-0.4, dy=0);
//   #MSHAREL:3 @TEXT("${net}", key="netname", size=0.6, halign="end", valign="middle", rotate=90, dx=0, dy=-0.4);
//   %g28 = $GROUND @ATTACH &VSS => @PLACE(59, -55.2);
//   &VSS @WIRE {#MSHAREL:4 (59, -52) %g28:p};
//   &HHIB @WIRE {#XHCTL:HIB (-52, 24) (-52, 26) #XDH:HIB};
//   %b_H = (-12, 24);
//   $JUNCTION @ATTACH %b_H;
//   &BH @WIRE {#XDH:BP %b_H};
//   &MIDH @WIRE {#CHB:1 #CHA:2};
//   &BH @WIRE {%b_H (-12, 38) #CHB:2};
//   &BH @WIRE {%b_H (-12, 10) #MSH:1};
//   &BH @WIRE {%b_H #MEQ1:1};
//   &LHIB @WIRE {#XLCTL:HIB (-52, -26) (-52, -24) #XDL:HIB};
//   %b_L = (-12, -26);
//   $JUNCTION @ATTACH %b_L;
//   &BL @WIRE {#XDL:BP %b_L};
//   &MIDL @WIRE {#CLB:1 #CLA:2};
//   &BL @WIRE {%b_L (-12, -12) #CLB:2};
//   &BL @WIRE {%b_L (-12, -40) #MSL:1};
//   &BL @WIRE {%b_L #MEQ2:1};
//   &VIN @WIRE {#MSH:3 (6, 6) (6, -44) #MSL:3};
//   &VG @WIRE {#MSH:2 (-5, 8) (-5, -42) #MSL:2};
//   %top_H = (44, 24);
//   $JUNCTION @ATTACH %top_H;
//   %top_L = (44, -26);
//   $JUNCTION @ATTACH %top_L;
//   &TOP @WIRE {#CHA:1 (44, 38) %top_H};
//   &TOP @WIRE {#CLA:1 (44, -12) %top_L};
//   &TOP @WIRE {%top_H %top_L};
//   &MIDH @WIRE {#MMIDNH:1 #MMIDPH:1};
//   &MIDL @WIRE {#MMIDNL:1 #MMIDPL:1};
//   %p_vin = $IO_PORT @ATTACH &VIN => @PLACE(2, 2) => @ORIENT("R90");
//   &VIN @WIRE {%p_vin:p #MSH:3};
//   %p_vg = $IO_PORT @ATTACH &VG => @PLACE(-5, 8) => @ORIENT("R0");
//   &VG @WIRE {%p_vg:p #MSH:2};
//   %p_dh = $IO_PORT @ATTACH &DH => @PLACE(-81, 24) => @ORIENT("R0");
//   &DH @WIRE {%p_dh:p #XHCTL:IN};
//   %p_rl = $IO_PORT @ATTACH &RL => @PLACE(-81, -26) => @ORIENT("R0");
//   &RL @WIRE {%p_rl:p #XLCTL:IN};
//   %p_en = $IO_PORT @ATTACH &EN => @PLACE(-45, 24) => @ORIENT("R0");
//   &EN @WIRE {%p_en:p #XDH:EN};
//   %p_enb = $IO_PORT @ATTACH &ENB => @PLACE(-45, 22) => @ORIENT("R0");
//   &ENB @WIRE {%p_enb:p #XDH:ENB};
//   %p_top = $IO_PORT @ATTACH &TOP => @PLACE(36, 38) => @ORIENT("MY");
//   &TOP @WIRE {%p_top:p #CHA:1};
//   %p_phi_s = $IO_PORT @ATTACH &PHI_S => @PLACE(108, 14) => @ORIENT("R0");
//   &PHI_S @WIRE {%p_phi_s:p #MMIDNH:2};
//   %p_phi_sb = $IO_PORT @ATTACH &PHI_SB => @PLACE(108, 32) => @ORIENT("R0");
//   &PHI_SB @WIRE {%p_phi_sb:p #MMIDPH:2};
//   %p_eqbus = $IO_PORT @ATTACH &EQBUS => @PLACE(56, -8) => @ORIENT("R90");
//   &EQBUS @WIRE {%p_eqbus:p #MSHAREH:3};
//   %p_apgate = $IO_PORT @ATTACH &APGATE => @PLACE(-19, 0) => @ORIENT("R0");
//   &APGATE @WIRE {%p_apgate:p #MEQ1:2};
//   (-10, 60) @TEXT("Matched half-capacitor pair j=0") => @SET-STYLE $title_style
// }
ends mq_cdac_bit0

// Physical sampling-entry assistance pulse
subckt mq_cdac_assist_pulse (PHI_S PHI_SB AGATE DVDD VREFN VSS)
// MOS gate loads delay a PHI_S inverter; two inverters restore the delayed control.
// The pass TG first passes PHI_SB to AGATE, then a PMOS pulls AGATE to DVDD.
// The pulse duration and overlap require PVT, startup and full-circuit verification.
M0N (D0 PHI_S VREFN VSS) nch_ulvt_mac w=4e-07 l=3e-08 nf=1
M0P (D0 PHI_S DVDD DVDD) pch_mac w=8e-07 l=3e-08 nf=1
MLOAD0 (VREFN D0 VREFN VSS) nch_ulvt_mac w=2.4e-05 l=3e-08 nf=12
MLOAD1 (VREFN D0 VREFN VSS) nch_ulvt_mac w=2.4e-05 l=3e-08 nf=12
MLOAD2 (VREFN D0 VREFN VSS) nch_ulvt_mac w=2.4e-05 l=3e-08 nf=12
MLOAD3 (VREFN D0 VREFN VSS) nch_ulvt_mac w=2.4e-05 l=3e-08 nf=12
M1N (D1 D0 VREFN VSS) nch_ulvt_mac w=2e-06 l=3e-08 nf=1
M1P (D1 D0 DVDD DVDD) pch_ulvt_mac w=4e-06 l=3e-08 nf=2
M2N (D2 D1 VREFN VSS) nch_ulvt_mac w=4e-06 l=3e-08 nf=2
M2P (D2 D1 DVDD DVDD) pch_mac w=8e-06 l=3e-08 nf=4
MNPASS (AGATE D2 PHI_SB VSS) nch_ulvt_mac w=4e-06 l=3e-08 nf=2
MPPASS (AGATE D1 PHI_SB DVDD) pch_mac w=8e-06 l=3e-08 nf=4
MPUP (AGATE D2 DVDD DVDD) pch_mac w=8e-06 l=3e-08 nf=4
// @RNL {
//   /* pins connected by net name: the net-name label of rnl-std-fill on every unwired pin, placed below by its key netname */
//   $LABEL_TERMINAL_SET @TEXT("${net}", key="netname", size=0.6);
//   &VSS @ADD-TO $GROUND_NET_SET; &VREFN @ADD-TO $GROUND_NET_SET;
//   &DVDD @ADD-TO $SUPPLY_NET_SET;
//   {#M0N #M0P} @GROUP;
//   {#M1N #M1P} @GROUP;
//   {#M2N #M2P} @GROUP;
//   {#MLOAD0 #MLOAD1 #MLOAD2 #MLOAD3} @AS $MATCHED;
//   {#MLOAD0 #MLOAD1 #MLOAD2 #MLOAD3} @GROUP;
//   {#MNPASS #MPPASS #MPUP} @GROUP;
//   #M0N @PLACE(0, 0);
//   #M0N @ORIENT("R0");
//   #M0N:1 @TEXT("${net}", key="netname", size=0.6, halign="start", valign="middle", rotate=90, dx=0, dy=0.4);
//   #M0N:2 @TEXT("${net}", key="netname", size=0.6, halign="end", valign="middle", dx=-0.4, dy=0);
//   %g1 = $GROUND @ATTACH &VREFN => @PLACE(0, -5.2);
//   &VREFN @WIRE {#M0N:3 (0, -2) %g1:p};
//   %g2 = $GROUND @ATTACH &VSS => @PLACE(3, -3.2);
//   &VSS @WIRE {#M0N:4 (3, 0) %g2:p};
//   #M0P @PLACE(0, 14);
//   #M0P @ORIENT("R0");
//   #M0P:1 @TEXT("${net}", key="netname", size=0.6, halign="end", valign="middle", rotate=90, dx=0, dy=-0.4);
//   #M0P:2 @TEXT("${net}", key="netname", size=0.6, halign="end", valign="middle", dx=-0.4, dy=0);
//   %v3 = $SUPPLY @ATTACH &DVDD => @PLACE(0, 19.2);
//   &DVDD @WIRE {#M0P:3 (0, 16) %v3:p};
//   %v4 = $SUPPLY @ATTACH &DVDD => @PLACE(3, 17.2);
//   &DVDD @WIRE {#M0P:4 (3, 14) %v4:p};
//   #MLOAD0 @PLACE(20, -22);
//   #MLOAD0 @ORIENT("R0");
//   %g5 = $GROUND @ATTACH &VREFN => @PLACE(20, -23.2);
//   &VREFN @WIRE {#MLOAD0:1 (20, -20) %g5:p};
//   #MLOAD0:2 @TEXT("${net}", key="netname", size=0.6, halign="end", valign="middle", dx=-0.4, dy=0);
//   %g6 = $GROUND @ATTACH &VREFN => @PLACE(20, -27.2);
//   &VREFN @WIRE {#MLOAD0:3 (20, -24) %g6:p};
//   %g7 = $GROUND @ATTACH &VSS => @PLACE(23, -25.2);
//   &VSS @WIRE {#MLOAD0:4 (23, -22) %g7:p};
//   #MLOAD1 @PLACE(34, -22);
//   #MLOAD1 @ORIENT("R0");
//   %g8 = $GROUND @ATTACH &VREFN => @PLACE(34, -23.2);
//   &VREFN @WIRE {#MLOAD1:1 (34, -20) %g8:p};
//   #MLOAD1:2 @TEXT("${net}", key="netname", size=0.6, halign="end", valign="middle", dx=-0.4, dy=0);
//   %g9 = $GROUND @ATTACH &VREFN => @PLACE(34, -27.2);
//   &VREFN @WIRE {#MLOAD1:3 (34, -24) %g9:p};
//   %g10 = $GROUND @ATTACH &VSS => @PLACE(37, -25.2);
//   &VSS @WIRE {#MLOAD1:4 (37, -22) %g10:p};
//   #MLOAD2 @PLACE(48, -22);
//   #MLOAD2 @ORIENT("R0");
//   %g11 = $GROUND @ATTACH &VREFN => @PLACE(48, -23.2);
//   &VREFN @WIRE {#MLOAD2:1 (48, -20) %g11:p};
//   #MLOAD2:2 @TEXT("${net}", key="netname", size=0.6, halign="end", valign="middle", dx=-0.4, dy=0);
//   %g12 = $GROUND @ATTACH &VREFN => @PLACE(48, -27.2);
//   &VREFN @WIRE {#MLOAD2:3 (48, -24) %g12:p};
//   %g13 = $GROUND @ATTACH &VSS => @PLACE(51, -25.2);
//   &VSS @WIRE {#MLOAD2:4 (51, -22) %g13:p};
//   #MLOAD3 @PLACE(62, -22);
//   #MLOAD3 @ORIENT("R0");
//   %g14 = $GROUND @ATTACH &VREFN => @PLACE(62, -23.2);
//   &VREFN @WIRE {#MLOAD3:1 (62, -20) %g14:p};
//   #MLOAD3:2 @TEXT("${net}", key="netname", size=0.6, halign="end", valign="middle", dx=-0.4, dy=0);
//   %g15 = $GROUND @ATTACH &VREFN => @PLACE(62, -27.2);
//   &VREFN @WIRE {#MLOAD3:3 (62, -24) %g15:p};
//   %g16 = $GROUND @ATTACH &VSS => @PLACE(65, -25.2);
//   &VSS @WIRE {#MLOAD3:4 (65, -22) %g16:p};
//   #M1N @PLACE(88, 0);
//   #M1N @ORIENT("R0");
//   #M1N:1 @TEXT("${net}", key="netname", size=0.6, halign="start", valign="middle", rotate=90, dx=0, dy=0.4);
//   #M1N:2 @TEXT("${net}", key="netname", size=0.6, halign="end", valign="middle", dx=-0.4, dy=0);
//   %g17 = $GROUND @ATTACH &VREFN => @PLACE(88, -5.2);
//   &VREFN @WIRE {#M1N:3 (88, -2) %g17:p};
//   %g18 = $GROUND @ATTACH &VSS => @PLACE(91, -3.2);
//   &VSS @WIRE {#M1N:4 (91, 0) %g18:p};
//   #M1P @PLACE(88, 14);
//   #M1P @ORIENT("R0");
//   #M1P:1 @TEXT("${net}", key="netname", size=0.6, halign="end", valign="middle", rotate=90, dx=0, dy=-0.4);
//   #M1P:2 @TEXT("${net}", key="netname", size=0.6, halign="end", valign="middle", dx=-0.4, dy=0);
//   %v19 = $SUPPLY @ATTACH &DVDD => @PLACE(88, 19.2);
//   &DVDD @WIRE {#M1P:3 (88, 16) %v19:p};
//   %v20 = $SUPPLY @ATTACH &DVDD => @PLACE(91, 17.2);
//   &DVDD @WIRE {#M1P:4 (91, 14) %v20:p};
//   #M2N @PLACE(118, 0);
//   #M2N @ORIENT("R0");
//   #M2N:1 @TEXT("${net}", key="netname", size=0.6, halign="start", valign="middle", rotate=90, dx=0, dy=0.4);
//   #M2N:2 @TEXT("${net}", key="netname", size=0.6, halign="end", valign="middle", dx=-0.4, dy=0);
//   %g21 = $GROUND @ATTACH &VREFN => @PLACE(118, -5.2);
//   &VREFN @WIRE {#M2N:3 (118, -2) %g21:p};
//   %g22 = $GROUND @ATTACH &VSS => @PLACE(121, -3.2);
//   &VSS @WIRE {#M2N:4 (121, 0) %g22:p};
//   #M2P @PLACE(118, 14);
//   #M2P @ORIENT("R0");
//   #M2P:1 @TEXT("${net}", key="netname", size=0.6, halign="end", valign="middle", rotate=90, dx=0, dy=-0.4);
//   #M2P:2 @TEXT("${net}", key="netname", size=0.6, halign="end", valign="middle", dx=-0.4, dy=0);
//   %v23 = $SUPPLY @ATTACH &DVDD => @PLACE(118, 19.2);
//   &DVDD @WIRE {#M2P:3 (118, 16) %v23:p};
//   %v24 = $SUPPLY @ATTACH &DVDD => @PLACE(121, 17.2);
//   &DVDD @WIRE {#M2P:4 (121, 14) %v24:p};
//   #MNPASS @PLACE(150, 0);
//   #MNPASS @ORIENT("R0");
//   #MNPASS:1 @TEXT("${net}", key="netname", size=0.6, halign="start", valign="middle", rotate=90, dx=0, dy=0.4);
//   #MNPASS:2 @TEXT("${net}", key="netname", size=0.6, halign="end", valign="middle", dx=-0.4, dy=0);
//   #MNPASS:3 @TEXT("${net}", key="netname", size=0.6, halign="end", valign="middle", rotate=90, dx=0, dy=-0.4);
//   %g25 = $GROUND @ATTACH &VSS => @PLACE(153, -3.2);
//   &VSS @WIRE {#MNPASS:4 (153, 0) %g25:p};
//   #MPPASS @PLACE(150, 14);
//   #MPPASS @ORIENT("R0");
//   #MPPASS:1 @TEXT("${net}", key="netname", size=0.6, halign="end", valign="middle", rotate=90, dx=0, dy=-0.4);
//   #MPPASS:2 @TEXT("${net}", key="netname", size=0.6, halign="end", valign="middle", dx=-0.4, dy=0);
//   #MPPASS:3 @TEXT("${net}", key="netname", size=0.6, halign="start", valign="middle", rotate=90, dx=0, dy=0.4);
//   %v26 = $SUPPLY @ATTACH &DVDD => @PLACE(153, 17.2);
//   &DVDD @WIRE {#MPPASS:4 (153, 14) %v26:p};
//   #MPUP @PLACE(180, 14);
//   #MPUP @ORIENT("R0");
//   #MPUP:1 @TEXT("${net}", key="netname", size=0.6, halign="end", valign="middle", rotate=90, dx=0, dy=-0.4);
//   #MPUP:2 @TEXT("${net}", key="netname", size=0.6, halign="end", valign="middle", dx=-0.4, dy=0);
//   %v27 = $SUPPLY @ATTACH &DVDD => @PLACE(180, 19.2);
//   &DVDD @WIRE {#MPUP:3 (180, 16) %v27:p};
//   %v28 = $SUPPLY @ATTACH &DVDD => @PLACE(183, 17.2);
//   &DVDD @WIRE {#MPUP:4 (183, 14) %v28:p};
//   &D0 @WIRE {#M0N:1 #M0P:1};
//   &PHI_S @WIRE {#M0N:2 (-5, 0) (-5, 10) #M0P:2};
//   &D1 @WIRE {#M1N:1 #M1P:1};
//   &D0 @WIRE {#M1N:2 (83, 0) (83, 10) #M1P:2};
//   &D2 @WIRE {#M2N:1 #M2P:1};
//   &D1 @WIRE {#M2N:2 (113, 0) (113, 10) #M2P:2};
//   %p_phi_s = $IO_PORT @ATTACH &PHI_S => @PLACE(-7, 0) => @ORIENT("R0");
//   &PHI_S @WIRE {%p_phi_s:p #M0N:2};
//   %p_phi_sb = $IO_PORT @ATTACH &PHI_SB => @PLACE(150, -6) => @ORIENT("R90");
//   &PHI_SB @WIRE {%p_phi_sb:p #MNPASS:3};
//   %p_agate = $IO_PORT @ATTACH &AGATE => @PLACE(150, 6) => @ORIENT("R270");
//   &AGATE @WIRE {%p_agate:p #MNPASS:1};
//   (-10, 36) @TEXT("Physical sampling-entry assistance pulse") => @SET-STYLE $title_style
// }
ends mq_cdac_assist_pulse

// CDAC: split-supply drivers and physical sampling switches
subckt adc_cdac (VIN VG TOP VCM VREFP VREFN PHI_S PHI_SB CONV DH12 DH11 DH10 DH9 DH8 DH7 DH6 DH5 DH4 DH3 DH2 DH1 DH0 RL12 RL11 RL10 RL9 RL8 RL7 RL6 RL5 RL4 RL3 RL2 RL1 RL0 DVDD VSS)
// ENB controls NMOS sharing; APGATE controls PMOS VIN assistance.
// Non-sampled j9 and j6 remain reference-driven during sampling.
// The top-plate transmission gate is driven directly by PHI_S/PHI_SB.
// Experimental dummy NMOS: D/S tied to TOP, gate PHI_SB; added hold capacitance and clock load require verification.
XEN (CONV EN ENB DVDD VREFN VSS) mq_cdac_enable
XAPULSE (PHI_S PHI_SB APGATE DVDD VREFN VSS) mq_cdac_assist_pulse
MTN (TOP PHI_S VCM VSS) nch_ulvt_mac w=1.2e-05 l=3e-08 nf=6
MTP (TOP PHI_SB VCM DVDD) pch_ulvt_mac w=4e-06 l=3e-08 nf=2
MTD (TOP PHI_SB TOP VSS) nch_ulvt_mac w=4e-06 l=3e-08 nf=2
XB12 (VIN VG DH12 RL12 EN ENB TOP VREFP VREFN VSS DVDD EQBUS APGATE) mq_cdac_bit12
XB11 (VIN VG DH11 RL11 EN ENB TOP VREFP VREFN VSS DVDD EQBUS APGATE) mq_cdac_bit11
XB10 (VIN VG DH10 RL10 EN ENB TOP VREFP VREFN VSS DVDD EQBUS APGATE) mq_cdac_bit10
XB9 (DH9 RL9 DVDD VREFN TOP VREFP VREFN VSS DVDD) mq_cdac_bit9
XB8 (VIN VG DH8 RL8 EN ENB TOP VREFP VREFN VSS DVDD EQBUS APGATE) mq_cdac_bit8
XB7 (VIN VG DH7 RL7 EN ENB TOP VREFP VREFN VSS PHI_S DVDD PHI_SB EQBUS APGATE) mq_cdac_bit7
XB6 (DH6 RL6 DVDD VREFN TOP VREFP VREFN VSS DVDD) mq_cdac_bit6
XB5 (VIN VG DH5 RL5 EN ENB TOP VREFP VREFN VSS DVDD EQBUS APGATE) mq_cdac_bit5
XB4 (VIN VG DH4 RL4 EN ENB TOP VREFP VREFN VSS DVDD EQBUS APGATE) mq_cdac_bit4
XB3 (VIN VG DH3 RL3 EN ENB TOP VREFP VREFN VSS DVDD EQBUS APGATE) mq_cdac_bit3
XB2 (VIN VG DH2 RL2 EN ENB TOP VREFP VREFN VSS PHI_S DVDD PHI_SB EQBUS APGATE) mq_cdac_bit2
XB1 (VIN VG DH1 RL1 EN ENB TOP VREFP VREFN VSS DVDD EQBUS APGATE) mq_cdac_bit1
XB0 (VIN VG DH0 RL0 EN ENB TOP VREFP VREFN VSS PHI_S DVDD PHI_SB EQBUS APGATE) mq_cdac_bit0
// @RNL {
//   /* pins connected by net name: the net-name label of rnl-std-fill on every unwired pin, placed below by its key netname */
//   $LABEL_TERMINAL_SET @TEXT("${net}", key="netname", size=0.6);
//   &VSS @ADD-TO $GROUND_NET_SET; &VREFN @ADD-TO $GROUND_NET_SET;
//   &VREFP @ADD-TO $SUPPLY_NET_SET;
//   &DVDD @ADD-TO $SUPPLY_NET_SET;
//   {#MTN #MTP} @GROUP;
//   #XEN @PLACE(160, 12);
//   #XEN @ORIENT("R0");
//   #XEN:IN @TEXT("${net}", key="netname", size=0.6, halign="end", valign="middle", dx=-0.4, dy=0);
//   #XEN:EN @TEXT("${net}", key="netname", size=0.6, halign="start", valign="middle", dx=0.4, dy=0);
//   #XEN:ENB @TEXT("${net}", key="netname", size=0.6, halign="start", valign="middle", dx=0.4, dy=0);
//   %v1 = $SUPPLY @ATTACH &DVDD => @PLACE(160, 19.2);
//   &DVDD @WIRE {#XEN:DVDD (160, 16) %v1:p};
//   %g2 = $GROUND @ATTACH &VREFN => @PLACE(158, 4.8);
//   &VREFN @WIRE {#XEN:VREFN (158, 8) %g2:p};
//   %g3 = $GROUND @ATTACH &VSS => @PLACE(162, 4.8);
//   &VSS @WIRE {#XEN:VSS (162, 8) %g3:p};
//   #XAPULSE @PLACE(160, -62);
//   #XAPULSE @ORIENT("R0");
//   #XAPULSE:PHI_S @TEXT("${net}", key="netname", size=0.6, halign="end", valign="middle", dx=-0.4, dy=0);
//   #XAPULSE:PHI_SB @TEXT("${net}", key="netname", size=0.6, halign="end", valign="middle", dx=-0.4, dy=0);
//   #XAPULSE:AGATE @TEXT("${net}", key="netname", size=0.6, halign="end", valign="middle", dx=-0.4, dy=0);
//   %v4 = $SUPPLY @ATTACH &DVDD => @PLACE(160, -53.8);
//   &DVDD @WIRE {#XAPULSE:DVDD (160, -57) %v4:p};
//   %g5 = $GROUND @ATTACH &VREFN => @PLACE(158, -70.2);
//   &VREFN @WIRE {#XAPULSE:VREFN (158, -67) %g5:p};
//   %g6 = $GROUND @ATTACH &VSS => @PLACE(162, -70.2);
//   &VSS @WIRE {#XAPULSE:VSS (162, -67) %g6:p};
//   #MTN @PLACE(160, -18);
//   #MTN @ORIENT("R0");
//   #MTN:1 @TEXT("${net}", key="netname", size=0.6, halign="start", valign="middle", rotate=90, dx=0, dy=0.4);
//   #MTN:2 @TEXT("${net}", key="netname", size=0.6, halign="end", valign="middle", dx=-0.4, dy=0);
//   #MTN:3 @TEXT("${net}", key="netname", size=0.6, halign="end", valign="middle", rotate=90, dx=0, dy=-0.4);
//   %g7 = $GROUND @ATTACH &VSS => @PLACE(163, -21.2);
//   &VSS @WIRE {#MTN:4 (163, -18) %g7:p};
//   #MTP @PLACE(184, -18);
//   #MTP @ORIENT("R0");
//   #MTP:1 @TEXT("${net}", key="netname", size=0.6, halign="end", valign="middle", rotate=90, dx=0, dy=-0.4);
//   #MTP:2 @TEXT("${net}", key="netname", size=0.6, halign="end", valign="middle", dx=-0.4, dy=0);
//   #MTP:3 @TEXT("${net}", key="netname", size=0.6, halign="start", valign="middle", rotate=90, dx=0, dy=0.4);
//   %v8 = $SUPPLY @ATTACH &DVDD => @PLACE(187, -14.8);
//   &DVDD @WIRE {#MTP:4 (187, -18) %v8:p};
//   #MTD @PLACE(218, -18);
//   #MTD @ORIENT("R0");
//   #MTD:1 @TEXT("${net}", key="netname", size=0.6, halign="start", valign="middle", rotate=90, dx=0, dy=0.4);
//   #MTD:2 @TEXT("${net}", key="netname", size=0.6, halign="end", valign="middle", dx=-0.4, dy=0);
//   #MTD:3 @TEXT("${net}", key="netname", size=0.6, halign="end", valign="middle", rotate=90, dx=0, dy=-0.4);
//   %g9 = $GROUND @ATTACH &VSS => @PLACE(221, -21.2);
//   &VSS @WIRE {#MTD:4 (221, -18) %g9:p};
//   #XB12 @PLACE(-30, 0);
//   #XB12 @ORIENT("R0");
//   #XB12:VIN @TEXT("${net}", key="netname", size=0.6, halign="end", valign="middle", dx=-0.4, dy=0);
//   #XB12:VG @TEXT("${net}", key="netname", size=0.6, halign="end", valign="middle", dx=-0.4, dy=0);
//   #XB12:DH @TEXT("${net}", key="netname", size=0.6, halign="end", valign="middle", dx=-0.4, dy=0);
//   #XB12:RL @TEXT("${net}", key="netname", size=0.6, halign="end", valign="middle", dx=-0.4, dy=0);
//   #XB12:EN @TEXT("${net}", key="netname", size=0.6, halign="end", valign="middle", dx=-0.4, dy=0);
//   #XB12:ENB @TEXT("${net}", key="netname", size=0.6, halign="end", valign="middle", dx=-0.4, dy=0);
//   #XB12:TOP @TEXT("${net}", key="netname", size=0.6, halign="start", valign="middle", dx=0.4, dy=0);
//   %v10 = $SUPPLY @ATTACH &VREFP => @PLACE(-32, 13.2);
//   &VREFP @WIRE {#XB12:VREFP (-32, 10) %v10:p};
//   %g11 = $GROUND @ATTACH &VREFN => @PLACE(-32, -13.2);
//   &VREFN @WIRE {#XB12:VREFN (-32, -10) %g11:p};
//   %g12 = $GROUND @ATTACH &VSS => @PLACE(-28, -13.2);
//   &VSS @WIRE {#XB12:VSS (-28, -10) %g12:p};
//   %v13 = $SUPPLY @ATTACH &DVDD => @PLACE(-28, 13.2);
//   &DVDD @WIRE {#XB12:DVDD (-28, 10) %v13:p};
//   #XB12:EQBUS @TEXT("${net}", key="netname", size=0.6, halign="end", valign="middle", dx=-0.4, dy=0);
//   #XB12:APGATE @TEXT("${net}", key="netname", size=0.6, halign="end", valign="middle", dx=-0.4, dy=0);
//   #XB11 @PLACE(-30, -42);
//   #XB11 @ORIENT("R0");
//   #XB11:VIN @TEXT("${net}", key="netname", size=0.6, halign="end", valign="middle", dx=-0.4, dy=0);
//   #XB11:VG @TEXT("${net}", key="netname", size=0.6, halign="end", valign="middle", dx=-0.4, dy=0);
//   #XB11:DH @TEXT("${net}", key="netname", size=0.6, halign="end", valign="middle", dx=-0.4, dy=0);
//   #XB11:RL @TEXT("${net}", key="netname", size=0.6, halign="end", valign="middle", dx=-0.4, dy=0);
//   #XB11:EN @TEXT("${net}", key="netname", size=0.6, halign="end", valign="middle", dx=-0.4, dy=0);
//   #XB11:ENB @TEXT("${net}", key="netname", size=0.6, halign="end", valign="middle", dx=-0.4, dy=0);
//   #XB11:TOP @TEXT("${net}", key="netname", size=0.6, halign="start", valign="middle", dx=0.4, dy=0);
//   %v14 = $SUPPLY @ATTACH &VREFP => @PLACE(-32, -28.8);
//   &VREFP @WIRE {#XB11:VREFP (-32, -32) %v14:p};
//   %g15 = $GROUND @ATTACH &VREFN => @PLACE(-32, -55.2);
//   &VREFN @WIRE {#XB11:VREFN (-32, -52) %g15:p};
//   %g16 = $GROUND @ATTACH &VSS => @PLACE(-28, -55.2);
//   &VSS @WIRE {#XB11:VSS (-28, -52) %g16:p};
//   %v17 = $SUPPLY @ATTACH &DVDD => @PLACE(-28, -28.8);
//   &DVDD @WIRE {#XB11:DVDD (-28, -32) %v17:p};
//   #XB11:EQBUS @TEXT("${net}", key="netname", size=0.6, halign="end", valign="middle", dx=-0.4, dy=0);
//   #XB11:APGATE @TEXT("${net}", key="netname", size=0.6, halign="end", valign="middle", dx=-0.4, dy=0);
//   #XB10 @PLACE(-30, -84);
//   #XB10 @ORIENT("R0");
//   #XB10:VIN @TEXT("${net}", key="netname", size=0.6, halign="end", valign="middle", dx=-0.4, dy=0);
//   #XB10:VG @TEXT("${net}", key="netname", size=0.6, halign="end", valign="middle", dx=-0.4, dy=0);
//   #XB10:DH @TEXT("${net}", key="netname", size=0.6, halign="end", valign="middle", dx=-0.4, dy=0);
//   #XB10:RL @TEXT("${net}", key="netname", size=0.6, halign="end", valign="middle", dx=-0.4, dy=0);
//   #XB10:EN @TEXT("${net}", key="netname", size=0.6, halign="end", valign="middle", dx=-0.4, dy=0);
//   #XB10:ENB @TEXT("${net}", key="netname", size=0.6, halign="end", valign="middle", dx=-0.4, dy=0);
//   #XB10:TOP @TEXT("${net}", key="netname", size=0.6, halign="start", valign="middle", dx=0.4, dy=0);
//   %v18 = $SUPPLY @ATTACH &VREFP => @PLACE(-32, -70.8);
//   &VREFP @WIRE {#XB10:VREFP (-32, -74) %v18:p};
//   %g19 = $GROUND @ATTACH &VREFN => @PLACE(-32, -97.2);
//   &VREFN @WIRE {#XB10:VREFN (-32, -94) %g19:p};
//   %g20 = $GROUND @ATTACH &VSS => @PLACE(-28, -97.2);
//   &VSS @WIRE {#XB10:VSS (-28, -94) %g20:p};
//   %v21 = $SUPPLY @ATTACH &DVDD => @PLACE(-28, -70.8);
//   &DVDD @WIRE {#XB10:DVDD (-28, -74) %v21:p};
//   #XB10:EQBUS @TEXT("${net}", key="netname", size=0.6, halign="end", valign="middle", dx=-0.4, dy=0);
//   #XB10:APGATE @TEXT("${net}", key="netname", size=0.6, halign="end", valign="middle", dx=-0.4, dy=0);
//   #XB9 @PLACE(-30, -126);
//   #XB9 @ORIENT("R0");
//   #XB9:DH @TEXT("${net}", key="netname", size=0.6, halign="end", valign="middle", dx=-0.4, dy=0);
//   #XB9:RL @TEXT("${net}", key="netname", size=0.6, halign="end", valign="middle", dx=-0.4, dy=0);
//   %v22 = $SUPPLY @ATTACH &DVDD => @PLACE(-37, -123.8);
//   &DVDD @WIRE {#XB9:EN (-37, -127) %v22:p};
//   %g23 = $GROUND @ATTACH &VREFN => @PLACE(-37, -132.2);
//   &VREFN @WIRE {#XB9:ENB (-37, -129) %g23:p};
//   #XB9:TOP @TEXT("${net}", key="netname", size=0.6, halign="start", valign="middle", dx=0.4, dy=0);
//   %v24 = $SUPPLY @ATTACH &VREFP => @PLACE(-32, -116.8);
//   &VREFP @WIRE {#XB9:VREFP (-32, -120) %v24:p};
//   %g25 = $GROUND @ATTACH &VREFN => @PLACE(-32, -135.2);
//   &VREFN @WIRE {#XB9:VREFN (-32, -132) %g25:p};
//   %g26 = $GROUND @ATTACH &VSS => @PLACE(-28, -135.2);
//   &VSS @WIRE {#XB9:VSS (-28, -132) %g26:p};
//   %v27 = $SUPPLY @ATTACH &DVDD => @PLACE(-28, -116.8);
//   &DVDD @WIRE {#XB9:DVDD (-28, -120) %v27:p};
//   #XB8 @PLACE(-30, -168);
//   #XB8 @ORIENT("R0");
//   #XB8:VIN @TEXT("${net}", key="netname", size=0.6, halign="end", valign="middle", dx=-0.4, dy=0);
//   #XB8:VG @TEXT("${net}", key="netname", size=0.6, halign="end", valign="middle", dx=-0.4, dy=0);
//   #XB8:DH @TEXT("${net}", key="netname", size=0.6, halign="end", valign="middle", dx=-0.4, dy=0);
//   #XB8:RL @TEXT("${net}", key="netname", size=0.6, halign="end", valign="middle", dx=-0.4, dy=0);
//   #XB8:EN @TEXT("${net}", key="netname", size=0.6, halign="end", valign="middle", dx=-0.4, dy=0);
//   #XB8:ENB @TEXT("${net}", key="netname", size=0.6, halign="end", valign="middle", dx=-0.4, dy=0);
//   #XB8:TOP @TEXT("${net}", key="netname", size=0.6, halign="start", valign="middle", dx=0.4, dy=0);
//   %v28 = $SUPPLY @ATTACH &VREFP => @PLACE(-32, -154.8);
//   &VREFP @WIRE {#XB8:VREFP (-32, -158) %v28:p};
//   %g29 = $GROUND @ATTACH &VREFN => @PLACE(-32, -181.2);
//   &VREFN @WIRE {#XB8:VREFN (-32, -178) %g29:p};
//   %g30 = $GROUND @ATTACH &VSS => @PLACE(-28, -181.2);
//   &VSS @WIRE {#XB8:VSS (-28, -178) %g30:p};
//   %v31 = $SUPPLY @ATTACH &DVDD => @PLACE(-28, -154.8);
//   &DVDD @WIRE {#XB8:DVDD (-28, -158) %v31:p};
//   #XB8:EQBUS @TEXT("${net}", key="netname", size=0.6, halign="end", valign="middle", dx=-0.4, dy=0);
//   #XB8:APGATE @TEXT("${net}", key="netname", size=0.6, halign="end", valign="middle", dx=-0.4, dy=0);
//   #XB7 @PLACE(28, 0);
//   #XB7 @ORIENT("R0");
//   #XB7:VIN @TEXT("${net}", key="netname", size=0.6, halign="end", valign="middle", dx=-0.4, dy=0);
//   #XB7:VG @TEXT("${net}", key="netname", size=0.6, halign="end", valign="middle", dx=-0.4, dy=0);
//   #XB7:DH @TEXT("${net}", key="netname", size=0.6, halign="end", valign="middle", dx=-0.4, dy=0);
//   #XB7:RL @TEXT("${net}", key="netname", size=0.6, halign="end", valign="middle", dx=-0.4, dy=0);
//   #XB7:EN @TEXT("${net}", key="netname", size=0.6, halign="end", valign="middle", dx=-0.4, dy=0);
//   #XB7:ENB @TEXT("${net}", key="netname", size=0.6, halign="end", valign="middle", dx=-0.4, dy=0);
//   #XB7:TOP @TEXT("${net}", key="netname", size=0.6, halign="start", valign="middle", dx=0.4, dy=0);
//   %v32 = $SUPPLY @ATTACH &VREFP => @PLACE(26, 15.2);
//   &VREFP @WIRE {#XB7:VREFP (26, 12) %v32:p};
//   %g33 = $GROUND @ATTACH &VREFN => @PLACE(26, -15.2);
//   &VREFN @WIRE {#XB7:VREFN (26, -12) %g33:p};
//   %g34 = $GROUND @ATTACH &VSS => @PLACE(30, -15.2);
//   &VSS @WIRE {#XB7:VSS (30, -12) %g34:p};
//   #XB7:PHI_S @TEXT("${net}", key="netname", size=0.6, halign="end", valign="middle", dx=-0.4, dy=0);
//   %v35 = $SUPPLY @ATTACH &DVDD => @PLACE(30, 15.2);
//   &DVDD @WIRE {#XB7:DVDD (30, 12) %v35:p};
//   #XB7:PHI_SB @TEXT("${net}", key="netname", size=0.6, halign="end", valign="middle", dx=-0.4, dy=0);
//   #XB7:EQBUS @TEXT("${net}", key="netname", size=0.6, halign="end", valign="middle", dx=-0.4, dy=0);
//   #XB7:APGATE @TEXT("${net}", key="netname", size=0.6, halign="end", valign="middle", dx=-0.4, dy=0);
//   #XB6 @PLACE(28, -42);
//   #XB6 @ORIENT("R0");
//   #XB6:DH @TEXT("${net}", key="netname", size=0.6, halign="end", valign="middle", dx=-0.4, dy=0);
//   #XB6:RL @TEXT("${net}", key="netname", size=0.6, halign="end", valign="middle", dx=-0.4, dy=0);
//   %v36 = $SUPPLY @ATTACH &DVDD => @PLACE(21, -39.8);
//   &DVDD @WIRE {#XB6:EN (21, -43) %v36:p};
//   %g37 = $GROUND @ATTACH &VREFN => @PLACE(21, -48.2);
//   &VREFN @WIRE {#XB6:ENB (21, -45) %g37:p};
//   #XB6:TOP @TEXT("${net}", key="netname", size=0.6, halign="start", valign="middle", dx=0.4, dy=0);
//   %v38 = $SUPPLY @ATTACH &VREFP => @PLACE(26, -32.8);
//   &VREFP @WIRE {#XB6:VREFP (26, -36) %v38:p};
//   %g39 = $GROUND @ATTACH &VREFN => @PLACE(26, -51.2);
//   &VREFN @WIRE {#XB6:VREFN (26, -48) %g39:p};
//   %g40 = $GROUND @ATTACH &VSS => @PLACE(30, -51.2);
//   &VSS @WIRE {#XB6:VSS (30, -48) %g40:p};
//   %v41 = $SUPPLY @ATTACH &DVDD => @PLACE(30, -32.8);
//   &DVDD @WIRE {#XB6:DVDD (30, -36) %v41:p};
//   #XB5 @PLACE(28, -84);
//   #XB5 @ORIENT("R0");
//   #XB5:VIN @TEXT("${net}", key="netname", size=0.6, halign="end", valign="middle", dx=-0.4, dy=0);
//   #XB5:VG @TEXT("${net}", key="netname", size=0.6, halign="end", valign="middle", dx=-0.4, dy=0);
//   #XB5:DH @TEXT("${net}", key="netname", size=0.6, halign="end", valign="middle", dx=-0.4, dy=0);
//   #XB5:RL @TEXT("${net}", key="netname", size=0.6, halign="end", valign="middle", dx=-0.4, dy=0);
//   #XB5:EN @TEXT("${net}", key="netname", size=0.6, halign="end", valign="middle", dx=-0.4, dy=0);
//   #XB5:ENB @TEXT("${net}", key="netname", size=0.6, halign="end", valign="middle", dx=-0.4, dy=0);
//   #XB5:TOP @TEXT("${net}", key="netname", size=0.6, halign="start", valign="middle", dx=0.4, dy=0);
//   %v42 = $SUPPLY @ATTACH &VREFP => @PLACE(26, -70.8);
//   &VREFP @WIRE {#XB5:VREFP (26, -74) %v42:p};
//   %g43 = $GROUND @ATTACH &VREFN => @PLACE(26, -97.2);
//   &VREFN @WIRE {#XB5:VREFN (26, -94) %g43:p};
//   %g44 = $GROUND @ATTACH &VSS => @PLACE(30, -97.2);
//   &VSS @WIRE {#XB5:VSS (30, -94) %g44:p};
//   %v45 = $SUPPLY @ATTACH &DVDD => @PLACE(30, -70.8);
//   &DVDD @WIRE {#XB5:DVDD (30, -74) %v45:p};
//   #XB5:EQBUS @TEXT("${net}", key="netname", size=0.6, halign="end", valign="middle", dx=-0.4, dy=0);
//   #XB5:APGATE @TEXT("${net}", key="netname", size=0.6, halign="end", valign="middle", dx=-0.4, dy=0);
//   #XB4 @PLACE(28, -126);
//   #XB4 @ORIENT("R0");
//   #XB4:VIN @TEXT("${net}", key="netname", size=0.6, halign="end", valign="middle", dx=-0.4, dy=0);
//   #XB4:VG @TEXT("${net}", key="netname", size=0.6, halign="end", valign="middle", dx=-0.4, dy=0);
//   #XB4:DH @TEXT("${net}", key="netname", size=0.6, halign="end", valign="middle", dx=-0.4, dy=0);
//   #XB4:RL @TEXT("${net}", key="netname", size=0.6, halign="end", valign="middle", dx=-0.4, dy=0);
//   #XB4:EN @TEXT("${net}", key="netname", size=0.6, halign="end", valign="middle", dx=-0.4, dy=0);
//   #XB4:ENB @TEXT("${net}", key="netname", size=0.6, halign="end", valign="middle", dx=-0.4, dy=0);
//   #XB4:TOP @TEXT("${net}", key="netname", size=0.6, halign="start", valign="middle", dx=0.4, dy=0);
//   %v46 = $SUPPLY @ATTACH &VREFP => @PLACE(26, -112.8);
//   &VREFP @WIRE {#XB4:VREFP (26, -116) %v46:p};
//   %g47 = $GROUND @ATTACH &VREFN => @PLACE(26, -139.2);
//   &VREFN @WIRE {#XB4:VREFN (26, -136) %g47:p};
//   %g48 = $GROUND @ATTACH &VSS => @PLACE(30, -139.2);
//   &VSS @WIRE {#XB4:VSS (30, -136) %g48:p};
//   %v49 = $SUPPLY @ATTACH &DVDD => @PLACE(30, -112.8);
//   &DVDD @WIRE {#XB4:DVDD (30, -116) %v49:p};
//   #XB4:EQBUS @TEXT("${net}", key="netname", size=0.6, halign="end", valign="middle", dx=-0.4, dy=0);
//   #XB4:APGATE @TEXT("${net}", key="netname", size=0.6, halign="end", valign="middle", dx=-0.4, dy=0);
//   #XB3 @PLACE(28, -168);
//   #XB3 @ORIENT("R0");
//   #XB3:VIN @TEXT("${net}", key="netname", size=0.6, halign="end", valign="middle", dx=-0.4, dy=0);
//   #XB3:VG @TEXT("${net}", key="netname", size=0.6, halign="end", valign="middle", dx=-0.4, dy=0);
//   #XB3:DH @TEXT("${net}", key="netname", size=0.6, halign="end", valign="middle", dx=-0.4, dy=0);
//   #XB3:RL @TEXT("${net}", key="netname", size=0.6, halign="end", valign="middle", dx=-0.4, dy=0);
//   #XB3:EN @TEXT("${net}", key="netname", size=0.6, halign="end", valign="middle", dx=-0.4, dy=0);
//   #XB3:ENB @TEXT("${net}", key="netname", size=0.6, halign="end", valign="middle", dx=-0.4, dy=0);
//   #XB3:TOP @TEXT("${net}", key="netname", size=0.6, halign="start", valign="middle", dx=0.4, dy=0);
//   %v50 = $SUPPLY @ATTACH &VREFP => @PLACE(26, -154.8);
//   &VREFP @WIRE {#XB3:VREFP (26, -158) %v50:p};
//   %g51 = $GROUND @ATTACH &VREFN => @PLACE(26, -181.2);
//   &VREFN @WIRE {#XB3:VREFN (26, -178) %g51:p};
//   %g52 = $GROUND @ATTACH &VSS => @PLACE(30, -181.2);
//   &VSS @WIRE {#XB3:VSS (30, -178) %g52:p};
//   %v53 = $SUPPLY @ATTACH &DVDD => @PLACE(30, -154.8);
//   &DVDD @WIRE {#XB3:DVDD (30, -158) %v53:p};
//   #XB3:EQBUS @TEXT("${net}", key="netname", size=0.6, halign="end", valign="middle", dx=-0.4, dy=0);
//   #XB3:APGATE @TEXT("${net}", key="netname", size=0.6, halign="end", valign="middle", dx=-0.4, dy=0);
//   #XB2 @PLACE(86, 0);
//   #XB2 @ORIENT("R0");
//   #XB2:VIN @TEXT("${net}", key="netname", size=0.6, halign="end", valign="middle", dx=-0.4, dy=0);
//   #XB2:VG @TEXT("${net}", key="netname", size=0.6, halign="end", valign="middle", dx=-0.4, dy=0);
//   #XB2:DH @TEXT("${net}", key="netname", size=0.6, halign="end", valign="middle", dx=-0.4, dy=0);
//   #XB2:RL @TEXT("${net}", key="netname", size=0.6, halign="end", valign="middle", dx=-0.4, dy=0);
//   #XB2:EN @TEXT("${net}", key="netname", size=0.6, halign="end", valign="middle", dx=-0.4, dy=0);
//   #XB2:ENB @TEXT("${net}", key="netname", size=0.6, halign="end", valign="middle", dx=-0.4, dy=0);
//   #XB2:TOP @TEXT("${net}", key="netname", size=0.6, halign="start", valign="middle", dx=0.4, dy=0);
//   %v54 = $SUPPLY @ATTACH &VREFP => @PLACE(84, 15.2);
//   &VREFP @WIRE {#XB2:VREFP (84, 12) %v54:p};
//   %g55 = $GROUND @ATTACH &VREFN => @PLACE(84, -15.2);
//   &VREFN @WIRE {#XB2:VREFN (84, -12) %g55:p};
//   %g56 = $GROUND @ATTACH &VSS => @PLACE(88, -15.2);
//   &VSS @WIRE {#XB2:VSS (88, -12) %g56:p};
//   #XB2:PHI_S @TEXT("${net}", key="netname", size=0.6, halign="end", valign="middle", dx=-0.4, dy=0);
//   %v57 = $SUPPLY @ATTACH &DVDD => @PLACE(88, 15.2);
//   &DVDD @WIRE {#XB2:DVDD (88, 12) %v57:p};
//   #XB2:PHI_SB @TEXT("${net}", key="netname", size=0.6, halign="end", valign="middle", dx=-0.4, dy=0);
//   #XB2:EQBUS @TEXT("${net}", key="netname", size=0.6, halign="end", valign="middle", dx=-0.4, dy=0);
//   #XB2:APGATE @TEXT("${net}", key="netname", size=0.6, halign="end", valign="middle", dx=-0.4, dy=0);
//   #XB1 @PLACE(86, -42);
//   #XB1 @ORIENT("R0");
//   #XB1:VIN @TEXT("${net}", key="netname", size=0.6, halign="end", valign="middle", dx=-0.4, dy=0);
//   #XB1:VG @TEXT("${net}", key="netname", size=0.6, halign="end", valign="middle", dx=-0.4, dy=0);
//   #XB1:DH @TEXT("${net}", key="netname", size=0.6, halign="end", valign="middle", dx=-0.4, dy=0);
//   #XB1:RL @TEXT("${net}", key="netname", size=0.6, halign="end", valign="middle", dx=-0.4, dy=0);
//   #XB1:EN @TEXT("${net}", key="netname", size=0.6, halign="end", valign="middle", dx=-0.4, dy=0);
//   #XB1:ENB @TEXT("${net}", key="netname", size=0.6, halign="end", valign="middle", dx=-0.4, dy=0);
//   #XB1:TOP @TEXT("${net}", key="netname", size=0.6, halign="start", valign="middle", dx=0.4, dy=0);
//   %v58 = $SUPPLY @ATTACH &VREFP => @PLACE(84, -28.8);
//   &VREFP @WIRE {#XB1:VREFP (84, -32) %v58:p};
//   %g59 = $GROUND @ATTACH &VREFN => @PLACE(84, -55.2);
//   &VREFN @WIRE {#XB1:VREFN (84, -52) %g59:p};
//   %g60 = $GROUND @ATTACH &VSS => @PLACE(88, -55.2);
//   &VSS @WIRE {#XB1:VSS (88, -52) %g60:p};
//   %v61 = $SUPPLY @ATTACH &DVDD => @PLACE(88, -28.8);
//   &DVDD @WIRE {#XB1:DVDD (88, -32) %v61:p};
//   #XB1:EQBUS @TEXT("${net}", key="netname", size=0.6, halign="end", valign="middle", dx=-0.4, dy=0);
//   #XB1:APGATE @TEXT("${net}", key="netname", size=0.6, halign="end", valign="middle", dx=-0.4, dy=0);
//   #XB0 @PLACE(86, -84);
//   #XB0 @ORIENT("R0");
//   #XB0:VIN @TEXT("${net}", key="netname", size=0.6, halign="end", valign="middle", dx=-0.4, dy=0);
//   #XB0:VG @TEXT("${net}", key="netname", size=0.6, halign="end", valign="middle", dx=-0.4, dy=0);
//   #XB0:DH @TEXT("${net}", key="netname", size=0.6, halign="end", valign="middle", dx=-0.4, dy=0);
//   #XB0:RL @TEXT("${net}", key="netname", size=0.6, halign="end", valign="middle", dx=-0.4, dy=0);
//   #XB0:EN @TEXT("${net}", key="netname", size=0.6, halign="end", valign="middle", dx=-0.4, dy=0);
//   #XB0:ENB @TEXT("${net}", key="netname", size=0.6, halign="end", valign="middle", dx=-0.4, dy=0);
//   #XB0:TOP @TEXT("${net}", key="netname", size=0.6, halign="start", valign="middle", dx=0.4, dy=0);
//   %v62 = $SUPPLY @ATTACH &VREFP => @PLACE(84, -68.8);
//   &VREFP @WIRE {#XB0:VREFP (84, -72) %v62:p};
//   %g63 = $GROUND @ATTACH &VREFN => @PLACE(84, -99.2);
//   &VREFN @WIRE {#XB0:VREFN (84, -96) %g63:p};
//   %g64 = $GROUND @ATTACH &VSS => @PLACE(88, -99.2);
//   &VSS @WIRE {#XB0:VSS (88, -96) %g64:p};
//   #XB0:PHI_S @TEXT("${net}", key="netname", size=0.6, halign="end", valign="middle", dx=-0.4, dy=0);
//   %v65 = $SUPPLY @ATTACH &DVDD => @PLACE(88, -68.8);
//   &DVDD @WIRE {#XB0:DVDD (88, -72) %v65:p};
//   #XB0:PHI_SB @TEXT("${net}", key="netname", size=0.6, halign="end", valign="middle", dx=-0.4, dy=0);
//   #XB0:EQBUS @TEXT("${net}", key="netname", size=0.6, halign="end", valign="middle", dx=-0.4, dy=0);
//   #XB0:APGATE @TEXT("${net}", key="netname", size=0.6, halign="end", valign="middle", dx=-0.4, dy=0);
//   %p_vin = $IO_PORT @ATTACH &VIN => @PLACE(-41, 7) => @ORIENT("R0");
//   &VIN @WIRE {%p_vin:p #XB12:VIN};
//   %p_vg = $IO_PORT @ATTACH &VG => @PLACE(-41, 5) => @ORIENT("R0");
//   &VG @WIRE {%p_vg:p #XB12:VG};
//   %p_top = $IO_PORT @ATTACH &TOP => @PLACE(160, -12) => @ORIENT("R270");
//   &TOP @WIRE {%p_top:p #MTN:1};
//   %p_vcm = $IO_PORT @ATTACH &VCM => @PLACE(160, -24) => @ORIENT("R90");
//   &VCM @WIRE {%p_vcm:p #MTN:3};
//   %p_phi_s = $IO_PORT @ATTACH &PHI_S => @PLACE(149, -60) => @ORIENT("R0");
//   &PHI_S @WIRE {%p_phi_s:p #XAPULSE:PHI_S};
//   %p_phi_sb = $IO_PORT @ATTACH &PHI_SB => @PLACE(149, -62) => @ORIENT("R0");
//   &PHI_SB @WIRE {%p_phi_sb:p #XAPULSE:PHI_SB};
//   %p_conv = $IO_PORT @ATTACH &CONV => @PLACE(149, 12) => @ORIENT("R0");
//   &CONV @WIRE {%p_conv:p #XEN:IN};
//   %p_dh12 = $IO_PORT @ATTACH &DH12 => @PLACE(-41, 3) => @ORIENT("R0");
//   &DH12 @WIRE {%p_dh12:p #XB12:DH};
//   %p_dh11 = $IO_PORT @ATTACH &DH11 => @PLACE(-41, -39) => @ORIENT("R0");
//   &DH11 @WIRE {%p_dh11:p #XB11:DH};
//   %p_dh10 = $IO_PORT @ATTACH &DH10 => @PLACE(-41, -81) => @ORIENT("R0");
//   &DH10 @WIRE {%p_dh10:p #XB10:DH};
//   %p_dh9 = $IO_PORT @ATTACH &DH9 => @PLACE(-41, -123) => @ORIENT("R0");
//   &DH9 @WIRE {%p_dh9:p #XB9:DH};
//   %p_dh8 = $IO_PORT @ATTACH &DH8 => @PLACE(-41, -165) => @ORIENT("R0");
//   &DH8 @WIRE {%p_dh8:p #XB8:DH};
//   %p_dh7 = $IO_PORT @ATTACH &DH7 => @PLACE(17, 5) => @ORIENT("R0");
//   &DH7 @WIRE {%p_dh7:p #XB7:DH};
//   %p_dh6 = $IO_PORT @ATTACH &DH6 => @PLACE(17, -39) => @ORIENT("R0");
//   &DH6 @WIRE {%p_dh6:p #XB6:DH};
//   %p_dh5 = $IO_PORT @ATTACH &DH5 => @PLACE(17, -81) => @ORIENT("R0");
//   &DH5 @WIRE {%p_dh5:p #XB5:DH};
//   %p_dh4 = $IO_PORT @ATTACH &DH4 => @PLACE(17, -123) => @ORIENT("R0");
//   &DH4 @WIRE {%p_dh4:p #XB4:DH};
//   %p_dh3 = $IO_PORT @ATTACH &DH3 => @PLACE(17, -165) => @ORIENT("R0");
//   &DH3 @WIRE {%p_dh3:p #XB3:DH};
//   %p_dh2 = $IO_PORT @ATTACH &DH2 => @PLACE(75, 5) => @ORIENT("R0");
//   &DH2 @WIRE {%p_dh2:p #XB2:DH};
//   %p_dh1 = $IO_PORT @ATTACH &DH1 => @PLACE(75, -39) => @ORIENT("R0");
//   &DH1 @WIRE {%p_dh1:p #XB1:DH};
//   %p_dh0 = $IO_PORT @ATTACH &DH0 => @PLACE(75, -79) => @ORIENT("R0");
//   &DH0 @WIRE {%p_dh0:p #XB0:DH};
//   %p_rl12 = $IO_PORT @ATTACH &RL12 => @PLACE(-41, 1) => @ORIENT("R0");
//   &RL12 @WIRE {%p_rl12:p #XB12:RL};
//   %p_rl11 = $IO_PORT @ATTACH &RL11 => @PLACE(-41, -41) => @ORIENT("R0");
//   &RL11 @WIRE {%p_rl11:p #XB11:RL};
//   %p_rl10 = $IO_PORT @ATTACH &RL10 => @PLACE(-41, -83) => @ORIENT("R0");
//   &RL10 @WIRE {%p_rl10:p #XB10:RL};
//   %p_rl9 = $IO_PORT @ATTACH &RL9 => @PLACE(-41, -125) => @ORIENT("R0");
//   &RL9 @WIRE {%p_rl9:p #XB9:RL};
//   %p_rl8 = $IO_PORT @ATTACH &RL8 => @PLACE(-41, -167) => @ORIENT("R0");
//   &RL8 @WIRE {%p_rl8:p #XB8:RL};
//   %p_rl7 = $IO_PORT @ATTACH &RL7 => @PLACE(17, 3) => @ORIENT("R0");
//   &RL7 @WIRE {%p_rl7:p #XB7:RL};
//   %p_rl6 = $IO_PORT @ATTACH &RL6 => @PLACE(17, -41) => @ORIENT("R0");
//   &RL6 @WIRE {%p_rl6:p #XB6:RL};
//   %p_rl5 = $IO_PORT @ATTACH &RL5 => @PLACE(17, -83) => @ORIENT("R0");
//   &RL5 @WIRE {%p_rl5:p #XB5:RL};
//   %p_rl4 = $IO_PORT @ATTACH &RL4 => @PLACE(17, -125) => @ORIENT("R0");
//   &RL4 @WIRE {%p_rl4:p #XB4:RL};
//   %p_rl3 = $IO_PORT @ATTACH &RL3 => @PLACE(17, -167) => @ORIENT("R0");
//   &RL3 @WIRE {%p_rl3:p #XB3:RL};
//   %p_rl2 = $IO_PORT @ATTACH &RL2 => @PLACE(75, 3) => @ORIENT("R0");
//   &RL2 @WIRE {%p_rl2:p #XB2:RL};
//   %p_rl1 = $IO_PORT @ATTACH &RL1 => @PLACE(75, -41) => @ORIENT("R0");
//   &RL1 @WIRE {%p_rl1:p #XB1:RL};
//   %p_rl0 = $IO_PORT @ATTACH &RL0 => @PLACE(75, -81) => @ORIENT("R0");
//   &RL0 @WIRE {%p_rl0:p #XB0:RL};
//   (-10, 34) @TEXT("CDAC: split-supply drivers and physical sampling switches") => @SET-STYLE $title_style
// }
ends adc_cdac
