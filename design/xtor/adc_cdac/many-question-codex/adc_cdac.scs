// V29 layout hierarchy: pure MOM array and separate bottom switching array.
// @RNL(type="header") {
// @VERSION("0.3");
// @USE-PACKAGE(name="adc28", version="0.1", path="../../../rnl/adc28.rnl");
// }
// @RNL {
// $BOOST = @DEFINE-SYMBOL {
// @LINE {(-10,-7) (10,-7) (10,7) (-10,7) (-10,-7)};
// (-14,0) @PIN(terminal=1, direction="left");
// @LINE {(-14,0) (-10,0)};
// (14,0) @PIN(terminal=2, direction="right");
// @LINE {(10,0) (14,0)};
// (-4,11) @PIN(terminal=3, direction="up");
// @LINE {(-4,11) (-4,7)};
// (4,11) @PIN(terminal=4, direction="up");
// @LINE {(4,11) (4,7)};
// (0,-11) @PIN(terminal=5, direction="down");
// @LINE {(0,-11) (0,-7)};
// (-9,0) @TEXT("CLKB", size=1, valign="middle");
// (9,0) @TEXT("BST", size=1, halign="end", valign="middle");
// (-4,6) @TEXT("DVDD", size=0.8, halign="middle");
// (4,6) @TEXT("VB", size=0.8, halign="middle");
// (0,-6) @TEXT("VSS", size=0.8, halign="middle");
// (0,3) @TEXT("Booster", size=1.2, halign="middle");
// (0,-3) @TEXT("MOS driver", size=0.9, halign="middle");
// ? @TEXT("${name}", key="name", size=1.1, bold=true) => @PLACE(-10,13);
// };
// # @SELECT-INSTANCE(model="mq_cdac_reset_booster") => @SET-SYMBOL $BOOST;
// }
// @RNL {
// # @SELECT-INSTANCE(model="mq_cdac_ctl_l") => @SET-SYMBOL $INVERTER;
// # @SELECT-INSTANCE(model="mq_cdac_ctl_h") => @SET-SYMBOL $BUFFER;
// $DRAW_mq_cdac_enable = @DEFINE-SYMBOL {
//   @LINE {(-10, 0) (-6, 0)};
//   @LINE {(-6, 2) (-2, 0) (-6, -2) (-6, 2)};
//   (-1.3,0) @CIRCLE(radius=0.7);
//   @LINE {(-0.6, 0) (2, 0) (2, -3) (12, -3)};
//   @LINE {(2, 0) (2, 3) (4, 3)};
//   @LINE {(4, 5) (8, 3) (4, 1) (4, 5)};
//   (8.7,3) @CIRCLE(radius=0.7);
//   @LINE {(9.4, 3) (12, 3)};
//   (0, -6) @TEXT("EN + complement", size=1.05, halign="middle");
//   @LINE {(-5, 11) (-5, 9)};
//   @LINE {(-5, -11) (-5, -9)};
//   @LINE {(5, -11) (5, -9)};
//   (-10, 0) @PIN(terminal=1, direction="left");
//   (12, 3) @PIN(terminal=2, direction="right");
//   (12, -3) @PIN(terminal=3, direction="right");
//   (-5, 11) @PIN(terminal=4, direction="up");
//   (-5, -11) @PIN(terminal=5, direction="down");
//   (5, -11) @PIN(terminal=6, direction="down");
//   ? @TEXT("${name}", key="name", size=0.9, bold=true) => @PLACE(-7, 11);
// };
// # @SELECT-INSTANCE(model="mq_cdac_enable") => @SET-SYMBOL $DRAW_mq_cdac_enable;
// $DRAW_mq_cdac_drv12 = @DEFINE-SYMBOL {
//   @LINE {(-4, 6) (5, 2) (-4, -2) (-4, 6)};
//   (5.7,2) @CIRCLE(radius=0.7);
//   @LINE {(6.4, 2) (9, 2)};
//   (0, 1) @TEXT("REF", size=1.05, halign="middle");
//   (0, -6.8) @TEXT("EN / high-Z", size=1.05, halign="middle");
//   (-8, 2) @PIN(terminal=1, direction="left");
//   @LINE {(-8, 2) (-5, 2)};
//   (-4.8, 2) @TEXT("HIB", size=1.05, halign="start", valign="middle");
//   (-8, -2) @PIN(terminal=2, direction="left");
//   @LINE {(-8, -2) (-5, -2)};
//   (-4.8, -2) @TEXT("EN", size=1.05, halign="start", valign="middle");
//   (-8, -5) @PIN(terminal=3, direction="left");
//   @LINE {(-8, -5) (-5, -5)};
//   (-4.8, -5) @TEXT("ENB", size=1.05, halign="start", valign="middle");
//   (9, 2) @PIN(terminal=4, direction="right");
//   (9, 1) @TEXT("BP", size=1.05, halign="middle");
//   (3, 9) @PIN(terminal=5, direction="up");
//   (3, 8) @TEXT("VREFP", size=1.05, halign="middle");
//   (3, -9) @PIN(terminal=6, direction="down");
//   (3, -8) @TEXT("VREFN", size=1.05, halign="middle");
//   (-3, -9) @PIN(terminal=7, direction="down");
//   (-3, -8) @TEXT("VSS", size=1.05, halign="middle");
//   (-3, 9) @PIN(terminal=8, direction="up");
//   (-3, 8) @TEXT("DVDD", size=1.05, halign="middle");
//   ? @TEXT("${name}", key="name", size=0.9, bold=true) => @PLACE(-7, 11);
// };
// # @SELECT-INSTANCE(model="mq_cdac_drv12") => @SET-SYMBOL $DRAW_mq_cdac_drv12;
// $DRAW_mq_cdac_drv11 = @DEFINE-SYMBOL {
//   @LINE {(-4, 6) (5, 2) (-4, -2) (-4, 6)};
//   (5.7,2) @CIRCLE(radius=0.7);
//   @LINE {(6.4, 2) (9, 2)};
//   (0, 1) @TEXT("REF", size=1.05, halign="middle");
//   (0, -6.8) @TEXT("EN / high-Z", size=1.05, halign="middle");
//   (-8, 2) @PIN(terminal=1, direction="left");
//   @LINE {(-8, 2) (-5, 2)};
//   (-4.8, 2) @TEXT("HIB", size=1.05, halign="start", valign="middle");
//   (-8, -2) @PIN(terminal=2, direction="left");
//   @LINE {(-8, -2) (-5, -2)};
//   (-4.8, -2) @TEXT("EN", size=1.05, halign="start", valign="middle");
//   (-8, -5) @PIN(terminal=3, direction="left");
//   @LINE {(-8, -5) (-5, -5)};
//   (-4.8, -5) @TEXT("ENB", size=1.05, halign="start", valign="middle");
//   (9, 2) @PIN(terminal=4, direction="right");
//   (9, 1) @TEXT("BP", size=1.05, halign="middle");
//   (3, 9) @PIN(terminal=5, direction="up");
//   (3, 8) @TEXT("VREFP", size=1.05, halign="middle");
//   (3, -9) @PIN(terminal=6, direction="down");
//   (3, -8) @TEXT("VREFN", size=1.05, halign="middle");
//   (-3, -9) @PIN(terminal=7, direction="down");
//   (-3, -8) @TEXT("VSS", size=1.05, halign="middle");
//   (-3, 9) @PIN(terminal=8, direction="up");
//   (-3, 8) @TEXT("DVDD", size=1.05, halign="middle");
//   ? @TEXT("${name}", key="name", size=0.9, bold=true) => @PLACE(-7, 11);
// };
// # @SELECT-INSTANCE(model="mq_cdac_drv11") => @SET-SYMBOL $DRAW_mq_cdac_drv11;
// $DRAW_mq_cdac_drv10 = @DEFINE-SYMBOL {
//   @LINE {(-4, 6) (5, 2) (-4, -2) (-4, 6)};
//   (5.7,2) @CIRCLE(radius=0.7);
//   @LINE {(6.4, 2) (9, 2)};
//   (0, 1) @TEXT("REF", size=1.05, halign="middle");
//   (0, -6.8) @TEXT("EN / high-Z", size=1.05, halign="middle");
//   (-8, 2) @PIN(terminal=1, direction="left");
//   @LINE {(-8, 2) (-5, 2)};
//   (-4.8, 2) @TEXT("HIB", size=1.05, halign="start", valign="middle");
//   (-8, -2) @PIN(terminal=2, direction="left");
//   @LINE {(-8, -2) (-5, -2)};
//   (-4.8, -2) @TEXT("EN", size=1.05, halign="start", valign="middle");
//   (-8, -5) @PIN(terminal=3, direction="left");
//   @LINE {(-8, -5) (-5, -5)};
//   (-4.8, -5) @TEXT("ENB", size=1.05, halign="start", valign="middle");
//   (9, 2) @PIN(terminal=4, direction="right");
//   (9, 1) @TEXT("BP", size=1.05, halign="middle");
//   (3, 9) @PIN(terminal=5, direction="up");
//   (3, 8) @TEXT("VREFP", size=1.05, halign="middle");
//   (3, -9) @PIN(terminal=6, direction="down");
//   (3, -8) @TEXT("VREFN", size=1.05, halign="middle");
//   (-3, -9) @PIN(terminal=7, direction="down");
//   (-3, -8) @TEXT("VSS", size=1.05, halign="middle");
//   (-3, 9) @PIN(terminal=8, direction="up");
//   (-3, 8) @TEXT("DVDD", size=1.05, halign="middle");
//   ? @TEXT("${name}", key="name", size=0.9, bold=true) => @PLACE(-7, 11);
// };
// # @SELECT-INSTANCE(model="mq_cdac_drv10") => @SET-SYMBOL $DRAW_mq_cdac_drv10;
// $DRAW_mq_cdac_drv9 = @DEFINE-SYMBOL {
//   @LINE {(-4, 6) (5, 2) (-4, -2) (-4, 6)};
//   (5.7,2) @CIRCLE(radius=0.7);
//   @LINE {(6.4, 2) (9, 2)};
//   (0, 1) @TEXT("REF", size=1.05, halign="middle");
//   (0, -6.8) @TEXT("EN / high-Z", size=1.05, halign="middle");
//   (-8, 2) @PIN(terminal=1, direction="left");
//   @LINE {(-8, 2) (-5, 2)};
//   (-4.8, 2) @TEXT("HIB", size=1.05, halign="start", valign="middle");
//   (-8, -2) @PIN(terminal=2, direction="left");
//   @LINE {(-8, -2) (-5, -2)};
//   (-4.8, -2) @TEXT("EN", size=1.05, halign="start", valign="middle");
//   (-8, -5) @PIN(terminal=3, direction="left");
//   @LINE {(-8, -5) (-5, -5)};
//   (-4.8, -5) @TEXT("ENB", size=1.05, halign="start", valign="middle");
//   (9, 2) @PIN(terminal=4, direction="right");
//   (9, 1) @TEXT("BP", size=1.05, halign="middle");
//   (3, 9) @PIN(terminal=5, direction="up");
//   (3, 8) @TEXT("VREFP", size=1.05, halign="middle");
//   (3, -9) @PIN(terminal=6, direction="down");
//   (3, -8) @TEXT("VREFN", size=1.05, halign="middle");
//   (-3, -9) @PIN(terminal=7, direction="down");
//   (-3, -8) @TEXT("VSS", size=1.05, halign="middle");
//   (-3, 9) @PIN(terminal=8, direction="up");
//   (-3, 8) @TEXT("DVDD", size=1.05, halign="middle");
//   ? @TEXT("${name}", key="name", size=0.9, bold=true) => @PLACE(-7, 11);
// };
// # @SELECT-INSTANCE(model="mq_cdac_drv9") => @SET-SYMBOL $DRAW_mq_cdac_drv9;
// $DRAW_mq_cdac_drv8 = @DEFINE-SYMBOL {
//   @LINE {(-4, 6) (5, 2) (-4, -2) (-4, 6)};
//   (5.7,2) @CIRCLE(radius=0.7);
//   @LINE {(6.4, 2) (9, 2)};
//   (0, 1) @TEXT("REF", size=1.05, halign="middle");
//   (0, -6.8) @TEXT("EN / high-Z", size=1.05, halign="middle");
//   (-8, 2) @PIN(terminal=1, direction="left");
//   @LINE {(-8, 2) (-5, 2)};
//   (-4.8, 2) @TEXT("HIB", size=1.05, halign="start", valign="middle");
//   (-8, -2) @PIN(terminal=2, direction="left");
//   @LINE {(-8, -2) (-5, -2)};
//   (-4.8, -2) @TEXT("EN", size=1.05, halign="start", valign="middle");
//   (-8, -5) @PIN(terminal=3, direction="left");
//   @LINE {(-8, -5) (-5, -5)};
//   (-4.8, -5) @TEXT("ENB", size=1.05, halign="start", valign="middle");
//   (9, 2) @PIN(terminal=4, direction="right");
//   (9, 1) @TEXT("BP", size=1.05, halign="middle");
//   (3, 9) @PIN(terminal=5, direction="up");
//   (3, 8) @TEXT("VREFP", size=1.05, halign="middle");
//   (3, -9) @PIN(terminal=6, direction="down");
//   (3, -8) @TEXT("VREFN", size=1.05, halign="middle");
//   (-3, -9) @PIN(terminal=7, direction="down");
//   (-3, -8) @TEXT("VSS", size=1.05, halign="middle");
//   (-3, 9) @PIN(terminal=8, direction="up");
//   (-3, 8) @TEXT("DVDD", size=1.05, halign="middle");
//   ? @TEXT("${name}", key="name", size=0.9, bold=true) => @PLACE(-7, 11);
// };
// # @SELECT-INSTANCE(model="mq_cdac_drv8") => @SET-SYMBOL $DRAW_mq_cdac_drv8;
// $DRAW_mq_cdac_drv7 = @DEFINE-SYMBOL {
//   @LINE {(-4, 6) (5, 2) (-4, -2) (-4, 6)};
//   (5.7,2) @CIRCLE(radius=0.7);
//   @LINE {(6.4, 2) (9, 2)};
//   (0, 1) @TEXT("REF", size=1.05, halign="middle");
//   (0, -6.8) @TEXT("EN / high-Z", size=1.05, halign="middle");
//   (-8, 2) @PIN(terminal=1, direction="left");
//   @LINE {(-8, 2) (-5, 2)};
//   (-4.8, 2) @TEXT("HIB", size=1.05, halign="start", valign="middle");
//   (-8, -2) @PIN(terminal=2, direction="left");
//   @LINE {(-8, -2) (-5, -2)};
//   (-4.8, -2) @TEXT("EN", size=1.05, halign="start", valign="middle");
//   (-8, -5) @PIN(terminal=3, direction="left");
//   @LINE {(-8, -5) (-5, -5)};
//   (-4.8, -5) @TEXT("ENB", size=1.05, halign="start", valign="middle");
//   (9, 2) @PIN(terminal=4, direction="right");
//   (9, 1) @TEXT("BP", size=1.05, halign="middle");
//   (3, 9) @PIN(terminal=5, direction="up");
//   (3, 8) @TEXT("VREFP", size=1.05, halign="middle");
//   (3, -9) @PIN(terminal=6, direction="down");
//   (3, -8) @TEXT("VREFN", size=1.05, halign="middle");
//   (-3, -9) @PIN(terminal=7, direction="down");
//   (-3, -8) @TEXT("VSS", size=1.05, halign="middle");
//   (-3, 9) @PIN(terminal=8, direction="up");
//   (-3, 8) @TEXT("DVDD", size=1.05, halign="middle");
//   ? @TEXT("${name}", key="name", size=0.9, bold=true) => @PLACE(-7, 11);
// };
// # @SELECT-INSTANCE(model="mq_cdac_drv7") => @SET-SYMBOL $DRAW_mq_cdac_drv7;
// $DRAW_mq_cdac_drv6 = @DEFINE-SYMBOL {
//   @LINE {(-4, 6) (5, 2) (-4, -2) (-4, 6)};
//   (5.7,2) @CIRCLE(radius=0.7);
//   @LINE {(6.4, 2) (9, 2)};
//   (0, 1) @TEXT("REF", size=1.05, halign="middle");
//   (0, -6.8) @TEXT("EN / high-Z", size=1.05, halign="middle");
//   (-8, 2) @PIN(terminal=1, direction="left");
//   @LINE {(-8, 2) (-5, 2)};
//   (-4.8, 2) @TEXT("HIB", size=1.05, halign="start", valign="middle");
//   (-8, -2) @PIN(terminal=2, direction="left");
//   @LINE {(-8, -2) (-5, -2)};
//   (-4.8, -2) @TEXT("EN", size=1.05, halign="start", valign="middle");
//   (-8, -5) @PIN(terminal=3, direction="left");
//   @LINE {(-8, -5) (-5, -5)};
//   (-4.8, -5) @TEXT("ENB", size=1.05, halign="start", valign="middle");
//   (9, 2) @PIN(terminal=4, direction="right");
//   (9, 1) @TEXT("BP", size=1.05, halign="middle");
//   (3, 9) @PIN(terminal=5, direction="up");
//   (3, 8) @TEXT("VREFP", size=1.05, halign="middle");
//   (3, -9) @PIN(terminal=6, direction="down");
//   (3, -8) @TEXT("VREFN", size=1.05, halign="middle");
//   (-3, -9) @PIN(terminal=7, direction="down");
//   (-3, -8) @TEXT("VSS", size=1.05, halign="middle");
//   (-3, 9) @PIN(terminal=8, direction="up");
//   (-3, 8) @TEXT("DVDD", size=1.05, halign="middle");
//   ? @TEXT("${name}", key="name", size=0.9, bold=true) => @PLACE(-7, 11);
// };
// # @SELECT-INSTANCE(model="mq_cdac_drv6") => @SET-SYMBOL $DRAW_mq_cdac_drv6;
// $DRAW_mq_cdac_drv5 = @DEFINE-SYMBOL {
//   @LINE {(-4, 6) (5, 2) (-4, -2) (-4, 6)};
//   (5.7,2) @CIRCLE(radius=0.7);
//   @LINE {(6.4, 2) (9, 2)};
//   (0, 1) @TEXT("REF", size=1.05, halign="middle");
//   (0, -6.8) @TEXT("EN / high-Z", size=1.05, halign="middle");
//   (-8, 2) @PIN(terminal=1, direction="left");
//   @LINE {(-8, 2) (-5, 2)};
//   (-4.8, 2) @TEXT("HIB", size=1.05, halign="start", valign="middle");
//   (-8, -2) @PIN(terminal=2, direction="left");
//   @LINE {(-8, -2) (-5, -2)};
//   (-4.8, -2) @TEXT("EN", size=1.05, halign="start", valign="middle");
//   (-8, -5) @PIN(terminal=3, direction="left");
//   @LINE {(-8, -5) (-5, -5)};
//   (-4.8, -5) @TEXT("ENB", size=1.05, halign="start", valign="middle");
//   (9, 2) @PIN(terminal=4, direction="right");
//   (9, 1) @TEXT("BP", size=1.05, halign="middle");
//   (3, 9) @PIN(terminal=5, direction="up");
//   (3, 8) @TEXT("VREFP", size=1.05, halign="middle");
//   (3, -9) @PIN(terminal=6, direction="down");
//   (3, -8) @TEXT("VREFN", size=1.05, halign="middle");
//   (-3, -9) @PIN(terminal=7, direction="down");
//   (-3, -8) @TEXT("VSS", size=1.05, halign="middle");
//   (-3, 9) @PIN(terminal=8, direction="up");
//   (-3, 8) @TEXT("DVDD", size=1.05, halign="middle");
//   ? @TEXT("${name}", key="name", size=0.9, bold=true) => @PLACE(-7, 11);
// };
// # @SELECT-INSTANCE(model="mq_cdac_drv5") => @SET-SYMBOL $DRAW_mq_cdac_drv5;
// $DRAW_mq_cdac_drv4 = @DEFINE-SYMBOL {
//   @LINE {(-4, 6) (5, 2) (-4, -2) (-4, 6)};
//   (5.7,2) @CIRCLE(radius=0.7);
//   @LINE {(6.4, 2) (9, 2)};
//   (0, 1) @TEXT("REF", size=1.05, halign="middle");
//   (0, -6.8) @TEXT("EN / high-Z", size=1.05, halign="middle");
//   (-8, 2) @PIN(terminal=1, direction="left");
//   @LINE {(-8, 2) (-5, 2)};
//   (-4.8, 2) @TEXT("HIB", size=1.05, halign="start", valign="middle");
//   (-8, -2) @PIN(terminal=2, direction="left");
//   @LINE {(-8, -2) (-5, -2)};
//   (-4.8, -2) @TEXT("EN", size=1.05, halign="start", valign="middle");
//   (-8, -5) @PIN(terminal=3, direction="left");
//   @LINE {(-8, -5) (-5, -5)};
//   (-4.8, -5) @TEXT("ENB", size=1.05, halign="start", valign="middle");
//   (9, 2) @PIN(terminal=4, direction="right");
//   (9, 1) @TEXT("BP", size=1.05, halign="middle");
//   (3, 9) @PIN(terminal=5, direction="up");
//   (3, 8) @TEXT("VREFP", size=1.05, halign="middle");
//   (3, -9) @PIN(terminal=6, direction="down");
//   (3, -8) @TEXT("VREFN", size=1.05, halign="middle");
//   (-3, -9) @PIN(terminal=7, direction="down");
//   (-3, -8) @TEXT("VSS", size=1.05, halign="middle");
//   (-3, 9) @PIN(terminal=8, direction="up");
//   (-3, 8) @TEXT("DVDD", size=1.05, halign="middle");
//   ? @TEXT("${name}", key="name", size=0.9, bold=true) => @PLACE(-7, 11);
// };
// # @SELECT-INSTANCE(model="mq_cdac_drv4") => @SET-SYMBOL $DRAW_mq_cdac_drv4;
// $DRAW_mq_cdac_drv3 = @DEFINE-SYMBOL {
//   @LINE {(-4, 6) (5, 2) (-4, -2) (-4, 6)};
//   (5.7,2) @CIRCLE(radius=0.7);
//   @LINE {(6.4, 2) (9, 2)};
//   (0, 1) @TEXT("REF", size=1.05, halign="middle");
//   (0, -6.8) @TEXT("EN / high-Z", size=1.05, halign="middle");
//   (-8, 2) @PIN(terminal=1, direction="left");
//   @LINE {(-8, 2) (-5, 2)};
//   (-4.8, 2) @TEXT("HIB", size=1.05, halign="start", valign="middle");
//   (-8, -2) @PIN(terminal=2, direction="left");
//   @LINE {(-8, -2) (-5, -2)};
//   (-4.8, -2) @TEXT("EN", size=1.05, halign="start", valign="middle");
//   (-8, -5) @PIN(terminal=3, direction="left");
//   @LINE {(-8, -5) (-5, -5)};
//   (-4.8, -5) @TEXT("ENB", size=1.05, halign="start", valign="middle");
//   (9, 2) @PIN(terminal=4, direction="right");
//   (9, 1) @TEXT("BP", size=1.05, halign="middle");
//   (3, 9) @PIN(terminal=5, direction="up");
//   (3, 8) @TEXT("VREFP", size=1.05, halign="middle");
//   (3, -9) @PIN(terminal=6, direction="down");
//   (3, -8) @TEXT("VREFN", size=1.05, halign="middle");
//   (-3, -9) @PIN(terminal=7, direction="down");
//   (-3, -8) @TEXT("VSS", size=1.05, halign="middle");
//   (-3, 9) @PIN(terminal=8, direction="up");
//   (-3, 8) @TEXT("DVDD", size=1.05, halign="middle");
//   ? @TEXT("${name}", key="name", size=0.9, bold=true) => @PLACE(-7, 11);
// };
// # @SELECT-INSTANCE(model="mq_cdac_drv3") => @SET-SYMBOL $DRAW_mq_cdac_drv3;
// $DRAW_mq_cdac_drv2 = @DEFINE-SYMBOL {
//   @LINE {(-4, 6) (5, 2) (-4, -2) (-4, 6)};
//   (5.7,2) @CIRCLE(radius=0.7);
//   @LINE {(6.4, 2) (9, 2)};
//   (0, 1) @TEXT("REF", size=1.05, halign="middle");
//   (0, -6.8) @TEXT("EN / high-Z", size=1.05, halign="middle");
//   (-8, 2) @PIN(terminal=1, direction="left");
//   @LINE {(-8, 2) (-5, 2)};
//   (-4.8, 2) @TEXT("HIB", size=1.05, halign="start", valign="middle");
//   (-8, -2) @PIN(terminal=2, direction="left");
//   @LINE {(-8, -2) (-5, -2)};
//   (-4.8, -2) @TEXT("EN", size=1.05, halign="start", valign="middle");
//   (-8, -5) @PIN(terminal=3, direction="left");
//   @LINE {(-8, -5) (-5, -5)};
//   (-4.8, -5) @TEXT("ENB", size=1.05, halign="start", valign="middle");
//   (9, 2) @PIN(terminal=4, direction="right");
//   (9, 1) @TEXT("BP", size=1.05, halign="middle");
//   (3, 9) @PIN(terminal=5, direction="up");
//   (3, 8) @TEXT("VREFP", size=1.05, halign="middle");
//   (3, -9) @PIN(terminal=6, direction="down");
//   (3, -8) @TEXT("VREFN", size=1.05, halign="middle");
//   (-3, -9) @PIN(terminal=7, direction="down");
//   (-3, -8) @TEXT("VSS", size=1.05, halign="middle");
//   (-3, 9) @PIN(terminal=8, direction="up");
//   (-3, 8) @TEXT("DVDD", size=1.05, halign="middle");
//   ? @TEXT("${name}", key="name", size=0.9, bold=true) => @PLACE(-7, 11);
// };
// # @SELECT-INSTANCE(model="mq_cdac_drv2") => @SET-SYMBOL $DRAW_mq_cdac_drv2;
// $DRAW_mq_cdac_drv1 = @DEFINE-SYMBOL {
//   @LINE {(-4, 6) (5, 2) (-4, -2) (-4, 6)};
//   (5.7,2) @CIRCLE(radius=0.7);
//   @LINE {(6.4, 2) (9, 2)};
//   (0, 1) @TEXT("REF", size=1.05, halign="middle");
//   (0, -6.8) @TEXT("EN / high-Z", size=1.05, halign="middle");
//   (-8, 2) @PIN(terminal=1, direction="left");
//   @LINE {(-8, 2) (-5, 2)};
//   (-4.8, 2) @TEXT("HIB", size=1.05, halign="start", valign="middle");
//   (-8, -2) @PIN(terminal=2, direction="left");
//   @LINE {(-8, -2) (-5, -2)};
//   (-4.8, -2) @TEXT("EN", size=1.05, halign="start", valign="middle");
//   (-8, -5) @PIN(terminal=3, direction="left");
//   @LINE {(-8, -5) (-5, -5)};
//   (-4.8, -5) @TEXT("ENB", size=1.05, halign="start", valign="middle");
//   (9, 2) @PIN(terminal=4, direction="right");
//   (9, 1) @TEXT("BP", size=1.05, halign="middle");
//   (3, 9) @PIN(terminal=5, direction="up");
//   (3, 8) @TEXT("VREFP", size=1.05, halign="middle");
//   (3, -9) @PIN(terminal=6, direction="down");
//   (3, -8) @TEXT("VREFN", size=1.05, halign="middle");
//   (-3, -9) @PIN(terminal=7, direction="down");
//   (-3, -8) @TEXT("VSS", size=1.05, halign="middle");
//   (-3, 9) @PIN(terminal=8, direction="up");
//   (-3, 8) @TEXT("DVDD", size=1.05, halign="middle");
//   ? @TEXT("${name}", key="name", size=0.9, bold=true) => @PLACE(-7, 11);
// };
// # @SELECT-INSTANCE(model="mq_cdac_drv1") => @SET-SYMBOL $DRAW_mq_cdac_drv1;
// $DRAW_mq_cdac_drv0 = @DEFINE-SYMBOL {
//   @LINE {(-4, 6) (5, 2) (-4, -2) (-4, 6)};
//   (5.7,2) @CIRCLE(radius=0.7);
//   @LINE {(6.4, 2) (9, 2)};
//   (0, 1) @TEXT("REF", size=1.05, halign="middle");
//   (0, -6.8) @TEXT("EN / high-Z", size=1.05, halign="middle");
//   (-8, 2) @PIN(terminal=1, direction="left");
//   @LINE {(-8, 2) (-5, 2)};
//   (-4.8, 2) @TEXT("HIB", size=1.05, halign="start", valign="middle");
//   (-8, -2) @PIN(terminal=2, direction="left");
//   @LINE {(-8, -2) (-5, -2)};
//   (-4.8, -2) @TEXT("EN", size=1.05, halign="start", valign="middle");
//   (-8, -5) @PIN(terminal=3, direction="left");
//   @LINE {(-8, -5) (-5, -5)};
//   (-4.8, -5) @TEXT("ENB", size=1.05, halign="start", valign="middle");
//   (9, 2) @PIN(terminal=4, direction="right");
//   (9, 1) @TEXT("BP", size=1.05, halign="middle");
//   (3, 9) @PIN(terminal=5, direction="up");
//   (3, 8) @TEXT("VREFP", size=1.05, halign="middle");
//   (3, -9) @PIN(terminal=6, direction="down");
//   (3, -8) @TEXT("VREFN", size=1.05, halign="middle");
//   (-3, -9) @PIN(terminal=7, direction="down");
//   (-3, -8) @TEXT("VSS", size=1.05, halign="middle");
//   (-3, 9) @PIN(terminal=8, direction="up");
//   (-3, 8) @TEXT("DVDD", size=1.05, halign="middle");
//   ? @TEXT("${name}", key="name", size=0.9, bold=true) => @PLACE(-7, 11);
// };
// # @SELECT-INSTANCE(model="mq_cdac_drv0") => @SET-SYMBOL $DRAW_mq_cdac_drv0;
// $DRAW_mq_cdac_assist_pulse = @DEFINE-SYMBOL {
//   @LINE {(-12, 4) (-5, 4) (-5, 7) (-1, 7) (-1, 4) (2, 4)};
//   @LINE {(-12, -4) (2, -4)};
//   @LINE {(2, 5) (8, 0) (2, -5) (2, 5)};
//   @LINE {(8, 0) (12, 0)};
//   (0, -8) @TEXT("delayed assist pulse", size=1.05, halign="middle");
//   @LINE {(-5, 11) (-5, 9)};
//   @LINE {(5, 11) (5, 9)};
//   @LINE {(-5, -11) (-5, -9)};
//   @LINE {(5, -11) (5, -9)};
//   (-12, 4) @PIN(terminal=1, direction="left");
//   (-12, -4) @PIN(terminal=2, direction="left");
//   (12, 0) @PIN(terminal=3, direction="right");
//   (-5, 11) @PIN(terminal=4, direction="up");
//   (5, 11) @PIN(terminal=7, direction="up");
//   (-5, -11) @PIN(terminal=5, direction="down");
//   (5, -11) @PIN(terminal=6, direction="down");
//   ? @TEXT("${name}", key="name", size=0.9, bold=true) => @PLACE(-7, 11);
// };
// # @SELECT-INSTANCE(model="mq_cdac_assist_pulse") => @SET-SYMBOL $DRAW_mq_cdac_assist_pulse;
// $DRAW_mq_cdac_sw0 = @DEFINE-SYMBOL {
//   @LINE {(-14, -18) (14, -18) (14, 18) (-14, 18) (-14, -18)};
//   (0, 13) @TEXT("bit 0", size=1.5, halign="middle", bold=true);
//   @LINE {(-9, 8) (-4, 6) (-9, 4) (-9, 8)};
//   @LINE {(-4, 6) (0, 6)};
//   @LINE {(0, 6) (4, 8)};
//   @LINE {(5, 6) (11, 6)};
//   @LINE {(-9, -4) (-4, -6) (-9, -8) (-9, -4)};
//   @LINE {(-4, -6) (0, -6)};
//   @LINE {(0, -6) (4, -4)};
//   @LINE {(5, -6) (11, -6)};
//   (0, -14) @TEXT("SW + drivers", size=1.1, halign="middle");
//   @LINE {(-18, 14) (-14, 14)};
//   (-18, 14) @PIN(terminal=1, direction="left");
//   @LINE {(-18, 11) (-14, 11)};
//   (-18, 11) @PIN(terminal=2, direction="left");
//   @LINE {(-18, 8) (-14, 8)};
//   (-18, 8) @PIN(terminal=3, direction="left");
//   @LINE {(-18, 5) (-14, 5)};
//   (-18, 5) @PIN(terminal=4, direction="left");
//   @LINE {(-18, 2) (-14, 2)};
//   (-18, 2) @PIN(terminal=5, direction="left");
//   @LINE {(-18, -1) (-14, -1)};
//   (-18, -1) @PIN(terminal=6, direction="left");
//   @LINE {(-18, -4) (-14, -4)};
//   (-18, -4) @PIN(terminal=10, direction="left");
//   @LINE {(-18, -7) (-14, -7)};
//   (-18, -7) @PIN(terminal=12, direction="left");
//   @LINE {(-18, -10) (-14, -10)};
//   (-18, -10) @PIN(terminal=13, direction="left");
//   @LINE {(-18, -13) (-14, -13)};
//   (-18, -13) @PIN(terminal=14, direction="left");
//   @LINE {(-18, -16) (-14, -16)};
//   (-18, -16) @PIN(terminal=15, direction="left");
//   @LINE {(18, 8) (14, 8)};
//   (18, 8) @PIN(terminal=16, direction="right");
//   @LINE {(18, -8) (14, -8)};
//   (18, -8) @PIN(terminal=17, direction="right");
//   @LINE {(18, 3) (14, 3)};
//   (18, 3) @PIN(terminal=18, direction="right");
//   @LINE {(18, -3) (14, -3)};
//   (18, -3) @PIN(terminal=19, direction="right");
//   @LINE {(-6, 21) (-6, 18)};
//   (-6, 21) @PIN(terminal=11, direction="left");
//   @LINE {(6, 21) (6, 18)};
//   (6, 21) @PIN(terminal=7, direction="right");
//   @LINE {(-6, -21) (-6, -18)};
//   (-6, -21) @PIN(terminal=8, direction="left");
//   @LINE {(6, -21) (6, -18)};
//   (6, -21) @PIN(terminal=9, direction="right");
// };
// # @SELECT-INSTANCE(model="mq_cdac_sw0") => @SET-SYMBOL $DRAW_mq_cdac_sw0;
// $DRAW_mq_cdac_sw1 = @DEFINE-SYMBOL {
//   @LINE {(-14, -18) (14, -18) (14, 18) (-14, 18) (-14, -18)};
//   (0, 13) @TEXT("bit 1", size=1.5, halign="middle", bold=true);
//   @LINE {(-9, 8) (-4, 6) (-9, 4) (-9, 8)};
//   @LINE {(-4, 6) (0, 6)};
//   @LINE {(0, 6) (4, 8)};
//   @LINE {(5, 6) (11, 6)};
//   @LINE {(-9, -4) (-4, -6) (-9, -8) (-9, -4)};
//   @LINE {(-4, -6) (0, -6)};
//   @LINE {(0, -6) (4, -4)};
//   @LINE {(5, -6) (11, -6)};
//   (0, -14) @TEXT("SW + drivers", size=1.1, halign="middle");
//   @LINE {(-18, 14) (-14, 14)};
//   (-18, 14) @PIN(terminal=1, direction="left");
//   @LINE {(-18, 11) (-14, 11)};
//   (-18, 11) @PIN(terminal=2, direction="left");
//   @LINE {(-18, 8) (-14, 8)};
//   (-18, 8) @PIN(terminal=3, direction="left");
//   @LINE {(-18, 5) (-14, 5)};
//   (-18, 5) @PIN(terminal=4, direction="left");
//   @LINE {(-18, 2) (-14, 2)};
//   (-18, 2) @PIN(terminal=5, direction="left");
//   @LINE {(-18, -1) (-14, -1)};
//   (-18, -1) @PIN(terminal=6, direction="left");
//   @LINE {(-18, -4) (-14, -4)};
//   (-18, -4) @PIN(terminal=11, direction="left");
//   @LINE {(-18, -7) (-14, -7)};
//   (-18, -7) @PIN(terminal=12, direction="left");
//   @LINE {(-18, -10) (-14, -10)};
//   (-18, -10) @PIN(terminal=13, direction="left");
//   @LINE {(18, 8) (14, 8)};
//   (18, 8) @PIN(terminal=14, direction="right");
//   @LINE {(18, -8) (14, -8)};
//   (18, -8) @PIN(terminal=15, direction="right");
//   @LINE {(-6, 21) (-6, 18)};
//   (-6, 21) @PIN(terminal=10, direction="left");
//   @LINE {(6, 21) (6, 18)};
//   (6, 21) @PIN(terminal=7, direction="right");
//   @LINE {(-6, -21) (-6, -18)};
//   (-6, -21) @PIN(terminal=8, direction="left");
//   @LINE {(6, -21) (6, -18)};
//   (6, -21) @PIN(terminal=9, direction="right");
// };
// # @SELECT-INSTANCE(model="mq_cdac_sw1") => @SET-SYMBOL $DRAW_mq_cdac_sw1;
// $DRAW_mq_cdac_sw2 = @DEFINE-SYMBOL {
//   @LINE {(-14, -18) (14, -18) (14, 18) (-14, 18) (-14, -18)};
//   (0, 13) @TEXT("bit 2", size=1.5, halign="middle", bold=true);
//   @LINE {(-9, 8) (-4, 6) (-9, 4) (-9, 8)};
//   @LINE {(-4, 6) (0, 6)};
//   @LINE {(0, 6) (4, 8)};
//   @LINE {(5, 6) (11, 6)};
//   @LINE {(-9, -4) (-4, -6) (-9, -8) (-9, -4)};
//   @LINE {(-4, -6) (0, -6)};
//   @LINE {(0, -6) (4, -4)};
//   @LINE {(5, -6) (11, -6)};
//   (0, -14) @TEXT("SW + drivers", size=1.1, halign="middle");
//   @LINE {(-18, 14) (-14, 14)};
//   (-18, 14) @PIN(terminal=1, direction="left");
//   @LINE {(-18, 11) (-14, 11)};
//   (-18, 11) @PIN(terminal=2, direction="left");
//   @LINE {(-18, 8) (-14, 8)};
//   (-18, 8) @PIN(terminal=3, direction="left");
//   @LINE {(-18, 5) (-14, 5)};
//   (-18, 5) @PIN(terminal=4, direction="left");
//   @LINE {(-18, 2) (-14, 2)};
//   (-18, 2) @PIN(terminal=5, direction="left");
//   @LINE {(-18, -1) (-14, -1)};
//   (-18, -1) @PIN(terminal=6, direction="left");
//   @LINE {(-18, -4) (-14, -4)};
//   (-18, -4) @PIN(terminal=10, direction="left");
//   @LINE {(-18, -7) (-14, -7)};
//   (-18, -7) @PIN(terminal=12, direction="left");
//   @LINE {(-18, -10) (-14, -10)};
//   (-18, -10) @PIN(terminal=13, direction="left");
//   @LINE {(-18, -13) (-14, -13)};
//   (-18, -13) @PIN(terminal=14, direction="left");
//   @LINE {(-18, -16) (-14, -16)};
//   (-18, -16) @PIN(terminal=15, direction="left");
//   @LINE {(18, 8) (14, 8)};
//   (18, 8) @PIN(terminal=16, direction="right");
//   @LINE {(18, -8) (14, -8)};
//   (18, -8) @PIN(terminal=17, direction="right");
//   @LINE {(18, 3) (14, 3)};
//   (18, 3) @PIN(terminal=18, direction="right");
//   @LINE {(18, -3) (14, -3)};
//   (18, -3) @PIN(terminal=19, direction="right");
//   @LINE {(-6, 21) (-6, 18)};
//   (-6, 21) @PIN(terminal=11, direction="left");
//   @LINE {(6, 21) (6, 18)};
//   (6, 21) @PIN(terminal=7, direction="right");
//   @LINE {(-6, -21) (-6, -18)};
//   (-6, -21) @PIN(terminal=8, direction="left");
//   @LINE {(6, -21) (6, -18)};
//   (6, -21) @PIN(terminal=9, direction="right");
// };
// # @SELECT-INSTANCE(model="mq_cdac_sw2") => @SET-SYMBOL $DRAW_mq_cdac_sw2;
// $DRAW_mq_cdac_sw3 = @DEFINE-SYMBOL {
//   @LINE {(-14, -18) (14, -18) (14, 18) (-14, 18) (-14, -18)};
//   (0, 13) @TEXT("bit 3", size=1.5, halign="middle", bold=true);
//   @LINE {(-9, 8) (-4, 6) (-9, 4) (-9, 8)};
//   @LINE {(-4, 6) (0, 6)};
//   @LINE {(0, 6) (4, 8)};
//   @LINE {(5, 6) (11, 6)};
//   @LINE {(-9, -4) (-4, -6) (-9, -8) (-9, -4)};
//   @LINE {(-4, -6) (0, -6)};
//   @LINE {(0, -6) (4, -4)};
//   @LINE {(5, -6) (11, -6)};
//   (0, -14) @TEXT("SW + drivers", size=1.1, halign="middle");
//   @LINE {(-18, 14) (-14, 14)};
//   (-18, 14) @PIN(terminal=1, direction="left");
//   @LINE {(-18, 11) (-14, 11)};
//   (-18, 11) @PIN(terminal=2, direction="left");
//   @LINE {(-18, 8) (-14, 8)};
//   (-18, 8) @PIN(terminal=3, direction="left");
//   @LINE {(-18, 5) (-14, 5)};
//   (-18, 5) @PIN(terminal=4, direction="left");
//   @LINE {(-18, 2) (-14, 2)};
//   (-18, 2) @PIN(terminal=5, direction="left");
//   @LINE {(-18, -1) (-14, -1)};
//   (-18, -1) @PIN(terminal=6, direction="left");
//   @LINE {(-18, -4) (-14, -4)};
//   (-18, -4) @PIN(terminal=11, direction="left");
//   @LINE {(-18, -7) (-14, -7)};
//   (-18, -7) @PIN(terminal=12, direction="left");
//   @LINE {(-18, -10) (-14, -10)};
//   (-18, -10) @PIN(terminal=13, direction="left");
//   @LINE {(18, 8) (14, 8)};
//   (18, 8) @PIN(terminal=14, direction="right");
//   @LINE {(18, -8) (14, -8)};
//   (18, -8) @PIN(terminal=15, direction="right");
//   @LINE {(-6, 21) (-6, 18)};
//   (-6, 21) @PIN(terminal=10, direction="left");
//   @LINE {(6, 21) (6, 18)};
//   (6, 21) @PIN(terminal=7, direction="right");
//   @LINE {(-6, -21) (-6, -18)};
//   (-6, -21) @PIN(terminal=8, direction="left");
//   @LINE {(6, -21) (6, -18)};
//   (6, -21) @PIN(terminal=9, direction="right");
// };
// # @SELECT-INSTANCE(model="mq_cdac_sw3") => @SET-SYMBOL $DRAW_mq_cdac_sw3;
// $DRAW_mq_cdac_sw4 = @DEFINE-SYMBOL {
//   @LINE {(-14, -18) (14, -18) (14, 18) (-14, 18) (-14, -18)};
//   (0, 13) @TEXT("bit 4", size=1.5, halign="middle", bold=true);
//   @LINE {(-9, 8) (-4, 6) (-9, 4) (-9, 8)};
//   @LINE {(-4, 6) (0, 6)};
//   @LINE {(0, 6) (4, 8)};
//   @LINE {(5, 6) (11, 6)};
//   @LINE {(-9, -4) (-4, -6) (-9, -8) (-9, -4)};
//   @LINE {(-4, -6) (0, -6)};
//   @LINE {(0, -6) (4, -4)};
//   @LINE {(5, -6) (11, -6)};
//   (0, -14) @TEXT("SW + drivers", size=1.1, halign="middle");
//   @LINE {(-18, 14) (-14, 14)};
//   (-18, 14) @PIN(terminal=1, direction="left");
//   @LINE {(-18, 11) (-14, 11)};
//   (-18, 11) @PIN(terminal=2, direction="left");
//   @LINE {(-18, 8) (-14, 8)};
//   (-18, 8) @PIN(terminal=3, direction="left");
//   @LINE {(-18, 5) (-14, 5)};
//   (-18, 5) @PIN(terminal=4, direction="left");
//   @LINE {(-18, 2) (-14, 2)};
//   (-18, 2) @PIN(terminal=5, direction="left");
//   @LINE {(-18, -1) (-14, -1)};
//   (-18, -1) @PIN(terminal=6, direction="left");
//   @LINE {(-18, -4) (-14, -4)};
//   (-18, -4) @PIN(terminal=11, direction="left");
//   @LINE {(-18, -7) (-14, -7)};
//   (-18, -7) @PIN(terminal=12, direction="left");
//   @LINE {(-18, -10) (-14, -10)};
//   (-18, -10) @PIN(terminal=13, direction="left");
//   @LINE {(18, 8) (14, 8)};
//   (18, 8) @PIN(terminal=14, direction="right");
//   @LINE {(18, -8) (14, -8)};
//   (18, -8) @PIN(terminal=15, direction="right");
//   @LINE {(-6, 21) (-6, 18)};
//   (-6, 21) @PIN(terminal=10, direction="left");
//   @LINE {(6, 21) (6, 18)};
//   (6, 21) @PIN(terminal=7, direction="right");
//   @LINE {(-6, -21) (-6, -18)};
//   (-6, -21) @PIN(terminal=8, direction="left");
//   @LINE {(6, -21) (6, -18)};
//   (6, -21) @PIN(terminal=9, direction="right");
// };
// # @SELECT-INSTANCE(model="mq_cdac_sw4") => @SET-SYMBOL $DRAW_mq_cdac_sw4;
// $DRAW_mq_cdac_sw5 = @DEFINE-SYMBOL {
//   @LINE {(-14, -18) (14, -18) (14, 18) (-14, 18) (-14, -18)};
//   (0, 13) @TEXT("bit 5", size=1.5, halign="middle", bold=true);
//   @LINE {(-9, 8) (-4, 6) (-9, 4) (-9, 8)};
//   @LINE {(-4, 6) (0, 6)};
//   @LINE {(0, 6) (4, 8)};
//   @LINE {(5, 6) (11, 6)};
//   @LINE {(-9, -4) (-4, -6) (-9, -8) (-9, -4)};
//   @LINE {(-4, -6) (0, -6)};
//   @LINE {(0, -6) (4, -4)};
//   @LINE {(5, -6) (11, -6)};
//   (0, -14) @TEXT("SW + drivers", size=1.1, halign="middle");
//   @LINE {(-18, 14) (-14, 14)};
//   (-18, 14) @PIN(terminal=1, direction="left");
//   @LINE {(-18, 11) (-14, 11)};
//   (-18, 11) @PIN(terminal=2, direction="left");
//   @LINE {(-18, 8) (-14, 8)};
//   (-18, 8) @PIN(terminal=3, direction="left");
//   @LINE {(-18, 5) (-14, 5)};
//   (-18, 5) @PIN(terminal=4, direction="left");
//   @LINE {(-18, 2) (-14, 2)};
//   (-18, 2) @PIN(terminal=5, direction="left");
//   @LINE {(-18, -1) (-14, -1)};
//   (-18, -1) @PIN(terminal=6, direction="left");
//   @LINE {(-18, -4) (-14, -4)};
//   (-18, -4) @PIN(terminal=11, direction="left");
//   @LINE {(-18, -7) (-14, -7)};
//   (-18, -7) @PIN(terminal=12, direction="left");
//   @LINE {(-18, -10) (-14, -10)};
//   (-18, -10) @PIN(terminal=13, direction="left");
//   @LINE {(18, 8) (14, 8)};
//   (18, 8) @PIN(terminal=14, direction="right");
//   @LINE {(18, -8) (14, -8)};
//   (18, -8) @PIN(terminal=15, direction="right");
//   @LINE {(-6, 21) (-6, 18)};
//   (-6, 21) @PIN(terminal=10, direction="left");
//   @LINE {(6, 21) (6, 18)};
//   (6, 21) @PIN(terminal=7, direction="right");
//   @LINE {(-6, -21) (-6, -18)};
//   (-6, -21) @PIN(terminal=8, direction="left");
//   @LINE {(6, -21) (6, -18)};
//   (6, -21) @PIN(terminal=9, direction="right");
// };
// # @SELECT-INSTANCE(model="mq_cdac_sw5") => @SET-SYMBOL $DRAW_mq_cdac_sw5;
// $DRAW_mq_cdac_sw6 = @DEFINE-SYMBOL {
//   @LINE {(-14, -18) (14, -18) (14, 18) (-14, 18) (-14, -18)};
//   (0, 13) @TEXT("bit 6", size=1.5, halign="middle", bold=true);
//   @LINE {(-9, 8) (-4, 6) (-9, 4) (-9, 8)};
//   @LINE {(-4, 6) (0, 6)};
//   @LINE {(0, 6) (4, 8)};
//   @LINE {(5, 6) (11, 6)};
//   @LINE {(-9, -4) (-4, -6) (-9, -8) (-9, -4)};
//   @LINE {(-4, -6) (0, -6)};
//   @LINE {(0, -6) (4, -4)};
//   @LINE {(5, -6) (11, -6)};
//   (0, -14) @TEXT("SW + drivers", size=1.1, halign="middle");
//   @LINE {(-18, 14) (-14, 14)};
//   (-18, 14) @PIN(terminal=1, direction="left");
//   @LINE {(-18, 11) (-14, 11)};
//   (-18, 11) @PIN(terminal=2, direction="left");
//   @LINE {(-18, 8) (-14, 8)};
//   (-18, 8) @PIN(terminal=3, direction="left");
//   @LINE {(-18, 5) (-14, 5)};
//   (-18, 5) @PIN(terminal=4, direction="left");
//   @LINE {(18, 8) (14, 8)};
//   (18, 8) @PIN(terminal=9, direction="right");
//   @LINE {(18, -8) (14, -8)};
//   (18, -8) @PIN(terminal=10, direction="right");
//   @LINE {(-6, 21) (-6, 18)};
//   (-6, 21) @PIN(terminal=8, direction="left");
//   @LINE {(6, 21) (6, 18)};
//   (6, 21) @PIN(terminal=5, direction="right");
//   @LINE {(-6, -21) (-6, -18)};
//   (-6, -21) @PIN(terminal=6, direction="left");
//   @LINE {(6, -21) (6, -18)};
//   (6, -21) @PIN(terminal=7, direction="right");
// };
// # @SELECT-INSTANCE(model="mq_cdac_sw6") => @SET-SYMBOL $DRAW_mq_cdac_sw6;
// $DRAW_mq_cdac_sw7 = @DEFINE-SYMBOL {
//   @LINE {(-14, -18) (14, -18) (14, 18) (-14, 18) (-14, -18)};
//   (0, 13) @TEXT("bit 7", size=1.5, halign="middle", bold=true);
//   @LINE {(-9, 8) (-4, 6) (-9, 4) (-9, 8)};
//   @LINE {(-4, 6) (0, 6)};
//   @LINE {(0, 6) (4, 8)};
//   @LINE {(5, 6) (11, 6)};
//   @LINE {(-9, -4) (-4, -6) (-9, -8) (-9, -4)};
//   @LINE {(-4, -6) (0, -6)};
//   @LINE {(0, -6) (4, -4)};
//   @LINE {(5, -6) (11, -6)};
//   (0, -14) @TEXT("SW + drivers", size=1.1, halign="middle");
//   @LINE {(-18, 14) (-14, 14)};
//   (-18, 14) @PIN(terminal=1, direction="left");
//   @LINE {(-18, 11) (-14, 11)};
//   (-18, 11) @PIN(terminal=2, direction="left");
//   @LINE {(-18, 8) (-14, 8)};
//   (-18, 8) @PIN(terminal=3, direction="left");
//   @LINE {(-18, 5) (-14, 5)};
//   (-18, 5) @PIN(terminal=4, direction="left");
//   @LINE {(-18, 2) (-14, 2)};
//   (-18, 2) @PIN(terminal=5, direction="left");
//   @LINE {(-18, -1) (-14, -1)};
//   (-18, -1) @PIN(terminal=6, direction="left");
//   @LINE {(-18, -4) (-14, -4)};
//   (-18, -4) @PIN(terminal=10, direction="left");
//   @LINE {(-18, -7) (-14, -7)};
//   (-18, -7) @PIN(terminal=12, direction="left");
//   @LINE {(-18, -10) (-14, -10)};
//   (-18, -10) @PIN(terminal=13, direction="left");
//   @LINE {(-18, -13) (-14, -13)};
//   (-18, -13) @PIN(terminal=14, direction="left");
//   @LINE {(-18, -16) (-14, -16)};
//   (-18, -16) @PIN(terminal=15, direction="left");
//   @LINE {(18, 8) (14, 8)};
//   (18, 8) @PIN(terminal=16, direction="right");
//   @LINE {(18, -8) (14, -8)};
//   (18, -8) @PIN(terminal=17, direction="right");
//   @LINE {(18, 3) (14, 3)};
//   (18, 3) @PIN(terminal=18, direction="right");
//   @LINE {(18, -3) (14, -3)};
//   (18, -3) @PIN(terminal=19, direction="right");
//   @LINE {(-6, 21) (-6, 18)};
//   (-6, 21) @PIN(terminal=11, direction="left");
//   @LINE {(6, 21) (6, 18)};
//   (6, 21) @PIN(terminal=7, direction="right");
//   @LINE {(-6, -21) (-6, -18)};
//   (-6, -21) @PIN(terminal=8, direction="left");
//   @LINE {(6, -21) (6, -18)};
//   (6, -21) @PIN(terminal=9, direction="right");
// };
// # @SELECT-INSTANCE(model="mq_cdac_sw7") => @SET-SYMBOL $DRAW_mq_cdac_sw7;
// $DRAW_mq_cdac_sw8 = @DEFINE-SYMBOL {
//   @LINE {(-14, -18) (14, -18) (14, 18) (-14, 18) (-14, -18)};
//   (0, 13) @TEXT("bit 8", size=1.5, halign="middle", bold=true);
//   @LINE {(-9, 8) (-4, 6) (-9, 4) (-9, 8)};
//   @LINE {(-4, 6) (0, 6)};
//   @LINE {(0, 6) (4, 8)};
//   @LINE {(5, 6) (11, 6)};
//   @LINE {(-9, -4) (-4, -6) (-9, -8) (-9, -4)};
//   @LINE {(-4, -6) (0, -6)};
//   @LINE {(0, -6) (4, -4)};
//   @LINE {(5, -6) (11, -6)};
//   (0, -14) @TEXT("SW + drivers", size=1.1, halign="middle");
//   @LINE {(-18, 14) (-14, 14)};
//   (-18, 14) @PIN(terminal=1, direction="left");
//   @LINE {(-18, 11) (-14, 11)};
//   (-18, 11) @PIN(terminal=2, direction="left");
//   @LINE {(-18, 8) (-14, 8)};
//   (-18, 8) @PIN(terminal=3, direction="left");
//   @LINE {(-18, 5) (-14, 5)};
//   (-18, 5) @PIN(terminal=4, direction="left");
//   @LINE {(-18, 2) (-14, 2)};
//   (-18, 2) @PIN(terminal=5, direction="left");
//   @LINE {(-18, -1) (-14, -1)};
//   (-18, -1) @PIN(terminal=6, direction="left");
//   @LINE {(-18, -4) (-14, -4)};
//   (-18, -4) @PIN(terminal=11, direction="left");
//   @LINE {(-18, -7) (-14, -7)};
//   (-18, -7) @PIN(terminal=12, direction="left");
//   @LINE {(-18, -10) (-14, -10)};
//   (-18, -10) @PIN(terminal=13, direction="left");
//   @LINE {(18, 8) (14, 8)};
//   (18, 8) @PIN(terminal=14, direction="right");
//   @LINE {(18, -8) (14, -8)};
//   (18, -8) @PIN(terminal=15, direction="right");
//   @LINE {(-6, 21) (-6, 18)};
//   (-6, 21) @PIN(terminal=10, direction="left");
//   @LINE {(6, 21) (6, 18)};
//   (6, 21) @PIN(terminal=7, direction="right");
//   @LINE {(-6, -21) (-6, -18)};
//   (-6, -21) @PIN(terminal=8, direction="left");
//   @LINE {(6, -21) (6, -18)};
//   (6, -21) @PIN(terminal=9, direction="right");
// };
// # @SELECT-INSTANCE(model="mq_cdac_sw8") => @SET-SYMBOL $DRAW_mq_cdac_sw8;
// $DRAW_mq_cdac_sw9 = @DEFINE-SYMBOL {
//   @LINE {(-14, -18) (14, -18) (14, 18) (-14, 18) (-14, -18)};
//   (0, 13) @TEXT("bit 9", size=1.5, halign="middle", bold=true);
//   @LINE {(-9, 8) (-4, 6) (-9, 4) (-9, 8)};
//   @LINE {(-4, 6) (0, 6)};
//   @LINE {(0, 6) (4, 8)};
//   @LINE {(5, 6) (11, 6)};
//   @LINE {(-9, -4) (-4, -6) (-9, -8) (-9, -4)};
//   @LINE {(-4, -6) (0, -6)};
//   @LINE {(0, -6) (4, -4)};
//   @LINE {(5, -6) (11, -6)};
//   (0, -14) @TEXT("SW + drivers", size=1.1, halign="middle");
//   @LINE {(-18, 14) (-14, 14)};
//   (-18, 14) @PIN(terminal=1, direction="left");
//   @LINE {(-18, 11) (-14, 11)};
//   (-18, 11) @PIN(terminal=2, direction="left");
//   @LINE {(-18, 8) (-14, 8)};
//   (-18, 8) @PIN(terminal=3, direction="left");
//   @LINE {(-18, 5) (-14, 5)};
//   (-18, 5) @PIN(terminal=4, direction="left");
//   @LINE {(18, 8) (14, 8)};
//   (18, 8) @PIN(terminal=9, direction="right");
//   @LINE {(18, -8) (14, -8)};
//   (18, -8) @PIN(terminal=10, direction="right");
//   @LINE {(-6, 21) (-6, 18)};
//   (-6, 21) @PIN(terminal=8, direction="left");
//   @LINE {(6, 21) (6, 18)};
//   (6, 21) @PIN(terminal=5, direction="right");
//   @LINE {(-6, -21) (-6, -18)};
//   (-6, -21) @PIN(terminal=6, direction="left");
//   @LINE {(6, -21) (6, -18)};
//   (6, -21) @PIN(terminal=7, direction="right");
// };
// # @SELECT-INSTANCE(model="mq_cdac_sw9") => @SET-SYMBOL $DRAW_mq_cdac_sw9;
// $DRAW_mq_cdac_sw10 = @DEFINE-SYMBOL {
//   @LINE {(-14, -18) (14, -18) (14, 18) (-14, 18) (-14, -18)};
//   (0, 13) @TEXT("bit 10", size=1.5, halign="middle", bold=true);
//   @LINE {(-9, 8) (-4, 6) (-9, 4) (-9, 8)};
//   @LINE {(-4, 6) (0, 6)};
//   @LINE {(0, 6) (4, 8)};
//   @LINE {(5, 6) (11, 6)};
//   @LINE {(-9, -4) (-4, -6) (-9, -8) (-9, -4)};
//   @LINE {(-4, -6) (0, -6)};
//   @LINE {(0, -6) (4, -4)};
//   @LINE {(5, -6) (11, -6)};
//   (0, -14) @TEXT("SW + drivers", size=1.1, halign="middle");
//   @LINE {(-18, 14) (-14, 14)};
//   (-18, 14) @PIN(terminal=1, direction="left");
//   @LINE {(-18, 11) (-14, 11)};
//   (-18, 11) @PIN(terminal=2, direction="left");
//   @LINE {(-18, 8) (-14, 8)};
//   (-18, 8) @PIN(terminal=3, direction="left");
//   @LINE {(-18, 5) (-14, 5)};
//   (-18, 5) @PIN(terminal=4, direction="left");
//   @LINE {(-18, 2) (-14, 2)};
//   (-18, 2) @PIN(terminal=5, direction="left");
//   @LINE {(-18, -1) (-14, -1)};
//   (-18, -1) @PIN(terminal=6, direction="left");
//   @LINE {(-18, -4) (-14, -4)};
//   (-18, -4) @PIN(terminal=11, direction="left");
//   @LINE {(-18, -7) (-14, -7)};
//   (-18, -7) @PIN(terminal=12, direction="left");
//   @LINE {(-18, -10) (-14, -10)};
//   (-18, -10) @PIN(terminal=13, direction="left");
//   @LINE {(18, 8) (14, 8)};
//   (18, 8) @PIN(terminal=14, direction="right");
//   @LINE {(18, -8) (14, -8)};
//   (18, -8) @PIN(terminal=15, direction="right");
//   @LINE {(-6, 21) (-6, 18)};
//   (-6, 21) @PIN(terminal=10, direction="left");
//   @LINE {(6, 21) (6, 18)};
//   (6, 21) @PIN(terminal=7, direction="right");
//   @LINE {(-6, -21) (-6, -18)};
//   (-6, -21) @PIN(terminal=8, direction="left");
//   @LINE {(6, -21) (6, -18)};
//   (6, -21) @PIN(terminal=9, direction="right");
// };
// # @SELECT-INSTANCE(model="mq_cdac_sw10") => @SET-SYMBOL $DRAW_mq_cdac_sw10;
// $DRAW_mq_cdac_sw11 = @DEFINE-SYMBOL {
//   @LINE {(-14, -18) (14, -18) (14, 18) (-14, 18) (-14, -18)};
//   (0, 13) @TEXT("bit 11", size=1.5, halign="middle", bold=true);
//   @LINE {(-9, 8) (-4, 6) (-9, 4) (-9, 8)};
//   @LINE {(-4, 6) (0, 6)};
//   @LINE {(0, 6) (4, 8)};
//   @LINE {(5, 6) (11, 6)};
//   @LINE {(-9, -4) (-4, -6) (-9, -8) (-9, -4)};
//   @LINE {(-4, -6) (0, -6)};
//   @LINE {(0, -6) (4, -4)};
//   @LINE {(5, -6) (11, -6)};
//   (0, -14) @TEXT("SW + drivers", size=1.1, halign="middle");
//   @LINE {(-18, 14) (-14, 14)};
//   (-18, 14) @PIN(terminal=1, direction="left");
//   @LINE {(-18, 11) (-14, 11)};
//   (-18, 11) @PIN(terminal=2, direction="left");
//   @LINE {(-18, 8) (-14, 8)};
//   (-18, 8) @PIN(terminal=3, direction="left");
//   @LINE {(-18, 5) (-14, 5)};
//   (-18, 5) @PIN(terminal=4, direction="left");
//   @LINE {(-18, 2) (-14, 2)};
//   (-18, 2) @PIN(terminal=5, direction="left");
//   @LINE {(-18, -1) (-14, -1)};
//   (-18, -1) @PIN(terminal=6, direction="left");
//   @LINE {(-18, -4) (-14, -4)};
//   (-18, -4) @PIN(terminal=11, direction="left");
//   @LINE {(-18, -7) (-14, -7)};
//   (-18, -7) @PIN(terminal=12, direction="left");
//   @LINE {(-18, -10) (-14, -10)};
//   (-18, -10) @PIN(terminal=13, direction="left");
//   @LINE {(18, 8) (14, 8)};
//   (18, 8) @PIN(terminal=14, direction="right");
//   @LINE {(18, -8) (14, -8)};
//   (18, -8) @PIN(terminal=15, direction="right");
//   @LINE {(-6, 21) (-6, 18)};
//   (-6, 21) @PIN(terminal=10, direction="left");
//   @LINE {(6, 21) (6, 18)};
//   (6, 21) @PIN(terminal=7, direction="right");
//   @LINE {(-6, -21) (-6, -18)};
//   (-6, -21) @PIN(terminal=8, direction="left");
//   @LINE {(6, -21) (6, -18)};
//   (6, -21) @PIN(terminal=9, direction="right");
// };
// # @SELECT-INSTANCE(model="mq_cdac_sw11") => @SET-SYMBOL $DRAW_mq_cdac_sw11;
// $DRAW_mq_cdac_sw12 = @DEFINE-SYMBOL {
//   @LINE {(-14, -18) (14, -18) (14, 18) (-14, 18) (-14, -18)};
//   (0, 13) @TEXT("bit 12", size=1.5, halign="middle", bold=true);
//   @LINE {(-9, 8) (-4, 6) (-9, 4) (-9, 8)};
//   @LINE {(-4, 6) (0, 6)};
//   @LINE {(0, 6) (4, 8)};
//   @LINE {(5, 6) (11, 6)};
//   @LINE {(-9, -4) (-4, -6) (-9, -8) (-9, -4)};
//   @LINE {(-4, -6) (0, -6)};
//   @LINE {(0, -6) (4, -4)};
//   @LINE {(5, -6) (11, -6)};
//   (0, -14) @TEXT("SW + drivers", size=1.1, halign="middle");
//   @LINE {(-18, 14) (-14, 14)};
//   (-18, 14) @PIN(terminal=1, direction="left");
//   @LINE {(-18, 11) (-14, 11)};
//   (-18, 11) @PIN(terminal=2, direction="left");
//   @LINE {(-18, 8) (-14, 8)};
//   (-18, 8) @PIN(terminal=3, direction="left");
//   @LINE {(-18, 5) (-14, 5)};
//   (-18, 5) @PIN(terminal=4, direction="left");
//   @LINE {(-18, 2) (-14, 2)};
//   (-18, 2) @PIN(terminal=5, direction="left");
//   @LINE {(-18, -1) (-14, -1)};
//   (-18, -1) @PIN(terminal=6, direction="left");
//   @LINE {(-18, -4) (-14, -4)};
//   (-18, -4) @PIN(terminal=11, direction="left");
//   @LINE {(-18, -7) (-14, -7)};
//   (-18, -7) @PIN(terminal=12, direction="left");
//   @LINE {(-18, -10) (-14, -10)};
//   (-18, -10) @PIN(terminal=13, direction="left");
//   @LINE {(18, 8) (14, 8)};
//   (18, 8) @PIN(terminal=14, direction="right");
//   @LINE {(18, -8) (14, -8)};
//   (18, -8) @PIN(terminal=15, direction="right");
//   @LINE {(-6, 21) (-6, 18)};
//   (-6, 21) @PIN(terminal=10, direction="left");
//   @LINE {(6, 21) (6, 18)};
//   (6, 21) @PIN(terminal=7, direction="right");
//   @LINE {(-6, -21) (-6, -18)};
//   (-6, -21) @PIN(terminal=8, direction="left");
//   @LINE {(6, -21) (6, -18)};
//   (6, -21) @PIN(terminal=9, direction="right");
// };
// # @SELECT-INSTANCE(model="mq_cdac_sw12") => @SET-SYMBOL $DRAW_mq_cdac_sw12;
// $DRAW_mq_cdac_cap_array = @DEFINE-SYMBOL {
//   @LINE {(-22, -57) (22, -57) (22, 57) (-22, 57) (-22, -57)};
//   (0, 52) @TEXT("XCAP", size=2, halign="middle", bold=true);
//   (0, 44) @TEXT("MOM array", size=1.6, halign="middle");
//   (0, -49) @TEXT("36 array MOM + 36 Cp", size=1.15, halign="middle");
//   @LINE {(-8, 20) (8, 20)};
//   @LINE {(-8, 16) (8, 16)};
//   @LINE {(0, 20) (0, 27)};
//   @LINE {(0, 16) (0, 9)};
//   @LINE {(-8, 2) (8, 2)};
//   @LINE {(-8, -2) (8, -2)};
//   @LINE {(0, 2) (0, 9)};
//   @LINE {(0, -2) (0, -9)};
//   @LINE {(-8, -16) (8, -16)};
//   @LINE {(-8, -20) (8, -20)};
//   @LINE {(0, -16) (0, -9)};
//   @LINE {(0, -20) (0, -27)};
//   @LINE {(-28, 48) (-22, 48)};
//   (-28, 48) @PIN(terminal=2, direction="left");
//   @LINE {(-28, 45) (-22, 45)};
//   (-28, 45) @PIN(terminal=3, direction="left");
//   @LINE {(-28, 42) (-22, 42)};
//   (-28, 42) @PIN(terminal=4, direction="left");
//   @LINE {(-28, 39) (-22, 39)};
//   (-28, 39) @PIN(terminal=5, direction="left");
//   @LINE {(-28, 36) (-22, 36)};
//   (-28, 36) @PIN(terminal=6, direction="left");
//   @LINE {(-28, 33) (-22, 33)};
//   (-28, 33) @PIN(terminal=7, direction="left");
//   @LINE {(-28, 30) (-22, 30)};
//   (-28, 30) @PIN(terminal=8, direction="left");
//   @LINE {(-28, 27) (-22, 27)};
//   (-28, 27) @PIN(terminal=9, direction="left");
//   @LINE {(-28, 24) (-22, 24)};
//   (-28, 24) @PIN(terminal=10, direction="left");
//   @LINE {(-28, 21) (-22, 21)};
//   (-28, 21) @PIN(terminal=11, direction="left");
//   @LINE {(-28, 18) (-22, 18)};
//   (-28, 18) @PIN(terminal=12, direction="left");
//   @LINE {(-28, 15) (-22, 15)};
//   (-28, 15) @PIN(terminal=13, direction="left");
//   @LINE {(-28, 12) (-22, 12)};
//   (-28, 12) @PIN(terminal=14, direction="left");
//   @LINE {(-28, 9) (-22, 9)};
//   (-28, 9) @PIN(terminal=15, direction="left");
//   @LINE {(-28, 6) (-22, 6)};
//   (-28, 6) @PIN(terminal=16, direction="left");
//   @LINE {(-28, 3) (-22, 3)};
//   (-28, 3) @PIN(terminal=17, direction="left");
//   @LINE {(-28, 0) (-22, 0)};
//   (-28, 0) @PIN(terminal=18, direction="left");
//   @LINE {(-28, -3) (-22, -3)};
//   (-28, -3) @PIN(terminal=19, direction="left");
//   @LINE {(-28, -6) (-22, -6)};
//   (-28, -6) @PIN(terminal=20, direction="left");
//   @LINE {(-28, -9) (-22, -9)};
//   (-28, -9) @PIN(terminal=21, direction="left");
//   @LINE {(-28, -12) (-22, -12)};
//   (-28, -12) @PIN(terminal=22, direction="left");
//   @LINE {(-28, -15) (-22, -15)};
//   (-28, -15) @PIN(terminal=23, direction="left");
//   @LINE {(-28, -18) (-22, -18)};
//   (-28, -18) @PIN(terminal=24, direction="left");
//   @LINE {(-28, -21) (-22, -21)};
//   (-28, -21) @PIN(terminal=25, direction="left");
//   @LINE {(-28, -24) (-22, -24)};
//   (-28, -24) @PIN(terminal=26, direction="left");
//   @LINE {(-28, -27) (-22, -27)};
//   (-28, -27) @PIN(terminal=27, direction="left");
//   @LINE {(-28, -30) (-22, -30)};
//   (-28, -30) @PIN(terminal=28, direction="left");
//   @LINE {(-28, -33) (-22, -33)};
//   (-28, -33) @PIN(terminal=29, direction="left");
//   @LINE {(-28, -36) (-22, -36)};
//   (-28, -36) @PIN(terminal=30, direction="left");
//   @LINE {(-28, -39) (-22, -39)};
//   (-28, -39) @PIN(terminal=31, direction="left");
//   @LINE {(-28, -42) (-22, -42)};
//   (-28, -42) @PIN(terminal=32, direction="left");
//   @LINE {(-28, -45) (-22, -45)};
//   (-28, -45) @PIN(terminal=33, direction="left");
//   @LINE {(28, 32) (22, 32)};
//   (28, 32) @PIN(terminal=1, direction="right");
//   @LINE {(0, -63) (0, -57)};
//   (0, -63) @PIN(terminal=34, direction="down");
// };
// # @SELECT-INSTANCE(model="mq_cdac_cap_array") => @SET-SYMBOL $DRAW_mq_cdac_cap_array;
// $DRAW_mq_cdac_switch_array = @DEFINE-SYMBOL {
//   @LINE {(-22, -57) (22, -57) (22, 57) (-22, 57) (-22, -57)};
//   (0, 52) @TEXT("XSW", size=2, halign="middle", bold=true);
//   (0, 35) @TEXT("Bottom switches", size=1.3, halign="middle");
//   (0, 30) @TEXT("+ gate drivers", size=1.3, halign="middle");
//   @LINE {(-13, 13) (-6, 10) (-13, 7) (-13, 13)};
//   @LINE {(-6, 10) (-2, 10)};
//   @LINE {(-2, 10) (7, 14)};
//   @LINE {(8, 10) (15, 10)};
//   @LINE {(-13, -3) (-6, -6) (-13, -9) (-13, -3)};
//   @LINE {(-6, -6) (-2, -6)};
//   @LINE {(-2, -6) (7, -2)};
//   @LINE {(8, -6) (15, -6)};
//   @LINE {(-13, -19) (-6, -22) (-13, -25) (-13, -19)};
//   @LINE {(-6, -22) (-2, -22)};
//   @LINE {(-2, -22) (7, -18)};
//   @LINE {(8, -22) (15, -22)};
//   (0, -49) @TEXT("enable + assist", size=1.2, halign="middle");
//   @LINE {(28, 48) (22, 48)};
//   (28, 48) @PIN(terminal=36, direction="right");
//   @LINE {(28, 45) (22, 45)};
//   (28, 45) @PIN(terminal=37, direction="right");
//   @LINE {(28, 42) (22, 42)};
//   (28, 42) @PIN(terminal=38, direction="right");
//   @LINE {(28, 39) (22, 39)};
//   (28, 39) @PIN(terminal=39, direction="right");
//   @LINE {(28, 36) (22, 36)};
//   (28, 36) @PIN(terminal=40, direction="right");
//   @LINE {(28, 33) (22, 33)};
//   (28, 33) @PIN(terminal=41, direction="right");
//   @LINE {(28, 30) (22, 30)};
//   (28, 30) @PIN(terminal=42, direction="right");
//   @LINE {(28, 27) (22, 27)};
//   (28, 27) @PIN(terminal=43, direction="right");
//   @LINE {(28, 24) (22, 24)};
//   (28, 24) @PIN(terminal=44, direction="right");
//   @LINE {(28, 21) (22, 21)};
//   (28, 21) @PIN(terminal=45, direction="right");
//   @LINE {(28, 18) (22, 18)};
//   (28, 18) @PIN(terminal=46, direction="right");
//   @LINE {(28, 15) (22, 15)};
//   (28, 15) @PIN(terminal=47, direction="right");
//   @LINE {(28, 12) (22, 12)};
//   (28, 12) @PIN(terminal=48, direction="right");
//   @LINE {(28, 9) (22, 9)};
//   (28, 9) @PIN(terminal=49, direction="right");
//   @LINE {(28, 6) (22, 6)};
//   (28, 6) @PIN(terminal=50, direction="right");
//   @LINE {(28, 3) (22, 3)};
//   (28, 3) @PIN(terminal=51, direction="right");
//   @LINE {(28, 0) (22, 0)};
//   (28, 0) @PIN(terminal=52, direction="right");
//   @LINE {(28, -3) (22, -3)};
//   (28, -3) @PIN(terminal=53, direction="right");
//   @LINE {(28, -6) (22, -6)};
//   (28, -6) @PIN(terminal=54, direction="right");
//   @LINE {(28, -9) (22, -9)};
//   (28, -9) @PIN(terminal=55, direction="right");
//   @LINE {(28, -12) (22, -12)};
//   (28, -12) @PIN(terminal=56, direction="right");
//   @LINE {(28, -15) (22, -15)};
//   (28, -15) @PIN(terminal=57, direction="right");
//   @LINE {(28, -18) (22, -18)};
//   (28, -18) @PIN(terminal=58, direction="right");
//   @LINE {(28, -21) (22, -21)};
//   (28, -21) @PIN(terminal=59, direction="right");
//   @LINE {(28, -24) (22, -24)};
//   (28, -24) @PIN(terminal=60, direction="right");
//   @LINE {(28, -27) (22, -27)};
//   (28, -27) @PIN(terminal=61, direction="right");
//   @LINE {(28, -30) (22, -30)};
//   (28, -30) @PIN(terminal=62, direction="right");
//   @LINE {(28, -33) (22, -33)};
//   (28, -33) @PIN(terminal=63, direction="right");
//   @LINE {(28, -36) (22, -36)};
//   (28, -36) @PIN(terminal=64, direction="right");
//   @LINE {(28, -39) (22, -39)};
//   (28, -39) @PIN(terminal=65, direction="right");
//   @LINE {(28, -42) (22, -42)};
//   (28, -42) @PIN(terminal=66, direction="right");
//   @LINE {(28, -45) (22, -45)};
//   (28, -45) @PIN(terminal=67, direction="right");
//   @LINE {(-28, 48) (-22, 48)};
//   (-28, 48) @PIN(terminal=1, direction="left");
//   @LINE {(-28, 45) (-22, 45)};
//   (-28, 45) @PIN(terminal=2, direction="left");
//   @LINE {(-28, 42) (-22, 42)};
//   (-28, 42) @PIN(terminal=5, direction="left");
//   @LINE {(-28, 39) (-22, 39)};
//   (-28, 39) @PIN(terminal=6, direction="left");
//   @LINE {(-28, 36) (-22, 36)};
//   (-28, 36) @PIN(terminal=7, direction="left");
//   @LINE {(-28, 33) (-22, 33)};
//   (-28, 33) @PIN(terminal=8, direction="left");
//   @LINE {(-28, 30) (-22, 30)};
//   (-28, 30) @PIN(terminal=9, direction="left");
//   @LINE {(-28, 27) (-22, 27)};
//   (-28, 27) @PIN(terminal=10, direction="left");
//   @LINE {(-28, 24) (-22, 24)};
//   (-28, 24) @PIN(terminal=11, direction="left");
//   @LINE {(-28, 21) (-22, 21)};
//   (-28, 21) @PIN(terminal=12, direction="left");
//   @LINE {(-28, 18) (-22, 18)};
//   (-28, 18) @PIN(terminal=13, direction="left");
//   @LINE {(-28, 15) (-22, 15)};
//   (-28, 15) @PIN(terminal=14, direction="left");
//   @LINE {(-28, 12) (-22, 12)};
//   (-28, 12) @PIN(terminal=15, direction="left");
//   @LINE {(-28, 9) (-22, 9)};
//   (-28, 9) @PIN(terminal=16, direction="left");
//   @LINE {(-28, 6) (-22, 6)};
//   (-28, 6) @PIN(terminal=17, direction="left");
//   @LINE {(-28, 3) (-22, 3)};
//   (-28, 3) @PIN(terminal=18, direction="left");
//   @LINE {(-28, 0) (-22, 0)};
//   (-28, 0) @PIN(terminal=19, direction="left");
//   @LINE {(-28, -3) (-22, -3)};
//   (-28, -3) @PIN(terminal=20, direction="left");
//   @LINE {(-28, -6) (-22, -6)};
//   (-28, -6) @PIN(terminal=21, direction="left");
//   @LINE {(-28, -9) (-22, -9)};
//   (-28, -9) @PIN(terminal=22, direction="left");
//   @LINE {(-28, -12) (-22, -12)};
//   (-28, -12) @PIN(terminal=23, direction="left");
//   @LINE {(-28, -15) (-22, -15)};
//   (-28, -15) @PIN(terminal=24, direction="left");
//   @LINE {(-28, -18) (-22, -18)};
//   (-28, -18) @PIN(terminal=25, direction="left");
//   @LINE {(-28, -21) (-22, -21)};
//   (-28, -21) @PIN(terminal=26, direction="left");
//   @LINE {(-28, -24) (-22, -24)};
//   (-28, -24) @PIN(terminal=27, direction="left");
//   @LINE {(-28, -27) (-22, -27)};
//   (-28, -27) @PIN(terminal=28, direction="left");
//   @LINE {(-28, -30) (-22, -30)};
//   (-28, -30) @PIN(terminal=29, direction="left");
//   @LINE {(-28, -33) (-22, -33)};
//   (-28, -33) @PIN(terminal=30, direction="left");
//   @LINE {(-28, -36) (-22, -36)};
//   (-28, -36) @PIN(terminal=31, direction="left");
//   @LINE {(-28, -39) (-22, -39)};
//   (-28, -39) @PIN(terminal=32, direction="left");
//   @LINE {(-28, -42) (-22, -42)};
//   (-28, -42) @PIN(terminal=33, direction="left");
//   @LINE {(-10, 63) (-10, 57)};
//   (-10, 63) @PIN(terminal=34, direction="left");
//   @LINE {(10, 63) (10, 57)};
//   (10, 63) @PIN(terminal=3, direction="right");
//   @LINE {(-10, -63) (-10, -57)};
//   (-10, -63) @PIN(terminal=4, direction="left");
//   @LINE {(10, -63) (10, -57)};
//   (10, -63) @PIN(terminal=35, direction="right");
// };
// # @SELECT-INSTANCE(model="mq_cdac_switch_array") => @SET-SYMBOL $DRAW_mq_cdac_switch_array;
// }
simulator lang=spectre
subckt mq_cdac_ctl_l (IN HIB DVDD VREFN VSS)
M0N (HIB IN VREFN VSS) nch_ulvt_mac w=2e-06 l=3e-08 nf=1
M0P (HIB IN DVDD DVDD) pch_ulvt_mac w=4e-06 l=3e-08 nf=2
// @RNL {
// {&IN &HIB &DVDD &VREFN &VSS} @REMOVE-FROM $PORT_FILL_SET;
// &VSS @ADD-TO $GROUND_NET_SET;
// &VREFN @ADD-TO $GROUND_NET_SET;
// #M0N @PLACE(10, -7) => @ORIENT("R0");
// #M0N @SET-SYMBOL $NMOS;
// #M0N @TEXT("ULVT 2u", key="model", size=1.05, dx=1.5, dy=-1);
// #M0N @TEXT("M0N", key="name", size=1.1, dx=1.5, dy=1);
// #M0P @PLACE(10, 7) => @ORIENT("R0");
// #M0P @SET-SYMBOL $PMOS;
// #M0P @TEXT("ULVT 4u", key="model", size=1.05, dx=1.5, dy=-1);
// #M0P @TEXT("M0P", key="name", size=1.1, dx=1.5, dy=1);
// %j1 = (10, 0);
// %j2 = (5, 0);
// &HIB @WIRE {#M0N:1 %j1 #M0P:1};
// &IN @WIRE {#M0N:2 (5, -7) %j2 (5, 7) #M0P:2};
// &IN @WIRE {%j2 (-2, 0)};
// &HIB @WIRE {%j1 (18, 0)};
// (-2, 1) @TEXT("IN", size=1.05);
// (18, 1) @TEXT("HIB", size=1.05);
// %t3 = $GROUND @ATTACH &VREFN => @PLACE(10, -11);
// &VREFN @WIRE {#M0N:3 %t3:p};
// %t4 = $SUPPLY @ATTACH &DVDD => @PLACE(10, 11);
// &DVDD @WIRE {#M0P:3 %t4:p};
// $JUNCTION @ATTACH %j1;
// $JUNCTION @ATTACH %j2;
// (-5, 19) @TEXT("V29 diagnostic only / NOT qualified | low command: HIB = NOT IN", size=1.4, bold=true, textcolor="#17365d");
// (-5, 16.6) @TEXT("Drawing only | N bulk = VSS; L = 30 nm. P bulk DVDD: M0P", size=1.05, textcolor="#52606d");
// }
ends mq_cdac_ctl_l

subckt mq_cdac_ctl_h (IN HIB DVDD VREFN VSS)
M0N (I0 IN VREFN VSS) nch_ulvt_mac w=4e-07 l=3e-08 nf=1
M0P (I0 IN DVDD DVDD) pch_mac w=8e-07 l=3e-08 nf=1
M1N (HIB I0 VREFN VSS) nch_ulvt_mac w=2.4e-05 l=3e-08 nf=12
M1P (HIB I0 DVDD DVDD) pch_ulvt_mac w=1.6e-05 l=3e-08 nf=8
// @RNL {
// {&IN &HIB &DVDD &VREFN &VSS} @REMOVE-FROM $PORT_FILL_SET;
// &VSS @ADD-TO $GROUND_NET_SET;
// &VREFN @ADD-TO $GROUND_NET_SET;
// #M0N @PLACE(10, -7) => @ORIENT("R0");
// #M0N @SET-SYMBOL $NMOS;
// #M0N @TEXT("ULVT 0.4u", key="model", size=1.05, dx=1.5, dy=-1);
// #M0N @TEXT("M0N", key="name", size=1.1, dx=1.5, dy=1);
// #M0P @PLACE(10, 7) => @ORIENT("R0");
// #M0P @SET-SYMBOL $PMOS;
// #M0P @TEXT("SVT 0.8u", key="model", size=1.05, dx=1.5, dy=-1);
// #M0P @TEXT("M0P", key="name", size=1.1, dx=1.5, dy=1);
// %j1 = (10, 0);
// %j2 = (5, 0);
// &I0 @WIRE {#M0N:1 %j1 #M0P:1};
// &IN @WIRE {#M0N:2 (5, -7) %j2 (5, 7) #M0P:2};
// #M1N @PLACE(34, -7) => @ORIENT("R0");
// #M1N @SET-SYMBOL $NMOS;
// #M1N @TEXT("ULVT 24u", key="model", size=1.05, dx=1.5, dy=-1);
// #M1N @TEXT("M1N", key="name", size=1.1, dx=1.5, dy=1);
// #M1P @PLACE(34, 7) => @ORIENT("R0");
// #M1P @SET-SYMBOL $PMOS;
// #M1P @TEXT("ULVT 16u", key="model", size=1.05, dx=1.5, dy=-1);
// #M1P @TEXT("M1P", key="name", size=1.1, dx=1.5, dy=1);
// %j3 = (34, 0);
// %j4 = (29, 0);
// &HIB @WIRE {#M1N:1 %j3 #M1P:1};
// &I0 @WIRE {#M1N:2 (29, -7) %j4 (29, 7) #M1P:2};
// &I0 @WIRE {%j1 %j4};
// &IN @WIRE {%j2 (-2, 0)};
// (-2, 1) @TEXT("IN", size=1.05);
// &HIB @WIRE {%j3 (42, 0)};
// (42, 1) @TEXT("HIB", size=1.05);
// %t5 = $GROUND @ATTACH &VREFN => @PLACE(10, -11);
// &VREFN @WIRE {#M0N:3 %t5:p};
// %t6 = $SUPPLY @ATTACH &DVDD => @PLACE(10, 11);
// &DVDD @WIRE {#M0P:3 %t6:p};
// %t7 = $GROUND @ATTACH &VREFN => @PLACE(34, -11);
// &VREFN @WIRE {#M1N:3 %t7:p};
// %t8 = $SUPPLY @ATTACH &DVDD => @PLACE(34, 11);
// &DVDD @WIRE {#M1P:3 %t8:p};
// $JUNCTION @ATTACH %j1;
// $JUNCTION @ATTACH %j2;
// $JUNCTION @ATTACH %j3;
// $JUNCTION @ATTACH %j4;
// (-5, 19) @TEXT("V29 diagnostic only / NOT qualified | high command: HIB = IN", size=1.4, bold=true, textcolor="#17365d");
// (-5, 16.6) @TEXT("Drawing only | N bulk = VSS; L = 30 nm. P bulk DVDD: M0P, M1P", size=1.05, textcolor="#52606d");
// }
ends mq_cdac_ctl_h

subckt mq_cdac_enable (IN EN ENB DVDD VREFN VSS)
M0N (ENB IN VREFN VSS) nch_ulvt_mac w=6e-06 l=3e-08 nf=3
M0P (ENB IN DVDD DVDD) pch_mac w=1.2e-05 l=3e-08 nf=6
M1N (EN ENB VREFN VSS) nch_ulvt_mac w=2.4e-05 l=3e-08 nf=12
M1P (EN ENB DVDD DVDD) pch_ulvt_mac w=4.8e-05 l=3e-08 nf=24
// @RNL {
// {&IN &EN &ENB &DVDD &VREFN &VSS} @REMOVE-FROM $PORT_FILL_SET;
// &VSS @ADD-TO $GROUND_NET_SET;
// &VREFN @ADD-TO $GROUND_NET_SET;
// #M0N @PLACE(10, -7) => @ORIENT("R0");
// #M0N @SET-SYMBOL $NMOS;
// #M0N @TEXT("ULVT 6u", key="model", size=1.05, dx=1.5, dy=-1);
// #M0N @TEXT("M0N", key="name", size=1.1, dx=1.5, dy=1);
// #M0P @PLACE(10, 7) => @ORIENT("R0");
// #M0P @SET-SYMBOL $PMOS;
// #M0P @TEXT("SVT 12u", key="model", size=1.05, dx=1.5, dy=-1);
// #M0P @TEXT("M0P", key="name", size=1.1, dx=1.5, dy=1);
// %j1 = (10, 0);
// %j2 = (5, 0);
// &ENB @WIRE {#M0N:1 %j1 #M0P:1};
// &IN @WIRE {#M0N:2 (5, -7) %j2 (5, 7) #M0P:2};
// #M1N @PLACE(34, -7) => @ORIENT("R0");
// #M1N @SET-SYMBOL $NMOS;
// #M1N @TEXT("ULVT 24u", key="model", size=1.05, dx=1.5, dy=-1);
// #M1N @TEXT("M1N", key="name", size=1.1, dx=1.5, dy=1);
// #M1P @PLACE(34, 7) => @ORIENT("R0");
// #M1P @SET-SYMBOL $PMOS;
// #M1P @TEXT("ULVT 48u", key="model", size=1.05, dx=1.5, dy=-1);
// #M1P @TEXT("M1P", key="name", size=1.1, dx=1.5, dy=1);
// %j3 = (34, 0);
// %j4 = (29, 0);
// &EN @WIRE {#M1N:1 %j3 #M1P:1};
// &ENB @WIRE {#M1N:2 (29, -7) %j4 (29, 7) #M1P:2};
// &ENB @WIRE {%j1 %j4};
// &IN @WIRE {%j2 (-2, 0)};
// (-2, 1) @TEXT("IN", size=1.05);
// &EN @WIRE {%j3 (42, 0)};
// (42, 1) @TEXT("EN", size=1.05);
// (17, -3) @TEXT("ENB", size=1.05);
// %t5 = $GROUND @ATTACH &VREFN => @PLACE(10, -11);
// &VREFN @WIRE {#M0N:3 %t5:p};
// %t6 = $SUPPLY @ATTACH &DVDD => @PLACE(10, 11);
// &DVDD @WIRE {#M0P:3 %t6:p};
// %t7 = $GROUND @ATTACH &VREFN => @PLACE(34, -11);
// &VREFN @WIRE {#M1N:3 %t7:p};
// %t8 = $SUPPLY @ATTACH &DVDD => @PLACE(34, 11);
// &DVDD @WIRE {#M1P:3 %t8:p};
// $JUNCTION @ATTACH %j1;
// $JUNCTION @ATTACH %j2;
// $JUNCTION @ATTACH %j3;
// $JUNCTION @ATTACH %j4;
// (-5, 19) @TEXT("V29 diagnostic only / NOT qualified | complementary enable", size=1.4, bold=true, textcolor="#17365d");
// (-5, 16.6) @TEXT("Drawing only | N bulk = VSS; L = 30 nm. P bulk DVDD: M0P, M1P", size=1.05, textcolor="#52606d");
// }
ends mq_cdac_enable

subckt mq_cdac_drv12 (HIB EN ENB BP VREFP VREFN VSS DVDD)
// DVDD prelogic: PCOND = NOR(ENB,HIB); NOFF = NAND(EN,HIB).
// Reference-powered final inverters restore GP and GN to VREFP/VREFN.
// Actual current overlap, settling and device stress require measurement.
MPA0 (AP ENB DVDD DVDD) pch_ulvt_mac w=2e-05 l=3e-08 nf=10
MPA1 (PCOND HIB AP DVDD) pch_ulvt_mac w=8e-06 l=3e-08 nf=4
MNA0 (PCOND ENB VREFN VSS) nch_ulvt_mac w=4e-06 l=3e-08 nf=2
MNA1 (PCOND HIB VREFN VSS) nch_ulvt_mac w=4e-06 l=3e-08 nf=2
MPB0 (NOFF EN DVDD DVDD) pch_ulvt_mac w=4e-06 l=3e-08 nf=2
MPB1 (NOFF HIB DVDD DVDD) pch_ulvt_mac w=4e-06 l=3e-08 nf=2
MNB0 (NOFF EN BN VSS) nch_ulvt_mac w=2e-06 l=3e-08 nf=1
MNB1 (BN HIB VREFN VSS) nch_ulvt_mac w=8e-06 l=3e-08 nf=4
MGPN (GP PCOND VREFN VSS) nch_lvt_mac w=1e-05 l=3e-08 nf=5
MGPP (GP PCOND VREFP VREFP) pch_mac w=1.2e-05 l=3e-08 nf=6
MGNN (GN NOFF VREFN VSS) nch_ulvt_mac w=8e-06 l=3e-08 nf=4
MGNP (GN NOFF VREFP VREFP) pch_mac w=4e-06 l=3e-08 nf=2
MNOUT (BP GN VREFN VSS) nch_mac w=2.025e-05 l=4e-08 nf=10
MPOUT (BP GP VREFP VREFP) pch_mac w=4.05e-05 l=4e-08 nf=20
// Actively discharge AP while ENB turns the upper PMOS off.
MNDAP (AP ENB VREFN VSS) nch_ulvt_mac w=1e-06 l=3e-08 nf=1
// 50 existing physical MOM units, with 5% bottom Cp, slow AP feedthrough.
C_APLOAD (VSS AP) cfmom_2t w=5e-08 s=2.4e-07 nr=6 lr=1.69e-06 stm=2 spm=4 multi=50
CP_APLOAD (AP VSS) capacitor c=2.505725e-15

MNCANCEL (NOFF ENB NOFF VSS) nch_ulvt_mac w=2e-06 l=3e-08 nf=1
// @RNL {
// {&HIB &EN &ENB &BP &VREFP &VREFN &VSS &DVDD} @REMOVE-FROM $PORT_FILL_SET;
// &VSS @ADD-TO $GROUND_NET_SET;
// &VREFN @ADD-TO $GROUND_NET_SET;
// #MPA0 @PLACE(8, 32) => @ORIENT("R0");
// #MPA0 @SET-SYMBOL $PMOS;
// #MPA0 @TEXT("ULVT 20u", key="model", size=1.05, dx=1.5, dy=-1);
// #MPA0 @TEXT("MPA0", key="name", size=1.1, dx=1.5, dy=1);
// #MPA1 @PLACE(8, 24) => @ORIENT("R0");
// #MPA1 @SET-SYMBOL $PMOS;
// #MPA1 @TEXT("ULVT 8u", key="model", size=1.05, dx=1.5, dy=-1);
// #MPA1 @TEXT("MPA1", key="name", size=1.1, dx=1.5, dy=1);
// #MNA0 @PLACE(0, 8) => @ORIENT("R0");
// #MNA0 @SET-SYMBOL $NMOS;
// #MNA0 @TEXT("ULVT 4u", key="model", size=1.05, dx=1.5, dy=-1);
// #MNA0 @TEXT("MNA0", key="name", size=1.1, dx=1.5, dy=1);
// #MNA1 @PLACE(16, 8) => @ORIENT("R0");
// #MNA1 @SET-SYMBOL $NMOS;
// #MNA1 @TEXT("ULVT 4u", key="model", size=1.05, dx=1.5, dy=-1);
// #MNA1 @TEXT("MNA1", key="name", size=1.1, dx=1.5, dy=1);
// #MPB0 @PLACE(0, -8) => @ORIENT("R0");
// #MPB0 @SET-SYMBOL $PMOS;
// #MPB0 @TEXT("ULVT 4u", key="model", size=1.05, dx=1.5, dy=-1);
// #MPB0 @TEXT("MPB0", key="name", size=1.1, dx=1.5, dy=1);
// #MPB1 @PLACE(16, -8) => @ORIENT("R0");
// #MPB1 @SET-SYMBOL $PMOS;
// #MPB1 @TEXT("ULVT 4u", key="model", size=1.05, dx=1.5, dy=-1);
// #MPB1 @TEXT("MPB1", key="name", size=1.1, dx=1.5, dy=1);
// #MNB0 @PLACE(8, -24) => @ORIENT("R0");
// #MNB0 @SET-SYMBOL $NMOS;
// #MNB0 @TEXT("ULVT 2u", key="model", size=1.05, dx=1.5, dy=-1);
// #MNB0 @TEXT("MNB0", key="name", size=1.1, dx=1.5, dy=1);
// #MNB1 @PLACE(8, -32) => @ORIENT("R0");
// #MNB1 @SET-SYMBOL $NMOS;
// #MNB1 @TEXT("ULVT 8u", key="model", size=1.05, dx=1.5, dy=-1);
// #MNB1 @TEXT("MNB1", key="name", size=1.1, dx=1.5, dy=1);
// #MPOUT @PLACE(76, 18) => @ORIENT("R0");
// #MPOUT @SET-SYMBOL $PMOS;
// #MPOUT @TEXT("SVT 40n 40.5u", key="model", size=1.05, dx=1.5, dy=-1);
// #MPOUT @TEXT("MPOUT", key="name", size=1.1, dx=1.5, dy=1);
// #MNOUT @PLACE(76, -18) => @ORIENT("R0");
// #MNOUT @SET-SYMBOL $NMOS;
// #MNOUT @TEXT("SVT 40n 20.25u", key="model", size=1.05, dx=1.5, dy=-1);
// #MNOUT @TEXT("MNOUT", key="name", size=1.1, dx=1.5, dy=1);
// &AP @WIRE {#MPA0:1 #MPA1:3};
// (10, 28) @TEXT("AP", size=1.05);
// %j1 = (8, 16);
// &PCOND @WIRE {#MNA0:1 (0, 16) %j1 (16, 16) #MNA1:1};
// &PCOND @WIRE {#MPA1:1 %j1};
// #MGPN @PLACE(43, 9) => @ORIENT("R0");
// #MGPN @SET-SYMBOL $NMOS;
// #MGPN @TEXT("LVT 10u", key="model", size=1.05, dx=1.5, dy=-1);
// #MGPN @TEXT("MGPN", key="name", size=1.1, dx=1.5, dy=1);
// #MGPP @PLACE(43, 23) => @ORIENT("R0");
// #MGPP @SET-SYMBOL $PMOS;
// #MGPP @TEXT("SVT 12u", key="model", size=1.05, dx=1.5, dy=-1);
// #MGPP @TEXT("MGPP", key="name", size=1.1, dx=1.5, dy=1);
// %j2 = (43, 16);
// %j3 = (38, 16);
// &GP @WIRE {#MGPN:1 %j2 #MGPP:1};
// &PCOND @WIRE {#MGPN:2 (38, 9) %j3 (38, 23) #MGPP:2};
// &PCOND @WIRE {%j1 %j3};
// &GP @WIRE {%j2 (65, 16) (65, 18) #MPOUT:2};
// %j4 = (8, -16);
// &NOFF @WIRE {#MPB0:1 (0, -16) %j4 (16, -16) #MPB1:1};
// &NOFF @WIRE {#MNB0:1 %j4};
// &BN @WIRE {#MNB0:3 #MNB1:1};
// (18, -14) @TEXT("NOFF", size=1.05);
// #MGNN @PLACE(43, -23) => @ORIENT("R0");
// #MGNN @SET-SYMBOL $NMOS;
// #MGNN @TEXT("ULVT 8u", key="model", size=1.05, dx=1.5, dy=-1);
// #MGNN @TEXT("MGNN", key="name", size=1.1, dx=1.5, dy=1);
// #MGNP @PLACE(43, -9) => @ORIENT("R0");
// #MGNP @SET-SYMBOL $PMOS;
// #MGNP @TEXT("SVT 4u", key="model", size=1.05, dx=1.5, dy=-1);
// #MGNP @TEXT("MGNP", key="name", size=1.1, dx=1.5, dy=1);
// %j5 = (43, -16);
// %j6 = (38, -16);
// &GN @WIRE {#MGNN:1 %j5 #MGNP:1};
// &NOFF @WIRE {#MGNN:2 (38, -23) %j6 (38, -9) #MGNP:2};
// &NOFF @WIRE {%j4 %j6};
// &GN @WIRE {%j5 (65, -16) (65, -18) #MNOUT:2};
// %j7 = (76, 0);
// &BP @WIRE {#MPOUT:1 %j7 #MNOUT:1};
// &BP @WIRE {%j7 (85, 0)};
// (85, 1) @TEXT("BP", size=1.05);
// (-5, 42) @TEXT("NOR: PCOND = ~(ENB | HIB)", size=1.05);
// (-5, -42) @TEXT("NAND: NOFF = ~(EN & HIB)", size=1.05);
// (31, 39) @TEXT("Reference gate drivers", size=1.05);
// (67, 39) @TEXT("Output rail switch", size=1.05);
// #MNDAP @PLACE(100, 24) => @ORIENT("R0");
// #MNDAP @SET-SYMBOL $NMOS;
// #MNDAP @TEXT("ULVT 1u", key="model", size=1.05, dx=1.5, dy=-1);
// #MNDAP @TEXT("MNDAP", key="name", size=1.1, dx=1.5, dy=1);
// #C_APLOAD @PLACE(113, 24) => @ORIENT("MX");
// #C_APLOAD @TEXT("", key="value");
// #C_APLOAD @TEXT("", key="name");
// (115, 25) @TEXT("C_APLOAD", size=1.05);
// (115, 23) @TEXT("50 Cu", size=1.05);
// #CP_APLOAD @PLACE(128, 24) => @ORIENT("R0");
// #CP_APLOAD @TEXT("", key="value");
// #CP_APLOAD @TEXT("", key="name");
// (130, 25) @TEXT("CP_APLOAD", size=1.05);
// (130, 23) @TEXT("2.506 fF / 5%", size=1.05);
// %j8 = (113, 30);
// &AP @WIRE {#MNDAP:1 (100, 30) %j8 (128, 30) #CP_APLOAD:1};
// &AP @WIRE {#C_APLOAD:2 %j8};
// (113, 32) @TEXT("AP", size=1.05);
// #MNCANCEL @PLACE(109, -14) => @ORIENT("R0");
// #MNCANCEL @SET-SYMBOL $NMOS;
// #MNCANCEL @TEXT("ULVT 2u", key="model", size=1.05, dx=1.5, dy=-1);
// #MNCANCEL @TEXT("MNCANCEL", key="name", size=1.1, dx=1.5, dy=1);
// &NOFF @WIRE {#MNCANCEL:1 (115, -12) (115, -16) #MNCANCEL:3};
// (117, -14) @TEXT("NOFF", size=1.05);
// (96, 39) @TEXT("AP keeper + physical MOM load", size=1.05);
// (96, -25) @TEXT("ENB feedthrough cancellation", size=1.05);
// &ENB @WIRE {#MPA0:2 (3, 32)};
// (2.7, 32) @TEXT("ENB", size=1.05, halign="end", valign="middle");
// %t10 = $SUPPLY @ATTACH &DVDD => @PLACE(8, 36);
// &DVDD @WIRE {#MPA0:3 %t10:p};
// &HIB @WIRE {#MPA1:2 (3, 24)};
// (2.7, 24) @TEXT("HIB", size=1.05, halign="end", valign="middle");
// &ENB @WIRE {#MNA0:2 (-5, 8)};
// (-5.3, 8) @TEXT("ENB", size=1.05, halign="end", valign="middle");
// %t13 = $GROUND @ATTACH &VREFN => @PLACE(0, 4);
// &VREFN @WIRE {#MNA0:3 %t13:p};
// &HIB @WIRE {#MNA1:2 (11, 8)};
// (10.7, 8) @TEXT("HIB", size=1.05, halign="end", valign="middle");
// %t15 = $GROUND @ATTACH &VREFN => @PLACE(16, 4);
// &VREFN @WIRE {#MNA1:3 %t15:p};
// &EN @WIRE {#MPB0:2 (-5, -8)};
// (-5.3, -8) @TEXT("EN", size=1.05, halign="end", valign="middle");
// %t17 = $SUPPLY @ATTACH &DVDD => @PLACE(0, -4);
// &DVDD @WIRE {#MPB0:3 %t17:p};
// &HIB @WIRE {#MPB1:2 (11, -8)};
// (10.7, -8) @TEXT("HIB", size=1.05, halign="end", valign="middle");
// %t19 = $SUPPLY @ATTACH &DVDD => @PLACE(16, -4);
// &DVDD @WIRE {#MPB1:3 %t19:p};
// &EN @WIRE {#MNB0:2 (3, -24)};
// (2.7, -24) @TEXT("EN", size=1.05, halign="end", valign="middle");
// &HIB @WIRE {#MNB1:2 (3, -32)};
// (2.7, -32) @TEXT("HIB", size=1.05, halign="end", valign="middle");
// %t22 = $GROUND @ATTACH &VREFN => @PLACE(8, -36);
// &VREFN @WIRE {#MNB1:3 %t22:p};
// %t23 = $SUPPLY @ATTACH &VREFP => @PLACE(76, 22);
// &VREFP @WIRE {#MPOUT:3 %t23:p};
// %t24 = $GROUND @ATTACH &VREFN => @PLACE(76, -22);
// &VREFN @WIRE {#MNOUT:3 %t24:p};
// %t25 = $GROUND @ATTACH &VREFN => @PLACE(43, 5);
// &VREFN @WIRE {#MGPN:3 %t25:p};
// %t26 = $SUPPLY @ATTACH &VREFP => @PLACE(43, 27);
// &VREFP @WIRE {#MGPP:3 %t26:p};
// %t27 = $GROUND @ATTACH &VREFN => @PLACE(43, -27);
// &VREFN @WIRE {#MGNN:3 %t27:p};
// %t28 = $SUPPLY @ATTACH &VREFP => @PLACE(43, -5);
// &VREFP @WIRE {#MGNP:3 %t28:p};
// &ENB @WIRE {#MNDAP:2 (95, 24)};
// (94.7, 24) @TEXT("ENB", size=1.05, halign="end", valign="middle");
// %t30 = $GROUND @ATTACH &VREFN => @PLACE(100, 20);
// &VREFN @WIRE {#MNDAP:3 %t30:p};
// %t31 = $GROUND @ATTACH &VSS => @PLACE(113, 20);
// &VSS @WIRE {#C_APLOAD:1 %t31:p};
// %t32 = $GROUND @ATTACH &VSS => @PLACE(128, 20);
// &VSS @WIRE {#CP_APLOAD:2 %t32:p};
// &ENB @WIRE {#MNCANCEL:2 (104, -14)};
// (103.7, -14) @TEXT("ENB", size=1.05, halign="end", valign="middle");
// $JUNCTION @ATTACH %j1;
// $JUNCTION @ATTACH %j2;
// $JUNCTION @ATTACH %j3;
// $JUNCTION @ATTACH %j4;
// $JUNCTION @ATTACH %j5;
// $JUNCTION @ATTACH %j6;
// $JUNCTION @ATTACH %j7;
// $JUNCTION @ATTACH %j8;
// (-7, 51) @TEXT("V29 diagnostic only / NOT qualified | mq_cdac_drv12 | isolated DVDD logic / VREFP output", size=1.4, bold=true, textcolor="#17365d");
// (-7, 48.6) @TEXT("Drawing only | N bulk = VSS; L = 30 nm. P bulk DVDD: MPA0, MPA1, MPB0, MPB1; VREFP: MGPP, MGNP, MPOUT", size=1.05, textcolor="#52606d");
// }
ends mq_cdac_drv12

subckt mq_cdac_drv11 (HIB EN ENB BP VREFP VREFN VSS DVDD)
// DVDD prelogic: PCOND = NOR(ENB,HIB); NOFF = NAND(EN,HIB).
// Reference-powered final inverters restore GP and GN to VREFP/VREFN.
// Actual current overlap, settling and device stress require measurement.
MPA0 (AP ENB DVDD DVDD) pch_ulvt_mac w=4.575e-06 l=3e-08 nf=3
MPA1 (PCOND HIB AP DVDD) pch_ulvt_mac w=4.575e-06 l=3e-08 nf=3
MNA0 (PCOND ENB VREFN VSS) nch_ulvt_mac w=2.29e-06 l=3e-08 nf=2
MNA1 (PCOND HIB VREFN VSS) nch_ulvt_mac w=2.29e-06 l=3e-08 nf=2
MPB0 (NOFF EN DVDD DVDD) pch_ulvt_mac w=2.29e-06 l=3e-08 nf=2
MPB1 (NOFF HIB DVDD DVDD) pch_ulvt_mac w=2.29e-06 l=3e-08 nf=2
MNB0 (NOFF EN BN VSS) nch_ulvt_mac w=1e-06 l=3e-08 nf=1
MNB1 (BN HIB VREFN VSS) nch_ulvt_mac w=6e-06 l=3e-08 nf=3
MGPN (GP PCOND VREFN VSS) nch_mac w=4.575e-06 l=3e-08 nf=3
MGPP (GP PCOND VREFP VREFP) pch_mac w=6.86e-06 l=3e-08 nf=4
MGNN (GN NOFF VREFN VSS) nch_mac w=4.575e-06 l=3e-08 nf=3
MGNP (GN NOFF VREFP VREFP) pch_mac w=2.29e-06 l=3e-08 nf=2
MNOUT (BP GN VREFN VSS) nch_mac w=1.158e-05 l=4e-08 nf=6
MPOUT (BP GP VREFP VREFP) pch_mac w=2.316e-05 l=4e-08 nf=12
// Actively discharge AP while ENB turns the upper PMOS off.
MNDAP (AP ENB VREFN VSS) nch_ulvt_mac w=5.75e-07 l=3e-08 nf=1
// 12 existing physical MOM units, with 5% bottom Cp, slow AP feedthrough.
C_APLOAD (VSS AP) cfmom_2t w=5e-08 s=2.4e-07 nr=6 lr=1.69e-06 stm=2 spm=4 multi=12
CP_APLOAD (AP VSS) capacitor c=6.01374e-16
MNCANCEL (NOFF ENB NOFF VSS) nch_ulvt_mac w=1e-06 l=3e-08 nf=1
// @RNL {
// {&HIB &EN &ENB &BP &VREFP &VREFN &VSS &DVDD} @REMOVE-FROM $PORT_FILL_SET;
// &VSS @ADD-TO $GROUND_NET_SET;
// &VREFN @ADD-TO $GROUND_NET_SET;
// #MPA0 @PLACE(8, 32) => @ORIENT("R0");
// #MPA0 @SET-SYMBOL $PMOS;
// #MPA0 @TEXT("ULVT 4.575u", key="model", size=1.05, dx=1.5, dy=-1);
// #MPA0 @TEXT("MPA0", key="name", size=1.1, dx=1.5, dy=1);
// #MPA1 @PLACE(8, 24) => @ORIENT("R0");
// #MPA1 @SET-SYMBOL $PMOS;
// #MPA1 @TEXT("ULVT 4.575u", key="model", size=1.05, dx=1.5, dy=-1);
// #MPA1 @TEXT("MPA1", key="name", size=1.1, dx=1.5, dy=1);
// #MNA0 @PLACE(0, 8) => @ORIENT("R0");
// #MNA0 @SET-SYMBOL $NMOS;
// #MNA0 @TEXT("ULVT 2.29u", key="model", size=1.05, dx=1.5, dy=-1);
// #MNA0 @TEXT("MNA0", key="name", size=1.1, dx=1.5, dy=1);
// #MNA1 @PLACE(16, 8) => @ORIENT("R0");
// #MNA1 @SET-SYMBOL $NMOS;
// #MNA1 @TEXT("ULVT 2.29u", key="model", size=1.05, dx=1.5, dy=-1);
// #MNA1 @TEXT("MNA1", key="name", size=1.1, dx=1.5, dy=1);
// #MPB0 @PLACE(0, -8) => @ORIENT("R0");
// #MPB0 @SET-SYMBOL $PMOS;
// #MPB0 @TEXT("ULVT 2.29u", key="model", size=1.05, dx=1.5, dy=-1);
// #MPB0 @TEXT("MPB0", key="name", size=1.1, dx=1.5, dy=1);
// #MPB1 @PLACE(16, -8) => @ORIENT("R0");
// #MPB1 @SET-SYMBOL $PMOS;
// #MPB1 @TEXT("ULVT 2.29u", key="model", size=1.05, dx=1.5, dy=-1);
// #MPB1 @TEXT("MPB1", key="name", size=1.1, dx=1.5, dy=1);
// #MNB0 @PLACE(8, -24) => @ORIENT("R0");
// #MNB0 @SET-SYMBOL $NMOS;
// #MNB0 @TEXT("ULVT 1u", key="model", size=1.05, dx=1.5, dy=-1);
// #MNB0 @TEXT("MNB0", key="name", size=1.1, dx=1.5, dy=1);
// #MNB1 @PLACE(8, -32) => @ORIENT("R0");
// #MNB1 @SET-SYMBOL $NMOS;
// #MNB1 @TEXT("ULVT 6u", key="model", size=1.05, dx=1.5, dy=-1);
// #MNB1 @TEXT("MNB1", key="name", size=1.1, dx=1.5, dy=1);
// #MPOUT @PLACE(76, 18) => @ORIENT("R0");
// #MPOUT @SET-SYMBOL $PMOS;
// #MPOUT @TEXT("SVT 40n 23.16u", key="model", size=1.05, dx=1.5, dy=-1);
// #MPOUT @TEXT("MPOUT", key="name", size=1.1, dx=1.5, dy=1);
// #MNOUT @PLACE(76, -18) => @ORIENT("R0");
// #MNOUT @SET-SYMBOL $NMOS;
// #MNOUT @TEXT("SVT 40n 11.58u", key="model", size=1.05, dx=1.5, dy=-1);
// #MNOUT @TEXT("MNOUT", key="name", size=1.1, dx=1.5, dy=1);
// &AP @WIRE {#MPA0:1 #MPA1:3};
// (10, 28) @TEXT("AP", size=1.05);
// %j1 = (8, 16);
// &PCOND @WIRE {#MNA0:1 (0, 16) %j1 (16, 16) #MNA1:1};
// &PCOND @WIRE {#MPA1:1 %j1};
// #MGPN @PLACE(43, 9) => @ORIENT("R0");
// #MGPN @SET-SYMBOL $NMOS;
// #MGPN @TEXT("SVT 4.575u", key="model", size=1.05, dx=1.5, dy=-1);
// #MGPN @TEXT("MGPN", key="name", size=1.1, dx=1.5, dy=1);
// #MGPP @PLACE(43, 23) => @ORIENT("R0");
// #MGPP @SET-SYMBOL $PMOS;
// #MGPP @TEXT("SVT 6.86u", key="model", size=1.05, dx=1.5, dy=-1);
// #MGPP @TEXT("MGPP", key="name", size=1.1, dx=1.5, dy=1);
// %j2 = (43, 16);
// %j3 = (38, 16);
// &GP @WIRE {#MGPN:1 %j2 #MGPP:1};
// &PCOND @WIRE {#MGPN:2 (38, 9) %j3 (38, 23) #MGPP:2};
// &PCOND @WIRE {%j1 %j3};
// &GP @WIRE {%j2 (65, 16) (65, 18) #MPOUT:2};
// %j4 = (8, -16);
// &NOFF @WIRE {#MPB0:1 (0, -16) %j4 (16, -16) #MPB1:1};
// &NOFF @WIRE {#MNB0:1 %j4};
// &BN @WIRE {#MNB0:3 #MNB1:1};
// (18, -14) @TEXT("NOFF", size=1.05);
// #MGNN @PLACE(43, -23) => @ORIENT("R0");
// #MGNN @SET-SYMBOL $NMOS;
// #MGNN @TEXT("SVT 4.575u", key="model", size=1.05, dx=1.5, dy=-1);
// #MGNN @TEXT("MGNN", key="name", size=1.1, dx=1.5, dy=1);
// #MGNP @PLACE(43, -9) => @ORIENT("R0");
// #MGNP @SET-SYMBOL $PMOS;
// #MGNP @TEXT("SVT 2.29u", key="model", size=1.05, dx=1.5, dy=-1);
// #MGNP @TEXT("MGNP", key="name", size=1.1, dx=1.5, dy=1);
// %j5 = (43, -16);
// %j6 = (38, -16);
// &GN @WIRE {#MGNN:1 %j5 #MGNP:1};
// &NOFF @WIRE {#MGNN:2 (38, -23) %j6 (38, -9) #MGNP:2};
// &NOFF @WIRE {%j4 %j6};
// &GN @WIRE {%j5 (65, -16) (65, -18) #MNOUT:2};
// %j7 = (76, 0);
// &BP @WIRE {#MPOUT:1 %j7 #MNOUT:1};
// &BP @WIRE {%j7 (85, 0)};
// (85, 1) @TEXT("BP", size=1.05);
// (-5, 42) @TEXT("NOR: PCOND = ~(ENB | HIB)", size=1.05);
// (-5, -42) @TEXT("NAND: NOFF = ~(EN & HIB)", size=1.05);
// (31, 39) @TEXT("Reference gate drivers", size=1.05);
// (67, 39) @TEXT("Output rail switch", size=1.05);
// #MNDAP @PLACE(100, 24) => @ORIENT("R0");
// #MNDAP @SET-SYMBOL $NMOS;
// #MNDAP @TEXT("ULVT 0.575u", key="model", size=1.05, dx=1.5, dy=-1);
// #MNDAP @TEXT("MNDAP", key="name", size=1.1, dx=1.5, dy=1);
// #C_APLOAD @PLACE(113, 24) => @ORIENT("MX");
// #C_APLOAD @TEXT("", key="value");
// #C_APLOAD @TEXT("", key="name");
// (115, 25) @TEXT("C_APLOAD", size=1.05);
// (115, 23) @TEXT("12 Cu", size=1.05);
// #CP_APLOAD @PLACE(128, 24) => @ORIENT("R0");
// #CP_APLOAD @TEXT("", key="value");
// #CP_APLOAD @TEXT("", key="name");
// (130, 25) @TEXT("CP_APLOAD", size=1.05);
// (130, 23) @TEXT("0.6014 fF / 5%", size=1.05);
// %j8 = (113, 30);
// &AP @WIRE {#MNDAP:1 (100, 30) %j8 (128, 30) #CP_APLOAD:1};
// &AP @WIRE {#C_APLOAD:2 %j8};
// (113, 32) @TEXT("AP", size=1.05);
// #MNCANCEL @PLACE(109, -14) => @ORIENT("R0");
// #MNCANCEL @SET-SYMBOL $NMOS;
// #MNCANCEL @TEXT("ULVT 1u", key="model", size=1.05, dx=1.5, dy=-1);
// #MNCANCEL @TEXT("MNCANCEL", key="name", size=1.1, dx=1.5, dy=1);
// &NOFF @WIRE {#MNCANCEL:1 (115, -12) (115, -16) #MNCANCEL:3};
// (117, -14) @TEXT("NOFF", size=1.05);
// (96, 39) @TEXT("AP keeper + physical MOM load", size=1.05);
// (96, -25) @TEXT("ENB feedthrough cancellation", size=1.05);
// &ENB @WIRE {#MPA0:2 (3, 32)};
// (2.7, 32) @TEXT("ENB", size=1.05, halign="end", valign="middle");
// %t10 = $SUPPLY @ATTACH &DVDD => @PLACE(8, 36);
// &DVDD @WIRE {#MPA0:3 %t10:p};
// &HIB @WIRE {#MPA1:2 (3, 24)};
// (2.7, 24) @TEXT("HIB", size=1.05, halign="end", valign="middle");
// &ENB @WIRE {#MNA0:2 (-5, 8)};
// (-5.3, 8) @TEXT("ENB", size=1.05, halign="end", valign="middle");
// %t13 = $GROUND @ATTACH &VREFN => @PLACE(0, 4);
// &VREFN @WIRE {#MNA0:3 %t13:p};
// &HIB @WIRE {#MNA1:2 (11, 8)};
// (10.7, 8) @TEXT("HIB", size=1.05, halign="end", valign="middle");
// %t15 = $GROUND @ATTACH &VREFN => @PLACE(16, 4);
// &VREFN @WIRE {#MNA1:3 %t15:p};
// &EN @WIRE {#MPB0:2 (-5, -8)};
// (-5.3, -8) @TEXT("EN", size=1.05, halign="end", valign="middle");
// %t17 = $SUPPLY @ATTACH &DVDD => @PLACE(0, -4);
// &DVDD @WIRE {#MPB0:3 %t17:p};
// &HIB @WIRE {#MPB1:2 (11, -8)};
// (10.7, -8) @TEXT("HIB", size=1.05, halign="end", valign="middle");
// %t19 = $SUPPLY @ATTACH &DVDD => @PLACE(16, -4);
// &DVDD @WIRE {#MPB1:3 %t19:p};
// &EN @WIRE {#MNB0:2 (3, -24)};
// (2.7, -24) @TEXT("EN", size=1.05, halign="end", valign="middle");
// &HIB @WIRE {#MNB1:2 (3, -32)};
// (2.7, -32) @TEXT("HIB", size=1.05, halign="end", valign="middle");
// %t22 = $GROUND @ATTACH &VREFN => @PLACE(8, -36);
// &VREFN @WIRE {#MNB1:3 %t22:p};
// %t23 = $SUPPLY @ATTACH &VREFP => @PLACE(76, 22);
// &VREFP @WIRE {#MPOUT:3 %t23:p};
// %t24 = $GROUND @ATTACH &VREFN => @PLACE(76, -22);
// &VREFN @WIRE {#MNOUT:3 %t24:p};
// %t25 = $GROUND @ATTACH &VREFN => @PLACE(43, 5);
// &VREFN @WIRE {#MGPN:3 %t25:p};
// %t26 = $SUPPLY @ATTACH &VREFP => @PLACE(43, 27);
// &VREFP @WIRE {#MGPP:3 %t26:p};
// %t27 = $GROUND @ATTACH &VREFN => @PLACE(43, -27);
// &VREFN @WIRE {#MGNN:3 %t27:p};
// %t28 = $SUPPLY @ATTACH &VREFP => @PLACE(43, -5);
// &VREFP @WIRE {#MGNP:3 %t28:p};
// &ENB @WIRE {#MNDAP:2 (95, 24)};
// (94.7, 24) @TEXT("ENB", size=1.05, halign="end", valign="middle");
// %t30 = $GROUND @ATTACH &VREFN => @PLACE(100, 20);
// &VREFN @WIRE {#MNDAP:3 %t30:p};
// %t31 = $GROUND @ATTACH &VSS => @PLACE(113, 20);
// &VSS @WIRE {#C_APLOAD:1 %t31:p};
// %t32 = $GROUND @ATTACH &VSS => @PLACE(128, 20);
// &VSS @WIRE {#CP_APLOAD:2 %t32:p};
// &ENB @WIRE {#MNCANCEL:2 (104, -14)};
// (103.7, -14) @TEXT("ENB", size=1.05, halign="end", valign="middle");
// $JUNCTION @ATTACH %j1;
// $JUNCTION @ATTACH %j2;
// $JUNCTION @ATTACH %j3;
// $JUNCTION @ATTACH %j4;
// $JUNCTION @ATTACH %j5;
// $JUNCTION @ATTACH %j6;
// $JUNCTION @ATTACH %j7;
// $JUNCTION @ATTACH %j8;
// (-7, 51) @TEXT("V29 diagnostic only / NOT qualified | mq_cdac_drv11 | isolated DVDD logic / VREFP output", size=1.4, bold=true, textcolor="#17365d");
// (-7, 48.6) @TEXT("Drawing only | N bulk = VSS; L = 30 nm. P bulk DVDD: MPA0, MPA1, MPB0, MPB1; VREFP: MGPP, MGNP, MPOUT", size=1.05, textcolor="#52606d");
// }
ends mq_cdac_drv11

subckt mq_cdac_drv10 (HIB EN ENB BP VREFP VREFN VSS DVDD)
// DVDD prelogic: PCOND = NOR(ENB,HIB); NOFF = NAND(EN,HIB).
// Reference-powered final inverters restore GP and GN to VREFP/VREFN.
// Actual current overlap, settling and device stress require measurement.
MPA0 (AP ENB DVDD DVDD) pch_ulvt_mac w=2.6e-06 l=3e-08 nf=2
MPA1 (PCOND HIB AP DVDD) pch_ulvt_mac w=2.6e-06 l=3e-08 nf=2
MNA0 (PCOND ENB VREFN VSS) nch_ulvt_mac w=1.3e-06 l=3e-08 nf=1
MNA1 (PCOND HIB VREFN VSS) nch_ulvt_mac w=1.3e-06 l=3e-08 nf=1
MPB0 (NOFF EN DVDD DVDD) pch_ulvt_mac w=1.3e-06 l=3e-08 nf=1
MPB1 (NOFF HIB DVDD DVDD) pch_ulvt_mac w=1.3e-06 l=3e-08 nf=1
MNB0 (NOFF EN BN VSS) nch_ulvt_mac w=5.75e-07 l=3e-08 nf=1
MNB1 (BN HIB VREFN VSS) nch_ulvt_mac w=3.71e-06 l=3e-08 nf=2
MGPN (GP PCOND VREFN VSS) nch_mac w=2.6e-06 l=3e-08 nf=2
MGPP (GP PCOND VREFP VREFP) pch_mac w=3.89e-06 l=3e-08 nf=2
MGNN (GN NOFF VREFN VSS) nch_mac w=2.6e-06 l=3e-08 nf=2
MGNP (GN NOFF VREFP VREFP) pch_mac w=1.3e-06 l=3e-08 nf=1
MNOUT (BP GN VREFN VSS) nch_mac w=6.56e-06 l=3e-08 nf=4
MPOUT (BP GP VREFP VREFP) pch_mac w=1.3125e-05 l=3e-08 nf=7
// Actively discharge AP while ENB turns the upper PMOS off.
MNDAP (AP ENB VREFN VSS) nch_ulvt_mac w=3.25e-07 l=3e-08 nf=1
// 7 existing physical MOM units, with 5% bottom Cp, slow AP feedthrough.
C_APLOAD (VSS AP) cfmom_2t w=5e-08 s=2.4e-07 nr=6 lr=1.69e-06 stm=2 spm=4 multi=7
CP_APLOAD (AP VSS) capacitor c=3.508015e-16
MNCANCEL (NOFF ENB NOFF VSS) nch_ulvt_mac w=5.75e-07 l=3e-08 nf=1
// @RNL {
// {&HIB &EN &ENB &BP &VREFP &VREFN &VSS &DVDD} @REMOVE-FROM $PORT_FILL_SET;
// &VSS @ADD-TO $GROUND_NET_SET;
// &VREFN @ADD-TO $GROUND_NET_SET;
// #MPA0 @PLACE(8, 32) => @ORIENT("R0");
// #MPA0 @SET-SYMBOL $PMOS;
// #MPA0 @TEXT("ULVT 2.6u", key="model", size=1.05, dx=1.5, dy=-1);
// #MPA0 @TEXT("MPA0", key="name", size=1.1, dx=1.5, dy=1);
// #MPA1 @PLACE(8, 24) => @ORIENT("R0");
// #MPA1 @SET-SYMBOL $PMOS;
// #MPA1 @TEXT("ULVT 2.6u", key="model", size=1.05, dx=1.5, dy=-1);
// #MPA1 @TEXT("MPA1", key="name", size=1.1, dx=1.5, dy=1);
// #MNA0 @PLACE(0, 8) => @ORIENT("R0");
// #MNA0 @SET-SYMBOL $NMOS;
// #MNA0 @TEXT("ULVT 1.3u", key="model", size=1.05, dx=1.5, dy=-1);
// #MNA0 @TEXT("MNA0", key="name", size=1.1, dx=1.5, dy=1);
// #MNA1 @PLACE(16, 8) => @ORIENT("R0");
// #MNA1 @SET-SYMBOL $NMOS;
// #MNA1 @TEXT("ULVT 1.3u", key="model", size=1.05, dx=1.5, dy=-1);
// #MNA1 @TEXT("MNA1", key="name", size=1.1, dx=1.5, dy=1);
// #MPB0 @PLACE(0, -8) => @ORIENT("R0");
// #MPB0 @SET-SYMBOL $PMOS;
// #MPB0 @TEXT("ULVT 1.3u", key="model", size=1.05, dx=1.5, dy=-1);
// #MPB0 @TEXT("MPB0", key="name", size=1.1, dx=1.5, dy=1);
// #MPB1 @PLACE(16, -8) => @ORIENT("R0");
// #MPB1 @SET-SYMBOL $PMOS;
// #MPB1 @TEXT("ULVT 1.3u", key="model", size=1.05, dx=1.5, dy=-1);
// #MPB1 @TEXT("MPB1", key="name", size=1.1, dx=1.5, dy=1);
// #MNB0 @PLACE(8, -24) => @ORIENT("R0");
// #MNB0 @SET-SYMBOL $NMOS;
// #MNB0 @TEXT("ULVT 0.575u", key="model", size=1.05, dx=1.5, dy=-1);
// #MNB0 @TEXT("MNB0", key="name", size=1.1, dx=1.5, dy=1);
// #MNB1 @PLACE(8, -32) => @ORIENT("R0");
// #MNB1 @SET-SYMBOL $NMOS;
// #MNB1 @TEXT("ULVT 3.71u", key="model", size=1.05, dx=1.5, dy=-1);
// #MNB1 @TEXT("MNB1", key="name", size=1.1, dx=1.5, dy=1);
// #MPOUT @PLACE(76, 18) => @ORIENT("R0");
// #MPOUT @SET-SYMBOL $PMOS;
// #MPOUT @TEXT("SVT 13.125u", key="model", size=1.05, dx=1.5, dy=-1);
// #MPOUT @TEXT("MPOUT", key="name", size=1.1, dx=1.5, dy=1);
// #MNOUT @PLACE(76, -18) => @ORIENT("R0");
// #MNOUT @SET-SYMBOL $NMOS;
// #MNOUT @TEXT("SVT 6.56u", key="model", size=1.05, dx=1.5, dy=-1);
// #MNOUT @TEXT("MNOUT", key="name", size=1.1, dx=1.5, dy=1);
// &AP @WIRE {#MPA0:1 #MPA1:3};
// (10, 28) @TEXT("AP", size=1.05);
// %j1 = (8, 16);
// &PCOND @WIRE {#MNA0:1 (0, 16) %j1 (16, 16) #MNA1:1};
// &PCOND @WIRE {#MPA1:1 %j1};
// #MGPN @PLACE(43, 9) => @ORIENT("R0");
// #MGPN @SET-SYMBOL $NMOS;
// #MGPN @TEXT("SVT 2.6u", key="model", size=1.05, dx=1.5, dy=-1);
// #MGPN @TEXT("MGPN", key="name", size=1.1, dx=1.5, dy=1);
// #MGPP @PLACE(43, 23) => @ORIENT("R0");
// #MGPP @SET-SYMBOL $PMOS;
// #MGPP @TEXT("SVT 3.89u", key="model", size=1.05, dx=1.5, dy=-1);
// #MGPP @TEXT("MGPP", key="name", size=1.1, dx=1.5, dy=1);
// %j2 = (43, 16);
// %j3 = (38, 16);
// &GP @WIRE {#MGPN:1 %j2 #MGPP:1};
// &PCOND @WIRE {#MGPN:2 (38, 9) %j3 (38, 23) #MGPP:2};
// &PCOND @WIRE {%j1 %j3};
// &GP @WIRE {%j2 (65, 16) (65, 18) #MPOUT:2};
// %j4 = (8, -16);
// &NOFF @WIRE {#MPB0:1 (0, -16) %j4 (16, -16) #MPB1:1};
// &NOFF @WIRE {#MNB0:1 %j4};
// &BN @WIRE {#MNB0:3 #MNB1:1};
// (18, -14) @TEXT("NOFF", size=1.05);
// #MGNN @PLACE(43, -23) => @ORIENT("R0");
// #MGNN @SET-SYMBOL $NMOS;
// #MGNN @TEXT("SVT 2.6u", key="model", size=1.05, dx=1.5, dy=-1);
// #MGNN @TEXT("MGNN", key="name", size=1.1, dx=1.5, dy=1);
// #MGNP @PLACE(43, -9) => @ORIENT("R0");
// #MGNP @SET-SYMBOL $PMOS;
// #MGNP @TEXT("SVT 1.3u", key="model", size=1.05, dx=1.5, dy=-1);
// #MGNP @TEXT("MGNP", key="name", size=1.1, dx=1.5, dy=1);
// %j5 = (43, -16);
// %j6 = (38, -16);
// &GN @WIRE {#MGNN:1 %j5 #MGNP:1};
// &NOFF @WIRE {#MGNN:2 (38, -23) %j6 (38, -9) #MGNP:2};
// &NOFF @WIRE {%j4 %j6};
// &GN @WIRE {%j5 (65, -16) (65, -18) #MNOUT:2};
// %j7 = (76, 0);
// &BP @WIRE {#MPOUT:1 %j7 #MNOUT:1};
// &BP @WIRE {%j7 (85, 0)};
// (85, 1) @TEXT("BP", size=1.05);
// (-5, 42) @TEXT("NOR: PCOND = ~(ENB | HIB)", size=1.05);
// (-5, -42) @TEXT("NAND: NOFF = ~(EN & HIB)", size=1.05);
// (31, 39) @TEXT("Reference gate drivers", size=1.05);
// (67, 39) @TEXT("Output rail switch", size=1.05);
// #MNDAP @PLACE(100, 24) => @ORIENT("R0");
// #MNDAP @SET-SYMBOL $NMOS;
// #MNDAP @TEXT("ULVT 0.325u", key="model", size=1.05, dx=1.5, dy=-1);
// #MNDAP @TEXT("MNDAP", key="name", size=1.1, dx=1.5, dy=1);
// #C_APLOAD @PLACE(113, 24) => @ORIENT("MX");
// #C_APLOAD @TEXT("", key="value");
// #C_APLOAD @TEXT("", key="name");
// (115, 25) @TEXT("C_APLOAD", size=1.05);
// (115, 23) @TEXT("7 Cu", size=1.05);
// #CP_APLOAD @PLACE(128, 24) => @ORIENT("R0");
// #CP_APLOAD @TEXT("", key="value");
// #CP_APLOAD @TEXT("", key="name");
// (130, 25) @TEXT("CP_APLOAD", size=1.05);
// (130, 23) @TEXT("0.3508 fF / 5%", size=1.05);
// %j8 = (113, 30);
// &AP @WIRE {#MNDAP:1 (100, 30) %j8 (128, 30) #CP_APLOAD:1};
// &AP @WIRE {#C_APLOAD:2 %j8};
// (113, 32) @TEXT("AP", size=1.05);
// #MNCANCEL @PLACE(109, -14) => @ORIENT("R0");
// #MNCANCEL @SET-SYMBOL $NMOS;
// #MNCANCEL @TEXT("ULVT 0.575u", key="model", size=1.05, dx=1.5, dy=-1);
// #MNCANCEL @TEXT("MNCANCEL", key="name", size=1.1, dx=1.5, dy=1);
// &NOFF @WIRE {#MNCANCEL:1 (115, -12) (115, -16) #MNCANCEL:3};
// (117, -14) @TEXT("NOFF", size=1.05);
// (96, 39) @TEXT("AP keeper + physical MOM load", size=1.05);
// (96, -25) @TEXT("ENB feedthrough cancellation", size=1.05);
// &ENB @WIRE {#MPA0:2 (3, 32)};
// (2.7, 32) @TEXT("ENB", size=1.05, halign="end", valign="middle");
// %t10 = $SUPPLY @ATTACH &DVDD => @PLACE(8, 36);
// &DVDD @WIRE {#MPA0:3 %t10:p};
// &HIB @WIRE {#MPA1:2 (3, 24)};
// (2.7, 24) @TEXT("HIB", size=1.05, halign="end", valign="middle");
// &ENB @WIRE {#MNA0:2 (-5, 8)};
// (-5.3, 8) @TEXT("ENB", size=1.05, halign="end", valign="middle");
// %t13 = $GROUND @ATTACH &VREFN => @PLACE(0, 4);
// &VREFN @WIRE {#MNA0:3 %t13:p};
// &HIB @WIRE {#MNA1:2 (11, 8)};
// (10.7, 8) @TEXT("HIB", size=1.05, halign="end", valign="middle");
// %t15 = $GROUND @ATTACH &VREFN => @PLACE(16, 4);
// &VREFN @WIRE {#MNA1:3 %t15:p};
// &EN @WIRE {#MPB0:2 (-5, -8)};
// (-5.3, -8) @TEXT("EN", size=1.05, halign="end", valign="middle");
// %t17 = $SUPPLY @ATTACH &DVDD => @PLACE(0, -4);
// &DVDD @WIRE {#MPB0:3 %t17:p};
// &HIB @WIRE {#MPB1:2 (11, -8)};
// (10.7, -8) @TEXT("HIB", size=1.05, halign="end", valign="middle");
// %t19 = $SUPPLY @ATTACH &DVDD => @PLACE(16, -4);
// &DVDD @WIRE {#MPB1:3 %t19:p};
// &EN @WIRE {#MNB0:2 (3, -24)};
// (2.7, -24) @TEXT("EN", size=1.05, halign="end", valign="middle");
// &HIB @WIRE {#MNB1:2 (3, -32)};
// (2.7, -32) @TEXT("HIB", size=1.05, halign="end", valign="middle");
// %t22 = $GROUND @ATTACH &VREFN => @PLACE(8, -36);
// &VREFN @WIRE {#MNB1:3 %t22:p};
// %t23 = $SUPPLY @ATTACH &VREFP => @PLACE(76, 22);
// &VREFP @WIRE {#MPOUT:3 %t23:p};
// %t24 = $GROUND @ATTACH &VREFN => @PLACE(76, -22);
// &VREFN @WIRE {#MNOUT:3 %t24:p};
// %t25 = $GROUND @ATTACH &VREFN => @PLACE(43, 5);
// &VREFN @WIRE {#MGPN:3 %t25:p};
// %t26 = $SUPPLY @ATTACH &VREFP => @PLACE(43, 27);
// &VREFP @WIRE {#MGPP:3 %t26:p};
// %t27 = $GROUND @ATTACH &VREFN => @PLACE(43, -27);
// &VREFN @WIRE {#MGNN:3 %t27:p};
// %t28 = $SUPPLY @ATTACH &VREFP => @PLACE(43, -5);
// &VREFP @WIRE {#MGNP:3 %t28:p};
// &ENB @WIRE {#MNDAP:2 (95, 24)};
// (94.7, 24) @TEXT("ENB", size=1.05, halign="end", valign="middle");
// %t30 = $GROUND @ATTACH &VREFN => @PLACE(100, 20);
// &VREFN @WIRE {#MNDAP:3 %t30:p};
// %t31 = $GROUND @ATTACH &VSS => @PLACE(113, 20);
// &VSS @WIRE {#C_APLOAD:1 %t31:p};
// %t32 = $GROUND @ATTACH &VSS => @PLACE(128, 20);
// &VSS @WIRE {#CP_APLOAD:2 %t32:p};
// &ENB @WIRE {#MNCANCEL:2 (104, -14)};
// (103.7, -14) @TEXT("ENB", size=1.05, halign="end", valign="middle");
// $JUNCTION @ATTACH %j1;
// $JUNCTION @ATTACH %j2;
// $JUNCTION @ATTACH %j3;
// $JUNCTION @ATTACH %j4;
// $JUNCTION @ATTACH %j5;
// $JUNCTION @ATTACH %j6;
// $JUNCTION @ATTACH %j7;
// $JUNCTION @ATTACH %j8;
// (-7, 51) @TEXT("V29 diagnostic only / NOT qualified | mq_cdac_drv10 | isolated DVDD logic / VREFP output", size=1.4, bold=true, textcolor="#17365d");
// (-7, 48.6) @TEXT("Drawing only | N bulk = VSS; L = 30 nm. P bulk DVDD: MPA0, MPA1, MPB0, MPB1; VREFP: MGPP, MGNP, MPOUT", size=1.05, textcolor="#52606d");
// }
ends mq_cdac_drv10

subckt mq_cdac_drv9 (HIB EN ENB BP VREFP VREFN VSS DVDD)
// DVDD prelogic: PCOND = NOR(ENB,HIB); NOFF = NAND(EN,HIB).
// Reference-powered final inverters restore GP and GN to VREFP/VREFN.
// Actual current overlap, settling and device stress require measurement.
MPA0 (AP ENB DVDD DVDD) pch_ulvt_mac w=1.47e-06 l=3e-08 nf=1
MPA1 (PCOND HIB AP DVDD) pch_ulvt_mac w=1.47e-06 l=3e-08 nf=1
MNA0 (PCOND ENB VREFN VSS) nch_ulvt_mac w=7.35e-07 l=3e-08 nf=1
MNA1 (PCOND HIB VREFN VSS) nch_ulvt_mac w=7.35e-07 l=3e-08 nf=1
MPB0 (NOFF EN DVDD DVDD) pch_ulvt_mac w=7.35e-07 l=3e-08 nf=1
MPB1 (NOFF HIB DVDD DVDD) pch_ulvt_mac w=7.35e-07 l=3e-08 nf=1
MNB0 (NOFF EN BN VSS) nch_ulvt_mac w=3.25e-07 l=3e-08 nf=1
MNB1 (BN HIB VREFN VSS) nch_ulvt_mac w=2e-06 l=3e-08 nf=1
MGPN (GP PCOND VREFN VSS) nch_mac w=1.47e-06 l=3e-08 nf=1
MGPP (GP PCOND VREFP VREFP) pch_mac w=2.2e-06 l=3e-08 nf=2
MGNN (GN NOFF VREFN VSS) nch_mac w=1.47e-06 l=3e-08 nf=1
MGNP (GN NOFF VREFP VREFP) pch_mac w=7.35e-07 l=3e-08 nf=1
MNOUT (BP GN VREFN VSS) nch_mac w=1.113e-05 l=3e-08 nf=6
MPOUT (BP GP VREFP VREFP) pch_mac w=2.226e-05 l=3e-08 nf=12
// Actively discharge AP while ENB turns the upper PMOS off.
MNDAP (AP ENB VREFN VSS) nch_ulvt_mac w=1.85e-07 l=3e-08 nf=1
// 4 existing physical MOM units, with 5% bottom Cp, slow AP feedthrough.
C_APLOAD (VSS AP) cfmom_2t w=5e-08 s=2.4e-07 nr=6 lr=1.69e-06 stm=2 spm=4 multi=4
CP_APLOAD (AP VSS) capacitor c=2.00458e-16
MNCANCEL (NOFF ENB NOFF VSS) nch_ulvt_mac w=3.25e-07 l=3e-08 nf=1
// @RNL {
// {&HIB &EN &ENB &BP &VREFP &VREFN &VSS &DVDD} @REMOVE-FROM $PORT_FILL_SET;
// &VSS @ADD-TO $GROUND_NET_SET;
// &VREFN @ADD-TO $GROUND_NET_SET;
// #MPA0 @PLACE(8, 32) => @ORIENT("R0");
// #MPA0 @SET-SYMBOL $PMOS;
// #MPA0 @TEXT("ULVT 1.47u", key="model", size=1.05, dx=1.5, dy=-1);
// #MPA0 @TEXT("MPA0", key="name", size=1.1, dx=1.5, dy=1);
// #MPA1 @PLACE(8, 24) => @ORIENT("R0");
// #MPA1 @SET-SYMBOL $PMOS;
// #MPA1 @TEXT("ULVT 1.47u", key="model", size=1.05, dx=1.5, dy=-1);
// #MPA1 @TEXT("MPA1", key="name", size=1.1, dx=1.5, dy=1);
// #MNA0 @PLACE(0, 8) => @ORIENT("R0");
// #MNA0 @SET-SYMBOL $NMOS;
// #MNA0 @TEXT("ULVT 0.735u", key="model", size=1.05, dx=1.5, dy=-1);
// #MNA0 @TEXT("MNA0", key="name", size=1.1, dx=1.5, dy=1);
// #MNA1 @PLACE(16, 8) => @ORIENT("R0");
// #MNA1 @SET-SYMBOL $NMOS;
// #MNA1 @TEXT("ULVT 0.735u", key="model", size=1.05, dx=1.5, dy=-1);
// #MNA1 @TEXT("MNA1", key="name", size=1.1, dx=1.5, dy=1);
// #MPB0 @PLACE(0, -8) => @ORIENT("R0");
// #MPB0 @SET-SYMBOL $PMOS;
// #MPB0 @TEXT("ULVT 0.735u", key="model", size=1.05, dx=1.5, dy=-1);
// #MPB0 @TEXT("MPB0", key="name", size=1.1, dx=1.5, dy=1);
// #MPB1 @PLACE(16, -8) => @ORIENT("R0");
// #MPB1 @SET-SYMBOL $PMOS;
// #MPB1 @TEXT("ULVT 0.735u", key="model", size=1.05, dx=1.5, dy=-1);
// #MPB1 @TEXT("MPB1", key="name", size=1.1, dx=1.5, dy=1);
// #MNB0 @PLACE(8, -24) => @ORIENT("R0");
// #MNB0 @SET-SYMBOL $NMOS;
// #MNB0 @TEXT("ULVT 0.325u", key="model", size=1.05, dx=1.5, dy=-1);
// #MNB0 @TEXT("MNB0", key="name", size=1.1, dx=1.5, dy=1);
// #MNB1 @PLACE(8, -32) => @ORIENT("R0");
// #MNB1 @SET-SYMBOL $NMOS;
// #MNB1 @TEXT("ULVT 2u", key="model", size=1.05, dx=1.5, dy=-1);
// #MNB1 @TEXT("MNB1", key="name", size=1.1, dx=1.5, dy=1);
// #MPOUT @PLACE(76, 18) => @ORIENT("R0");
// #MPOUT @SET-SYMBOL $PMOS;
// #MPOUT @TEXT("SVT 22.26u", key="model", size=1.05, dx=1.5, dy=-1);
// #MPOUT @TEXT("MPOUT", key="name", size=1.1, dx=1.5, dy=1);
// #MNOUT @PLACE(76, -18) => @ORIENT("R0");
// #MNOUT @SET-SYMBOL $NMOS;
// #MNOUT @TEXT("SVT 11.13u", key="model", size=1.05, dx=1.5, dy=-1);
// #MNOUT @TEXT("MNOUT", key="name", size=1.1, dx=1.5, dy=1);
// &AP @WIRE {#MPA0:1 #MPA1:3};
// (10, 28) @TEXT("AP", size=1.05);
// %j1 = (8, 16);
// &PCOND @WIRE {#MNA0:1 (0, 16) %j1 (16, 16) #MNA1:1};
// &PCOND @WIRE {#MPA1:1 %j1};
// #MGPN @PLACE(43, 9) => @ORIENT("R0");
// #MGPN @SET-SYMBOL $NMOS;
// #MGPN @TEXT("SVT 1.47u", key="model", size=1.05, dx=1.5, dy=-1);
// #MGPN @TEXT("MGPN", key="name", size=1.1, dx=1.5, dy=1);
// #MGPP @PLACE(43, 23) => @ORIENT("R0");
// #MGPP @SET-SYMBOL $PMOS;
// #MGPP @TEXT("SVT 2.2u", key="model", size=1.05, dx=1.5, dy=-1);
// #MGPP @TEXT("MGPP", key="name", size=1.1, dx=1.5, dy=1);
// %j2 = (43, 16);
// %j3 = (38, 16);
// &GP @WIRE {#MGPN:1 %j2 #MGPP:1};
// &PCOND @WIRE {#MGPN:2 (38, 9) %j3 (38, 23) #MGPP:2};
// &PCOND @WIRE {%j1 %j3};
// &GP @WIRE {%j2 (65, 16) (65, 18) #MPOUT:2};
// %j4 = (8, -16);
// &NOFF @WIRE {#MPB0:1 (0, -16) %j4 (16, -16) #MPB1:1};
// &NOFF @WIRE {#MNB0:1 %j4};
// &BN @WIRE {#MNB0:3 #MNB1:1};
// (18, -14) @TEXT("NOFF", size=1.05);
// #MGNN @PLACE(43, -23) => @ORIENT("R0");
// #MGNN @SET-SYMBOL $NMOS;
// #MGNN @TEXT("SVT 1.47u", key="model", size=1.05, dx=1.5, dy=-1);
// #MGNN @TEXT("MGNN", key="name", size=1.1, dx=1.5, dy=1);
// #MGNP @PLACE(43, -9) => @ORIENT("R0");
// #MGNP @SET-SYMBOL $PMOS;
// #MGNP @TEXT("SVT 0.735u", key="model", size=1.05, dx=1.5, dy=-1);
// #MGNP @TEXT("MGNP", key="name", size=1.1, dx=1.5, dy=1);
// %j5 = (43, -16);
// %j6 = (38, -16);
// &GN @WIRE {#MGNN:1 %j5 #MGNP:1};
// &NOFF @WIRE {#MGNN:2 (38, -23) %j6 (38, -9) #MGNP:2};
// &NOFF @WIRE {%j4 %j6};
// &GN @WIRE {%j5 (65, -16) (65, -18) #MNOUT:2};
// %j7 = (76, 0);
// &BP @WIRE {#MPOUT:1 %j7 #MNOUT:1};
// &BP @WIRE {%j7 (85, 0)};
// (85, 1) @TEXT("BP", size=1.05);
// (-5, 42) @TEXT("NOR: PCOND = ~(ENB | HIB)", size=1.05);
// (-5, -42) @TEXT("NAND: NOFF = ~(EN & HIB)", size=1.05);
// (31, 39) @TEXT("Reference gate drivers", size=1.05);
// (67, 39) @TEXT("Output rail switch", size=1.05);
// #MNDAP @PLACE(100, 24) => @ORIENT("R0");
// #MNDAP @SET-SYMBOL $NMOS;
// #MNDAP @TEXT("ULVT 0.185u", key="model", size=1.05, dx=1.5, dy=-1);
// #MNDAP @TEXT("MNDAP", key="name", size=1.1, dx=1.5, dy=1);
// #C_APLOAD @PLACE(113, 24) => @ORIENT("MX");
// #C_APLOAD @TEXT("", key="value");
// #C_APLOAD @TEXT("", key="name");
// (115, 25) @TEXT("C_APLOAD", size=1.05);
// (115, 23) @TEXT("4 Cu", size=1.05);
// #CP_APLOAD @PLACE(128, 24) => @ORIENT("R0");
// #CP_APLOAD @TEXT("", key="value");
// #CP_APLOAD @TEXT("", key="name");
// (130, 25) @TEXT("CP_APLOAD", size=1.05);
// (130, 23) @TEXT("0.2005 fF / 5%", size=1.05);
// %j8 = (113, 30);
// &AP @WIRE {#MNDAP:1 (100, 30) %j8 (128, 30) #CP_APLOAD:1};
// &AP @WIRE {#C_APLOAD:2 %j8};
// (113, 32) @TEXT("AP", size=1.05);
// #MNCANCEL @PLACE(109, -14) => @ORIENT("R0");
// #MNCANCEL @SET-SYMBOL $NMOS;
// #MNCANCEL @TEXT("ULVT 0.325u", key="model", size=1.05, dx=1.5, dy=-1);
// #MNCANCEL @TEXT("MNCANCEL", key="name", size=1.1, dx=1.5, dy=1);
// &NOFF @WIRE {#MNCANCEL:1 (115, -12) (115, -16) #MNCANCEL:3};
// (117, -14) @TEXT("NOFF", size=1.05);
// (96, 39) @TEXT("AP keeper + physical MOM load", size=1.05);
// (96, -25) @TEXT("ENB feedthrough cancellation", size=1.05);
// &ENB @WIRE {#MPA0:2 (3, 32)};
// (2.7, 32) @TEXT("ENB", size=1.05, halign="end", valign="middle");
// %t10 = $SUPPLY @ATTACH &DVDD => @PLACE(8, 36);
// &DVDD @WIRE {#MPA0:3 %t10:p};
// &HIB @WIRE {#MPA1:2 (3, 24)};
// (2.7, 24) @TEXT("HIB", size=1.05, halign="end", valign="middle");
// &ENB @WIRE {#MNA0:2 (-5, 8)};
// (-5.3, 8) @TEXT("ENB", size=1.05, halign="end", valign="middle");
// %t13 = $GROUND @ATTACH &VREFN => @PLACE(0, 4);
// &VREFN @WIRE {#MNA0:3 %t13:p};
// &HIB @WIRE {#MNA1:2 (11, 8)};
// (10.7, 8) @TEXT("HIB", size=1.05, halign="end", valign="middle");
// %t15 = $GROUND @ATTACH &VREFN => @PLACE(16, 4);
// &VREFN @WIRE {#MNA1:3 %t15:p};
// &EN @WIRE {#MPB0:2 (-5, -8)};
// (-5.3, -8) @TEXT("EN", size=1.05, halign="end", valign="middle");
// %t17 = $SUPPLY @ATTACH &DVDD => @PLACE(0, -4);
// &DVDD @WIRE {#MPB0:3 %t17:p};
// &HIB @WIRE {#MPB1:2 (11, -8)};
// (10.7, -8) @TEXT("HIB", size=1.05, halign="end", valign="middle");
// %t19 = $SUPPLY @ATTACH &DVDD => @PLACE(16, -4);
// &DVDD @WIRE {#MPB1:3 %t19:p};
// &EN @WIRE {#MNB0:2 (3, -24)};
// (2.7, -24) @TEXT("EN", size=1.05, halign="end", valign="middle");
// &HIB @WIRE {#MNB1:2 (3, -32)};
// (2.7, -32) @TEXT("HIB", size=1.05, halign="end", valign="middle");
// %t22 = $GROUND @ATTACH &VREFN => @PLACE(8, -36);
// &VREFN @WIRE {#MNB1:3 %t22:p};
// %t23 = $SUPPLY @ATTACH &VREFP => @PLACE(76, 22);
// &VREFP @WIRE {#MPOUT:3 %t23:p};
// %t24 = $GROUND @ATTACH &VREFN => @PLACE(76, -22);
// &VREFN @WIRE {#MNOUT:3 %t24:p};
// %t25 = $GROUND @ATTACH &VREFN => @PLACE(43, 5);
// &VREFN @WIRE {#MGPN:3 %t25:p};
// %t26 = $SUPPLY @ATTACH &VREFP => @PLACE(43, 27);
// &VREFP @WIRE {#MGPP:3 %t26:p};
// %t27 = $GROUND @ATTACH &VREFN => @PLACE(43, -27);
// &VREFN @WIRE {#MGNN:3 %t27:p};
// %t28 = $SUPPLY @ATTACH &VREFP => @PLACE(43, -5);
// &VREFP @WIRE {#MGNP:3 %t28:p};
// &ENB @WIRE {#MNDAP:2 (95, 24)};
// (94.7, 24) @TEXT("ENB", size=1.05, halign="end", valign="middle");
// %t30 = $GROUND @ATTACH &VREFN => @PLACE(100, 20);
// &VREFN @WIRE {#MNDAP:3 %t30:p};
// %t31 = $GROUND @ATTACH &VSS => @PLACE(113, 20);
// &VSS @WIRE {#C_APLOAD:1 %t31:p};
// %t32 = $GROUND @ATTACH &VSS => @PLACE(128, 20);
// &VSS @WIRE {#CP_APLOAD:2 %t32:p};
// &ENB @WIRE {#MNCANCEL:2 (104, -14)};
// (103.7, -14) @TEXT("ENB", size=1.05, halign="end", valign="middle");
// $JUNCTION @ATTACH %j1;
// $JUNCTION @ATTACH %j2;
// $JUNCTION @ATTACH %j3;
// $JUNCTION @ATTACH %j4;
// $JUNCTION @ATTACH %j5;
// $JUNCTION @ATTACH %j6;
// $JUNCTION @ATTACH %j7;
// $JUNCTION @ATTACH %j8;
// (-7, 51) @TEXT("V29 diagnostic only / NOT qualified | mq_cdac_drv9 | isolated DVDD logic / VREFP output", size=1.4, bold=true, textcolor="#17365d");
// (-7, 48.6) @TEXT("Drawing only | N bulk = VSS; L = 30 nm. P bulk DVDD: MPA0, MPA1, MPB0, MPB1; VREFP: MGPP, MGNP, MPOUT", size=1.05, textcolor="#52606d");
// }
ends mq_cdac_drv9

subckt mq_cdac_drv8 (HIB EN ENB BP VREFP VREFN VSS DVDD)
// DVDD prelogic: PCOND = NOR(ENB,HIB); NOFF = NAND(EN,HIB).
// Reference-powered final inverters restore GP and GN to VREFP/VREFN.
// Actual current overlap, settling and device stress require measurement.
MPA0 (AP ENB DVDD DVDD) pch_ulvt_mac w=8.35e-07 l=3e-08 nf=1
MPA1 (PCOND HIB AP DVDD) pch_ulvt_mac w=8.35e-07 l=3e-08 nf=1
MNA0 (PCOND ENB VREFN VSS) nch_ulvt_mac w=4.15e-07 l=3e-08 nf=1
MNA1 (PCOND HIB VREFN VSS) nch_ulvt_mac w=4.15e-07 l=3e-08 nf=1
MPB0 (NOFF EN DVDD DVDD) pch_ulvt_mac w=4.15e-07 l=3e-08 nf=1
MPB1 (NOFF HIB DVDD DVDD) pch_ulvt_mac w=4.15e-07 l=3e-08 nf=1
MNB0 (NOFF EN BN VSS) nch_ulvt_mac w=1.85e-07 l=3e-08 nf=1
MNB1 (BN HIB VREFN VSS) nch_ulvt_mac w=1e-06 l=3e-08 nf=1
MGPN (GP PCOND VREFN VSS) nch_mac w=8.35e-07 l=3e-08 nf=1
MGPP (GP PCOND VREFP VREFP) pch_mac w=1.25e-06 l=3e-08 nf=1
MGNN (GN NOFF VREFN VSS) nch_mac w=8.35e-07 l=3e-08 nf=1
MGNP (GN NOFF VREFP VREFP) pch_mac w=4.15e-07 l=3e-08 nf=1
MNOUT (BP GN VREFN VSS) nch_mac w=2.11e-06 l=3e-08 nf=2
MPOUT (BP GP VREFP VREFP) pch_mac w=4.215e-06 l=3e-08 nf=3
// Actively discharge AP while ENB turns the upper PMOS off.
MNDAP (AP ENB VREFN VSS) nch_ulvt_mac w=1.2e-07 l=3e-08 nf=1
// 3 existing physical MOM units, with 5% bottom Cp, slow AP feedthrough.
C_APLOAD (VSS AP) cfmom_2t w=5e-08 s=2.4e-07 nr=6 lr=1.69e-06 stm=2 spm=4 multi=3
CP_APLOAD (AP VSS) capacitor c=1.503435e-16
MNCANCEL (NOFF ENB NOFF VSS) nch_ulvt_mac w=1.85e-07 l=3e-08 nf=1
// @RNL {
// {&HIB &EN &ENB &BP &VREFP &VREFN &VSS &DVDD} @REMOVE-FROM $PORT_FILL_SET;
// &VSS @ADD-TO $GROUND_NET_SET;
// &VREFN @ADD-TO $GROUND_NET_SET;
// #MPA0 @PLACE(8, 32) => @ORIENT("R0");
// #MPA0 @SET-SYMBOL $PMOS;
// #MPA0 @TEXT("ULVT 0.835u", key="model", size=1.05, dx=1.5, dy=-1);
// #MPA0 @TEXT("MPA0", key="name", size=1.1, dx=1.5, dy=1);
// #MPA1 @PLACE(8, 24) => @ORIENT("R0");
// #MPA1 @SET-SYMBOL $PMOS;
// #MPA1 @TEXT("ULVT 0.835u", key="model", size=1.05, dx=1.5, dy=-1);
// #MPA1 @TEXT("MPA1", key="name", size=1.1, dx=1.5, dy=1);
// #MNA0 @PLACE(0, 8) => @ORIENT("R0");
// #MNA0 @SET-SYMBOL $NMOS;
// #MNA0 @TEXT("ULVT 0.415u", key="model", size=1.05, dx=1.5, dy=-1);
// #MNA0 @TEXT("MNA0", key="name", size=1.1, dx=1.5, dy=1);
// #MNA1 @PLACE(16, 8) => @ORIENT("R0");
// #MNA1 @SET-SYMBOL $NMOS;
// #MNA1 @TEXT("ULVT 0.415u", key="model", size=1.05, dx=1.5, dy=-1);
// #MNA1 @TEXT("MNA1", key="name", size=1.1, dx=1.5, dy=1);
// #MPB0 @PLACE(0, -8) => @ORIENT("R0");
// #MPB0 @SET-SYMBOL $PMOS;
// #MPB0 @TEXT("ULVT 0.415u", key="model", size=1.05, dx=1.5, dy=-1);
// #MPB0 @TEXT("MPB0", key="name", size=1.1, dx=1.5, dy=1);
// #MPB1 @PLACE(16, -8) => @ORIENT("R0");
// #MPB1 @SET-SYMBOL $PMOS;
// #MPB1 @TEXT("ULVT 0.415u", key="model", size=1.05, dx=1.5, dy=-1);
// #MPB1 @TEXT("MPB1", key="name", size=1.1, dx=1.5, dy=1);
// #MNB0 @PLACE(8, -24) => @ORIENT("R0");
// #MNB0 @SET-SYMBOL $NMOS;
// #MNB0 @TEXT("ULVT 0.185u", key="model", size=1.05, dx=1.5, dy=-1);
// #MNB0 @TEXT("MNB0", key="name", size=1.1, dx=1.5, dy=1);
// #MNB1 @PLACE(8, -32) => @ORIENT("R0");
// #MNB1 @SET-SYMBOL $NMOS;
// #MNB1 @TEXT("ULVT 1u", key="model", size=1.05, dx=1.5, dy=-1);
// #MNB1 @TEXT("MNB1", key="name", size=1.1, dx=1.5, dy=1);
// #MPOUT @PLACE(76, 18) => @ORIENT("R0");
// #MPOUT @SET-SYMBOL $PMOS;
// #MPOUT @TEXT("SVT 4.215u", key="model", size=1.05, dx=1.5, dy=-1);
// #MPOUT @TEXT("MPOUT", key="name", size=1.1, dx=1.5, dy=1);
// #MNOUT @PLACE(76, -18) => @ORIENT("R0");
// #MNOUT @SET-SYMBOL $NMOS;
// #MNOUT @TEXT("SVT 2.11u", key="model", size=1.05, dx=1.5, dy=-1);
// #MNOUT @TEXT("MNOUT", key="name", size=1.1, dx=1.5, dy=1);
// &AP @WIRE {#MPA0:1 #MPA1:3};
// (10, 28) @TEXT("AP", size=1.05);
// %j1 = (8, 16);
// &PCOND @WIRE {#MNA0:1 (0, 16) %j1 (16, 16) #MNA1:1};
// &PCOND @WIRE {#MPA1:1 %j1};
// #MGPN @PLACE(43, 9) => @ORIENT("R0");
// #MGPN @SET-SYMBOL $NMOS;
// #MGPN @TEXT("SVT 0.835u", key="model", size=1.05, dx=1.5, dy=-1);
// #MGPN @TEXT("MGPN", key="name", size=1.1, dx=1.5, dy=1);
// #MGPP @PLACE(43, 23) => @ORIENT("R0");
// #MGPP @SET-SYMBOL $PMOS;
// #MGPP @TEXT("SVT 1.25u", key="model", size=1.05, dx=1.5, dy=-1);
// #MGPP @TEXT("MGPP", key="name", size=1.1, dx=1.5, dy=1);
// %j2 = (43, 16);
// %j3 = (38, 16);
// &GP @WIRE {#MGPN:1 %j2 #MGPP:1};
// &PCOND @WIRE {#MGPN:2 (38, 9) %j3 (38, 23) #MGPP:2};
// &PCOND @WIRE {%j1 %j3};
// &GP @WIRE {%j2 (65, 16) (65, 18) #MPOUT:2};
// %j4 = (8, -16);
// &NOFF @WIRE {#MPB0:1 (0, -16) %j4 (16, -16) #MPB1:1};
// &NOFF @WIRE {#MNB0:1 %j4};
// &BN @WIRE {#MNB0:3 #MNB1:1};
// (18, -14) @TEXT("NOFF", size=1.05);
// #MGNN @PLACE(43, -23) => @ORIENT("R0");
// #MGNN @SET-SYMBOL $NMOS;
// #MGNN @TEXT("SVT 0.835u", key="model", size=1.05, dx=1.5, dy=-1);
// #MGNN @TEXT("MGNN", key="name", size=1.1, dx=1.5, dy=1);
// #MGNP @PLACE(43, -9) => @ORIENT("R0");
// #MGNP @SET-SYMBOL $PMOS;
// #MGNP @TEXT("SVT 0.415u", key="model", size=1.05, dx=1.5, dy=-1);
// #MGNP @TEXT("MGNP", key="name", size=1.1, dx=1.5, dy=1);
// %j5 = (43, -16);
// %j6 = (38, -16);
// &GN @WIRE {#MGNN:1 %j5 #MGNP:1};
// &NOFF @WIRE {#MGNN:2 (38, -23) %j6 (38, -9) #MGNP:2};
// &NOFF @WIRE {%j4 %j6};
// &GN @WIRE {%j5 (65, -16) (65, -18) #MNOUT:2};
// %j7 = (76, 0);
// &BP @WIRE {#MPOUT:1 %j7 #MNOUT:1};
// &BP @WIRE {%j7 (85, 0)};
// (85, 1) @TEXT("BP", size=1.05);
// (-5, 42) @TEXT("NOR: PCOND = ~(ENB | HIB)", size=1.05);
// (-5, -42) @TEXT("NAND: NOFF = ~(EN & HIB)", size=1.05);
// (31, 39) @TEXT("Reference gate drivers", size=1.05);
// (67, 39) @TEXT("Output rail switch", size=1.05);
// #MNDAP @PLACE(100, 24) => @ORIENT("R0");
// #MNDAP @SET-SYMBOL $NMOS;
// #MNDAP @TEXT("ULVT 0.12u", key="model", size=1.05, dx=1.5, dy=-1);
// #MNDAP @TEXT("MNDAP", key="name", size=1.1, dx=1.5, dy=1);
// #C_APLOAD @PLACE(113, 24) => @ORIENT("MX");
// #C_APLOAD @TEXT("", key="value");
// #C_APLOAD @TEXT("", key="name");
// (115, 25) @TEXT("C_APLOAD", size=1.05);
// (115, 23) @TEXT("3 Cu", size=1.05);
// #CP_APLOAD @PLACE(128, 24) => @ORIENT("R0");
// #CP_APLOAD @TEXT("", key="value");
// #CP_APLOAD @TEXT("", key="name");
// (130, 25) @TEXT("CP_APLOAD", size=1.05);
// (130, 23) @TEXT("0.1503 fF / 5%", size=1.05);
// %j8 = (113, 30);
// &AP @WIRE {#MNDAP:1 (100, 30) %j8 (128, 30) #CP_APLOAD:1};
// &AP @WIRE {#C_APLOAD:2 %j8};
// (113, 32) @TEXT("AP", size=1.05);
// #MNCANCEL @PLACE(109, -14) => @ORIENT("R0");
// #MNCANCEL @SET-SYMBOL $NMOS;
// #MNCANCEL @TEXT("ULVT 0.185u", key="model", size=1.05, dx=1.5, dy=-1);
// #MNCANCEL @TEXT("MNCANCEL", key="name", size=1.1, dx=1.5, dy=1);
// &NOFF @WIRE {#MNCANCEL:1 (115, -12) (115, -16) #MNCANCEL:3};
// (117, -14) @TEXT("NOFF", size=1.05);
// (96, 39) @TEXT("AP keeper + physical MOM load", size=1.05);
// (96, -25) @TEXT("ENB feedthrough cancellation", size=1.05);
// &ENB @WIRE {#MPA0:2 (3, 32)};
// (2.7, 32) @TEXT("ENB", size=1.05, halign="end", valign="middle");
// %t10 = $SUPPLY @ATTACH &DVDD => @PLACE(8, 36);
// &DVDD @WIRE {#MPA0:3 %t10:p};
// &HIB @WIRE {#MPA1:2 (3, 24)};
// (2.7, 24) @TEXT("HIB", size=1.05, halign="end", valign="middle");
// &ENB @WIRE {#MNA0:2 (-5, 8)};
// (-5.3, 8) @TEXT("ENB", size=1.05, halign="end", valign="middle");
// %t13 = $GROUND @ATTACH &VREFN => @PLACE(0, 4);
// &VREFN @WIRE {#MNA0:3 %t13:p};
// &HIB @WIRE {#MNA1:2 (11, 8)};
// (10.7, 8) @TEXT("HIB", size=1.05, halign="end", valign="middle");
// %t15 = $GROUND @ATTACH &VREFN => @PLACE(16, 4);
// &VREFN @WIRE {#MNA1:3 %t15:p};
// &EN @WIRE {#MPB0:2 (-5, -8)};
// (-5.3, -8) @TEXT("EN", size=1.05, halign="end", valign="middle");
// %t17 = $SUPPLY @ATTACH &DVDD => @PLACE(0, -4);
// &DVDD @WIRE {#MPB0:3 %t17:p};
// &HIB @WIRE {#MPB1:2 (11, -8)};
// (10.7, -8) @TEXT("HIB", size=1.05, halign="end", valign="middle");
// %t19 = $SUPPLY @ATTACH &DVDD => @PLACE(16, -4);
// &DVDD @WIRE {#MPB1:3 %t19:p};
// &EN @WIRE {#MNB0:2 (3, -24)};
// (2.7, -24) @TEXT("EN", size=1.05, halign="end", valign="middle");
// &HIB @WIRE {#MNB1:2 (3, -32)};
// (2.7, -32) @TEXT("HIB", size=1.05, halign="end", valign="middle");
// %t22 = $GROUND @ATTACH &VREFN => @PLACE(8, -36);
// &VREFN @WIRE {#MNB1:3 %t22:p};
// %t23 = $SUPPLY @ATTACH &VREFP => @PLACE(76, 22);
// &VREFP @WIRE {#MPOUT:3 %t23:p};
// %t24 = $GROUND @ATTACH &VREFN => @PLACE(76, -22);
// &VREFN @WIRE {#MNOUT:3 %t24:p};
// %t25 = $GROUND @ATTACH &VREFN => @PLACE(43, 5);
// &VREFN @WIRE {#MGPN:3 %t25:p};
// %t26 = $SUPPLY @ATTACH &VREFP => @PLACE(43, 27);
// &VREFP @WIRE {#MGPP:3 %t26:p};
// %t27 = $GROUND @ATTACH &VREFN => @PLACE(43, -27);
// &VREFN @WIRE {#MGNN:3 %t27:p};
// %t28 = $SUPPLY @ATTACH &VREFP => @PLACE(43, -5);
// &VREFP @WIRE {#MGNP:3 %t28:p};
// &ENB @WIRE {#MNDAP:2 (95, 24)};
// (94.7, 24) @TEXT("ENB", size=1.05, halign="end", valign="middle");
// %t30 = $GROUND @ATTACH &VREFN => @PLACE(100, 20);
// &VREFN @WIRE {#MNDAP:3 %t30:p};
// %t31 = $GROUND @ATTACH &VSS => @PLACE(113, 20);
// &VSS @WIRE {#C_APLOAD:1 %t31:p};
// %t32 = $GROUND @ATTACH &VSS => @PLACE(128, 20);
// &VSS @WIRE {#CP_APLOAD:2 %t32:p};
// &ENB @WIRE {#MNCANCEL:2 (104, -14)};
// (103.7, -14) @TEXT("ENB", size=1.05, halign="end", valign="middle");
// $JUNCTION @ATTACH %j1;
// $JUNCTION @ATTACH %j2;
// $JUNCTION @ATTACH %j3;
// $JUNCTION @ATTACH %j4;
// $JUNCTION @ATTACH %j5;
// $JUNCTION @ATTACH %j6;
// $JUNCTION @ATTACH %j7;
// $JUNCTION @ATTACH %j8;
// (-7, 51) @TEXT("V29 diagnostic only / NOT qualified | mq_cdac_drv8 | isolated DVDD logic / VREFP output", size=1.4, bold=true, textcolor="#17365d");
// (-7, 48.6) @TEXT("Drawing only | N bulk = VSS; L = 30 nm. P bulk DVDD: MPA0, MPA1, MPB0, MPB1; VREFP: MGPP, MGNP, MPOUT", size=1.05, textcolor="#52606d");
// }
ends mq_cdac_drv8

subckt mq_cdac_drv7 (HIB EN ENB BP VREFP VREFN VSS DVDD)
// DVDD prelogic: PCOND = NOR(ENB,HIB); NOFF = NAND(EN,HIB).
// Reference-powered final inverters restore GP and GN to VREFP/VREFN.
// Actual current overlap, settling and device stress require measurement.
MPA0 (AP ENB DVDD DVDD) pch_ulvt_mac w=4.65e-07 l=3e-08 nf=1
MPA1 (PCOND HIB AP DVDD) pch_ulvt_mac w=4.65e-07 l=3e-08 nf=1
MNA0 (PCOND ENB VREFN VSS) nch_ulvt_mac w=2.35e-07 l=3e-08 nf=1
MNA1 (PCOND HIB VREFN VSS) nch_ulvt_mac w=2.35e-07 l=3e-08 nf=1
MPB0 (NOFF EN DVDD DVDD) pch_ulvt_mac w=2.35e-07 l=3e-08 nf=1
MPB1 (NOFF HIB DVDD DVDD) pch_ulvt_mac w=2.35e-07 l=3e-08 nf=1
MNB0 (NOFF EN BN VSS) nch_ulvt_mac w=1.2e-07 l=3e-08 nf=1
MNB1 (BN HIB VREFN VSS) nch_ulvt_mac w=5.75e-07 l=3e-08 nf=1
MGPN (GP PCOND VREFN VSS) nch_mac w=4.65e-07 l=3e-08 nf=1
MGPP (GP PCOND VREFP VREFP) pch_mac w=7e-07 l=3e-08 nf=1
MGNN (GN NOFF VREFN VSS) nch_mac w=4.65e-07 l=3e-08 nf=1
MGNP (GN NOFF VREFP VREFP) pch_mac w=2.35e-07 l=3e-08 nf=1
MNOUT (BP GN VREFN VSS) nch_mac w=1.18e-06 l=3e-08 nf=1
MPOUT (BP GP VREFP VREFP) pch_mac w=2.36e-06 l=3e-08 nf=2
// Actively discharge AP while ENB turns the upper PMOS off.
MNDAP (AP ENB VREFN VSS) nch_ulvt_mac w=1.2e-07 l=3e-08 nf=1
// 2 existing physical MOM units, with 5% bottom Cp, slow AP feedthrough.
C_APLOAD (VSS AP) cfmom_2t w=5e-08 s=2.4e-07 nr=6 lr=1.69e-06 stm=2 spm=4 multi=2
CP_APLOAD (AP VSS) capacitor c=1.00229e-16
MNCANCEL (NOFF ENB NOFF VSS) nch_ulvt_mac w=1.2e-07 l=3e-08 nf=1
// @RNL {
// {&HIB &EN &ENB &BP &VREFP &VREFN &VSS &DVDD} @REMOVE-FROM $PORT_FILL_SET;
// &VSS @ADD-TO $GROUND_NET_SET;
// &VREFN @ADD-TO $GROUND_NET_SET;
// #MPA0 @PLACE(8, 32) => @ORIENT("R0");
// #MPA0 @SET-SYMBOL $PMOS;
// #MPA0 @TEXT("ULVT 0.465u", key="model", size=1.05, dx=1.5, dy=-1);
// #MPA0 @TEXT("MPA0", key="name", size=1.1, dx=1.5, dy=1);
// #MPA1 @PLACE(8, 24) => @ORIENT("R0");
// #MPA1 @SET-SYMBOL $PMOS;
// #MPA1 @TEXT("ULVT 0.465u", key="model", size=1.05, dx=1.5, dy=-1);
// #MPA1 @TEXT("MPA1", key="name", size=1.1, dx=1.5, dy=1);
// #MNA0 @PLACE(0, 8) => @ORIENT("R0");
// #MNA0 @SET-SYMBOL $NMOS;
// #MNA0 @TEXT("ULVT 0.235u", key="model", size=1.05, dx=1.5, dy=-1);
// #MNA0 @TEXT("MNA0", key="name", size=1.1, dx=1.5, dy=1);
// #MNA1 @PLACE(16, 8) => @ORIENT("R0");
// #MNA1 @SET-SYMBOL $NMOS;
// #MNA1 @TEXT("ULVT 0.235u", key="model", size=1.05, dx=1.5, dy=-1);
// #MNA1 @TEXT("MNA1", key="name", size=1.1, dx=1.5, dy=1);
// #MPB0 @PLACE(0, -8) => @ORIENT("R0");
// #MPB0 @SET-SYMBOL $PMOS;
// #MPB0 @TEXT("ULVT 0.235u", key="model", size=1.05, dx=1.5, dy=-1);
// #MPB0 @TEXT("MPB0", key="name", size=1.1, dx=1.5, dy=1);
// #MPB1 @PLACE(16, -8) => @ORIENT("R0");
// #MPB1 @SET-SYMBOL $PMOS;
// #MPB1 @TEXT("ULVT 0.235u", key="model", size=1.05, dx=1.5, dy=-1);
// #MPB1 @TEXT("MPB1", key="name", size=1.1, dx=1.5, dy=1);
// #MNB0 @PLACE(8, -24) => @ORIENT("R0");
// #MNB0 @SET-SYMBOL $NMOS;
// #MNB0 @TEXT("ULVT 0.12u", key="model", size=1.05, dx=1.5, dy=-1);
// #MNB0 @TEXT("MNB0", key="name", size=1.1, dx=1.5, dy=1);
// #MNB1 @PLACE(8, -32) => @ORIENT("R0");
// #MNB1 @SET-SYMBOL $NMOS;
// #MNB1 @TEXT("ULVT 0.575u", key="model", size=1.05, dx=1.5, dy=-1);
// #MNB1 @TEXT("MNB1", key="name", size=1.1, dx=1.5, dy=1);
// #MPOUT @PLACE(76, 18) => @ORIENT("R0");
// #MPOUT @SET-SYMBOL $PMOS;
// #MPOUT @TEXT("SVT 2.36u", key="model", size=1.05, dx=1.5, dy=-1);
// #MPOUT @TEXT("MPOUT", key="name", size=1.1, dx=1.5, dy=1);
// #MNOUT @PLACE(76, -18) => @ORIENT("R0");
// #MNOUT @SET-SYMBOL $NMOS;
// #MNOUT @TEXT("SVT 1.18u", key="model", size=1.05, dx=1.5, dy=-1);
// #MNOUT @TEXT("MNOUT", key="name", size=1.1, dx=1.5, dy=1);
// &AP @WIRE {#MPA0:1 #MPA1:3};
// (10, 28) @TEXT("AP", size=1.05);
// %j1 = (8, 16);
// &PCOND @WIRE {#MNA0:1 (0, 16) %j1 (16, 16) #MNA1:1};
// &PCOND @WIRE {#MPA1:1 %j1};
// #MGPN @PLACE(43, 9) => @ORIENT("R0");
// #MGPN @SET-SYMBOL $NMOS;
// #MGPN @TEXT("SVT 0.465u", key="model", size=1.05, dx=1.5, dy=-1);
// #MGPN @TEXT("MGPN", key="name", size=1.1, dx=1.5, dy=1);
// #MGPP @PLACE(43, 23) => @ORIENT("R0");
// #MGPP @SET-SYMBOL $PMOS;
// #MGPP @TEXT("SVT 0.7u", key="model", size=1.05, dx=1.5, dy=-1);
// #MGPP @TEXT("MGPP", key="name", size=1.1, dx=1.5, dy=1);
// %j2 = (43, 16);
// %j3 = (38, 16);
// &GP @WIRE {#MGPN:1 %j2 #MGPP:1};
// &PCOND @WIRE {#MGPN:2 (38, 9) %j3 (38, 23) #MGPP:2};
// &PCOND @WIRE {%j1 %j3};
// &GP @WIRE {%j2 (65, 16) (65, 18) #MPOUT:2};
// %j4 = (8, -16);
// &NOFF @WIRE {#MPB0:1 (0, -16) %j4 (16, -16) #MPB1:1};
// &NOFF @WIRE {#MNB0:1 %j4};
// &BN @WIRE {#MNB0:3 #MNB1:1};
// (18, -14) @TEXT("NOFF", size=1.05);
// #MGNN @PLACE(43, -23) => @ORIENT("R0");
// #MGNN @SET-SYMBOL $NMOS;
// #MGNN @TEXT("SVT 0.465u", key="model", size=1.05, dx=1.5, dy=-1);
// #MGNN @TEXT("MGNN", key="name", size=1.1, dx=1.5, dy=1);
// #MGNP @PLACE(43, -9) => @ORIENT("R0");
// #MGNP @SET-SYMBOL $PMOS;
// #MGNP @TEXT("SVT 0.235u", key="model", size=1.05, dx=1.5, dy=-1);
// #MGNP @TEXT("MGNP", key="name", size=1.1, dx=1.5, dy=1);
// %j5 = (43, -16);
// %j6 = (38, -16);
// &GN @WIRE {#MGNN:1 %j5 #MGNP:1};
// &NOFF @WIRE {#MGNN:2 (38, -23) %j6 (38, -9) #MGNP:2};
// &NOFF @WIRE {%j4 %j6};
// &GN @WIRE {%j5 (65, -16) (65, -18) #MNOUT:2};
// %j7 = (76, 0);
// &BP @WIRE {#MPOUT:1 %j7 #MNOUT:1};
// &BP @WIRE {%j7 (85, 0)};
// (85, 1) @TEXT("BP", size=1.05);
// (-5, 42) @TEXT("NOR: PCOND = ~(ENB | HIB)", size=1.05);
// (-5, -42) @TEXT("NAND: NOFF = ~(EN & HIB)", size=1.05);
// (31, 39) @TEXT("Reference gate drivers", size=1.05);
// (67, 39) @TEXT("Output rail switch", size=1.05);
// #MNDAP @PLACE(100, 24) => @ORIENT("R0");
// #MNDAP @SET-SYMBOL $NMOS;
// #MNDAP @TEXT("ULVT 0.12u", key="model", size=1.05, dx=1.5, dy=-1);
// #MNDAP @TEXT("MNDAP", key="name", size=1.1, dx=1.5, dy=1);
// #C_APLOAD @PLACE(113, 24) => @ORIENT("MX");
// #C_APLOAD @TEXT("", key="value");
// #C_APLOAD @TEXT("", key="name");
// (115, 25) @TEXT("C_APLOAD", size=1.05);
// (115, 23) @TEXT("2 Cu", size=1.05);
// #CP_APLOAD @PLACE(128, 24) => @ORIENT("R0");
// #CP_APLOAD @TEXT("", key="value");
// #CP_APLOAD @TEXT("", key="name");
// (130, 25) @TEXT("CP_APLOAD", size=1.05);
// (130, 23) @TEXT("0.1002 fF / 5%", size=1.05);
// %j8 = (113, 30);
// &AP @WIRE {#MNDAP:1 (100, 30) %j8 (128, 30) #CP_APLOAD:1};
// &AP @WIRE {#C_APLOAD:2 %j8};
// (113, 32) @TEXT("AP", size=1.05);
// #MNCANCEL @PLACE(109, -14) => @ORIENT("R0");
// #MNCANCEL @SET-SYMBOL $NMOS;
// #MNCANCEL @TEXT("ULVT 0.12u", key="model", size=1.05, dx=1.5, dy=-1);
// #MNCANCEL @TEXT("MNCANCEL", key="name", size=1.1, dx=1.5, dy=1);
// &NOFF @WIRE {#MNCANCEL:1 (115, -12) (115, -16) #MNCANCEL:3};
// (117, -14) @TEXT("NOFF", size=1.05);
// (96, 39) @TEXT("AP keeper + physical MOM load", size=1.05);
// (96, -25) @TEXT("ENB feedthrough cancellation", size=1.05);
// &ENB @WIRE {#MPA0:2 (3, 32)};
// (2.7, 32) @TEXT("ENB", size=1.05, halign="end", valign="middle");
// %t10 = $SUPPLY @ATTACH &DVDD => @PLACE(8, 36);
// &DVDD @WIRE {#MPA0:3 %t10:p};
// &HIB @WIRE {#MPA1:2 (3, 24)};
// (2.7, 24) @TEXT("HIB", size=1.05, halign="end", valign="middle");
// &ENB @WIRE {#MNA0:2 (-5, 8)};
// (-5.3, 8) @TEXT("ENB", size=1.05, halign="end", valign="middle");
// %t13 = $GROUND @ATTACH &VREFN => @PLACE(0, 4);
// &VREFN @WIRE {#MNA0:3 %t13:p};
// &HIB @WIRE {#MNA1:2 (11, 8)};
// (10.7, 8) @TEXT("HIB", size=1.05, halign="end", valign="middle");
// %t15 = $GROUND @ATTACH &VREFN => @PLACE(16, 4);
// &VREFN @WIRE {#MNA1:3 %t15:p};
// &EN @WIRE {#MPB0:2 (-5, -8)};
// (-5.3, -8) @TEXT("EN", size=1.05, halign="end", valign="middle");
// %t17 = $SUPPLY @ATTACH &DVDD => @PLACE(0, -4);
// &DVDD @WIRE {#MPB0:3 %t17:p};
// &HIB @WIRE {#MPB1:2 (11, -8)};
// (10.7, -8) @TEXT("HIB", size=1.05, halign="end", valign="middle");
// %t19 = $SUPPLY @ATTACH &DVDD => @PLACE(16, -4);
// &DVDD @WIRE {#MPB1:3 %t19:p};
// &EN @WIRE {#MNB0:2 (3, -24)};
// (2.7, -24) @TEXT("EN", size=1.05, halign="end", valign="middle");
// &HIB @WIRE {#MNB1:2 (3, -32)};
// (2.7, -32) @TEXT("HIB", size=1.05, halign="end", valign="middle");
// %t22 = $GROUND @ATTACH &VREFN => @PLACE(8, -36);
// &VREFN @WIRE {#MNB1:3 %t22:p};
// %t23 = $SUPPLY @ATTACH &VREFP => @PLACE(76, 22);
// &VREFP @WIRE {#MPOUT:3 %t23:p};
// %t24 = $GROUND @ATTACH &VREFN => @PLACE(76, -22);
// &VREFN @WIRE {#MNOUT:3 %t24:p};
// %t25 = $GROUND @ATTACH &VREFN => @PLACE(43, 5);
// &VREFN @WIRE {#MGPN:3 %t25:p};
// %t26 = $SUPPLY @ATTACH &VREFP => @PLACE(43, 27);
// &VREFP @WIRE {#MGPP:3 %t26:p};
// %t27 = $GROUND @ATTACH &VREFN => @PLACE(43, -27);
// &VREFN @WIRE {#MGNN:3 %t27:p};
// %t28 = $SUPPLY @ATTACH &VREFP => @PLACE(43, -5);
// &VREFP @WIRE {#MGNP:3 %t28:p};
// &ENB @WIRE {#MNDAP:2 (95, 24)};
// (94.7, 24) @TEXT("ENB", size=1.05, halign="end", valign="middle");
// %t30 = $GROUND @ATTACH &VREFN => @PLACE(100, 20);
// &VREFN @WIRE {#MNDAP:3 %t30:p};
// %t31 = $GROUND @ATTACH &VSS => @PLACE(113, 20);
// &VSS @WIRE {#C_APLOAD:1 %t31:p};
// %t32 = $GROUND @ATTACH &VSS => @PLACE(128, 20);
// &VSS @WIRE {#CP_APLOAD:2 %t32:p};
// &ENB @WIRE {#MNCANCEL:2 (104, -14)};
// (103.7, -14) @TEXT("ENB", size=1.05, halign="end", valign="middle");
// $JUNCTION @ATTACH %j1;
// $JUNCTION @ATTACH %j2;
// $JUNCTION @ATTACH %j3;
// $JUNCTION @ATTACH %j4;
// $JUNCTION @ATTACH %j5;
// $JUNCTION @ATTACH %j6;
// $JUNCTION @ATTACH %j7;
// $JUNCTION @ATTACH %j8;
// (-7, 51) @TEXT("V29 diagnostic only / NOT qualified | mq_cdac_drv7 | isolated DVDD logic / VREFP output", size=1.4, bold=true, textcolor="#17365d");
// (-7, 48.6) @TEXT("Drawing only | N bulk = VSS; L = 30 nm. P bulk DVDD: MPA0, MPA1, MPB0, MPB1; VREFP: MGPP, MGNP, MPOUT", size=1.05, textcolor="#52606d");
// }
ends mq_cdac_drv7

subckt mq_cdac_drv6 (HIB EN ENB BP VREFP VREFN VSS DVDD)
// DVDD prelogic: PCOND = NOR(ENB,HIB); NOFF = NAND(EN,HIB).
// Reference-powered final inverters restore GP and GN to VREFP/VREFN.
// Actual current overlap, settling and device stress require measurement.
MPA0 (AP ENB DVDD DVDD) pch_ulvt_mac w=2.6e-07 l=3e-08 nf=1
MPA1 (PCOND HIB AP DVDD) pch_ulvt_mac w=2.6e-07 l=3e-08 nf=1
MNA0 (PCOND ENB VREFN VSS) nch_ulvt_mac w=1.3e-07 l=3e-08 nf=1
MNA1 (PCOND HIB VREFN VSS) nch_ulvt_mac w=1.3e-07 l=3e-08 nf=1
MPB0 (NOFF EN DVDD DVDD) pch_ulvt_mac w=1.3e-07 l=3e-08 nf=1
MPB1 (NOFF HIB DVDD DVDD) pch_ulvt_mac w=1.3e-07 l=3e-08 nf=1
MNB0 (NOFF EN BN VSS) nch_ulvt_mac w=1.2e-07 l=3e-08 nf=1
MNB1 (BN HIB VREFN VSS) nch_ulvt_mac w=3.25e-07 l=3e-08 nf=1
MGPN (GP PCOND VREFN VSS) nch_mac w=2.6e-07 l=3e-08 nf=1
MGPP (GP PCOND VREFP VREFP) pch_mac w=3.9e-07 l=3e-08 nf=1
MGNN (GN NOFF VREFN VSS) nch_mac w=2.6e-07 l=3e-08 nf=1
MGNP (GN NOFF VREFP VREFP) pch_mac w=1.3e-07 l=3e-08 nf=1
MNOUT (BP GN VREFN VSS) nch_mac w=1.98e-06 l=3e-08 nf=3
MPOUT (BP GP VREFP VREFP) pch_mac w=3.975e-06 l=3e-08 nf=3
// Actively discharge AP while ENB turns the upper PMOS off.
MNDAP (AP ENB VREFN VSS) nch_ulvt_mac w=1.2e-07 l=3e-08 nf=1
// 1 existing physical MOM units, with 5% bottom Cp, slow AP feedthrough.
C_APLOAD (VSS AP) cfmom_2t w=5e-08 s=2.4e-07 nr=6 lr=1.69e-06 stm=2 spm=4 multi=1
CP_APLOAD (AP VSS) capacitor c=5.01145e-17
MNCANCEL (NOFF ENB NOFF VSS) nch_ulvt_mac w=1.2e-07 l=3e-08 nf=1
// @RNL {
// {&HIB &EN &ENB &BP &VREFP &VREFN &VSS &DVDD} @REMOVE-FROM $PORT_FILL_SET;
// &VSS @ADD-TO $GROUND_NET_SET;
// &VREFN @ADD-TO $GROUND_NET_SET;
// #MPA0 @PLACE(8, 32) => @ORIENT("R0");
// #MPA0 @SET-SYMBOL $PMOS;
// #MPA0 @TEXT("ULVT 0.26u", key="model", size=1.05, dx=1.5, dy=-1);
// #MPA0 @TEXT("MPA0", key="name", size=1.1, dx=1.5, dy=1);
// #MPA1 @PLACE(8, 24) => @ORIENT("R0");
// #MPA1 @SET-SYMBOL $PMOS;
// #MPA1 @TEXT("ULVT 0.26u", key="model", size=1.05, dx=1.5, dy=-1);
// #MPA1 @TEXT("MPA1", key="name", size=1.1, dx=1.5, dy=1);
// #MNA0 @PLACE(0, 8) => @ORIENT("R0");
// #MNA0 @SET-SYMBOL $NMOS;
// #MNA0 @TEXT("ULVT 0.13u", key="model", size=1.05, dx=1.5, dy=-1);
// #MNA0 @TEXT("MNA0", key="name", size=1.1, dx=1.5, dy=1);
// #MNA1 @PLACE(16, 8) => @ORIENT("R0");
// #MNA1 @SET-SYMBOL $NMOS;
// #MNA1 @TEXT("ULVT 0.13u", key="model", size=1.05, dx=1.5, dy=-1);
// #MNA1 @TEXT("MNA1", key="name", size=1.1, dx=1.5, dy=1);
// #MPB0 @PLACE(0, -8) => @ORIENT("R0");
// #MPB0 @SET-SYMBOL $PMOS;
// #MPB0 @TEXT("ULVT 0.13u", key="model", size=1.05, dx=1.5, dy=-1);
// #MPB0 @TEXT("MPB0", key="name", size=1.1, dx=1.5, dy=1);
// #MPB1 @PLACE(16, -8) => @ORIENT("R0");
// #MPB1 @SET-SYMBOL $PMOS;
// #MPB1 @TEXT("ULVT 0.13u", key="model", size=1.05, dx=1.5, dy=-1);
// #MPB1 @TEXT("MPB1", key="name", size=1.1, dx=1.5, dy=1);
// #MNB0 @PLACE(8, -24) => @ORIENT("R0");
// #MNB0 @SET-SYMBOL $NMOS;
// #MNB0 @TEXT("ULVT 0.12u", key="model", size=1.05, dx=1.5, dy=-1);
// #MNB0 @TEXT("MNB0", key="name", size=1.1, dx=1.5, dy=1);
// #MNB1 @PLACE(8, -32) => @ORIENT("R0");
// #MNB1 @SET-SYMBOL $NMOS;
// #MNB1 @TEXT("ULVT 0.325u", key="model", size=1.05, dx=1.5, dy=-1);
// #MNB1 @TEXT("MNB1", key="name", size=1.1, dx=1.5, dy=1);
// #MPOUT @PLACE(76, 18) => @ORIENT("R0");
// #MPOUT @SET-SYMBOL $PMOS;
// #MPOUT @TEXT("SVT 3.975u", key="model", size=1.05, dx=1.5, dy=-1);
// #MPOUT @TEXT("MPOUT", key="name", size=1.1, dx=1.5, dy=1);
// #MNOUT @PLACE(76, -18) => @ORIENT("R0");
// #MNOUT @SET-SYMBOL $NMOS;
// #MNOUT @TEXT("SVT 1.98u", key="model", size=1.05, dx=1.5, dy=-1);
// #MNOUT @TEXT("MNOUT", key="name", size=1.1, dx=1.5, dy=1);
// &AP @WIRE {#MPA0:1 #MPA1:3};
// (10, 28) @TEXT("AP", size=1.05);
// %j1 = (8, 16);
// &PCOND @WIRE {#MNA0:1 (0, 16) %j1 (16, 16) #MNA1:1};
// &PCOND @WIRE {#MPA1:1 %j1};
// #MGPN @PLACE(43, 9) => @ORIENT("R0");
// #MGPN @SET-SYMBOL $NMOS;
// #MGPN @TEXT("SVT 0.26u", key="model", size=1.05, dx=1.5, dy=-1);
// #MGPN @TEXT("MGPN", key="name", size=1.1, dx=1.5, dy=1);
// #MGPP @PLACE(43, 23) => @ORIENT("R0");
// #MGPP @SET-SYMBOL $PMOS;
// #MGPP @TEXT("SVT 0.39u", key="model", size=1.05, dx=1.5, dy=-1);
// #MGPP @TEXT("MGPP", key="name", size=1.1, dx=1.5, dy=1);
// %j2 = (43, 16);
// %j3 = (38, 16);
// &GP @WIRE {#MGPN:1 %j2 #MGPP:1};
// &PCOND @WIRE {#MGPN:2 (38, 9) %j3 (38, 23) #MGPP:2};
// &PCOND @WIRE {%j1 %j3};
// &GP @WIRE {%j2 (65, 16) (65, 18) #MPOUT:2};
// %j4 = (8, -16);
// &NOFF @WIRE {#MPB0:1 (0, -16) %j4 (16, -16) #MPB1:1};
// &NOFF @WIRE {#MNB0:1 %j4};
// &BN @WIRE {#MNB0:3 #MNB1:1};
// (18, -14) @TEXT("NOFF", size=1.05);
// #MGNN @PLACE(43, -23) => @ORIENT("R0");
// #MGNN @SET-SYMBOL $NMOS;
// #MGNN @TEXT("SVT 0.26u", key="model", size=1.05, dx=1.5, dy=-1);
// #MGNN @TEXT("MGNN", key="name", size=1.1, dx=1.5, dy=1);
// #MGNP @PLACE(43, -9) => @ORIENT("R0");
// #MGNP @SET-SYMBOL $PMOS;
// #MGNP @TEXT("SVT 0.13u", key="model", size=1.05, dx=1.5, dy=-1);
// #MGNP @TEXT("MGNP", key="name", size=1.1, dx=1.5, dy=1);
// %j5 = (43, -16);
// %j6 = (38, -16);
// &GN @WIRE {#MGNN:1 %j5 #MGNP:1};
// &NOFF @WIRE {#MGNN:2 (38, -23) %j6 (38, -9) #MGNP:2};
// &NOFF @WIRE {%j4 %j6};
// &GN @WIRE {%j5 (65, -16) (65, -18) #MNOUT:2};
// %j7 = (76, 0);
// &BP @WIRE {#MPOUT:1 %j7 #MNOUT:1};
// &BP @WIRE {%j7 (85, 0)};
// (85, 1) @TEXT("BP", size=1.05);
// (-5, 42) @TEXT("NOR: PCOND = ~(ENB | HIB)", size=1.05);
// (-5, -42) @TEXT("NAND: NOFF = ~(EN & HIB)", size=1.05);
// (31, 39) @TEXT("Reference gate drivers", size=1.05);
// (67, 39) @TEXT("Output rail switch", size=1.05);
// #MNDAP @PLACE(100, 24) => @ORIENT("R0");
// #MNDAP @SET-SYMBOL $NMOS;
// #MNDAP @TEXT("ULVT 0.12u", key="model", size=1.05, dx=1.5, dy=-1);
// #MNDAP @TEXT("MNDAP", key="name", size=1.1, dx=1.5, dy=1);
// #C_APLOAD @PLACE(113, 24) => @ORIENT("MX");
// #C_APLOAD @TEXT("", key="value");
// #C_APLOAD @TEXT("", key="name");
// (115, 25) @TEXT("C_APLOAD", size=1.05);
// (115, 23) @TEXT("1 Cu", size=1.05);
// #CP_APLOAD @PLACE(128, 24) => @ORIENT("R0");
// #CP_APLOAD @TEXT("", key="value");
// #CP_APLOAD @TEXT("", key="name");
// (130, 25) @TEXT("CP_APLOAD", size=1.05);
// (130, 23) @TEXT("0.05011 fF / 5%", size=1.05);
// %j8 = (113, 30);
// &AP @WIRE {#MNDAP:1 (100, 30) %j8 (128, 30) #CP_APLOAD:1};
// &AP @WIRE {#C_APLOAD:2 %j8};
// (113, 32) @TEXT("AP", size=1.05);
// #MNCANCEL @PLACE(109, -14) => @ORIENT("R0");
// #MNCANCEL @SET-SYMBOL $NMOS;
// #MNCANCEL @TEXT("ULVT 0.12u", key="model", size=1.05, dx=1.5, dy=-1);
// #MNCANCEL @TEXT("MNCANCEL", key="name", size=1.1, dx=1.5, dy=1);
// &NOFF @WIRE {#MNCANCEL:1 (115, -12) (115, -16) #MNCANCEL:3};
// (117, -14) @TEXT("NOFF", size=1.05);
// (96, 39) @TEXT("AP keeper + physical MOM load", size=1.05);
// (96, -25) @TEXT("ENB feedthrough cancellation", size=1.05);
// &ENB @WIRE {#MPA0:2 (3, 32)};
// (2.7, 32) @TEXT("ENB", size=1.05, halign="end", valign="middle");
// %t10 = $SUPPLY @ATTACH &DVDD => @PLACE(8, 36);
// &DVDD @WIRE {#MPA0:3 %t10:p};
// &HIB @WIRE {#MPA1:2 (3, 24)};
// (2.7, 24) @TEXT("HIB", size=1.05, halign="end", valign="middle");
// &ENB @WIRE {#MNA0:2 (-5, 8)};
// (-5.3, 8) @TEXT("ENB", size=1.05, halign="end", valign="middle");
// %t13 = $GROUND @ATTACH &VREFN => @PLACE(0, 4);
// &VREFN @WIRE {#MNA0:3 %t13:p};
// &HIB @WIRE {#MNA1:2 (11, 8)};
// (10.7, 8) @TEXT("HIB", size=1.05, halign="end", valign="middle");
// %t15 = $GROUND @ATTACH &VREFN => @PLACE(16, 4);
// &VREFN @WIRE {#MNA1:3 %t15:p};
// &EN @WIRE {#MPB0:2 (-5, -8)};
// (-5.3, -8) @TEXT("EN", size=1.05, halign="end", valign="middle");
// %t17 = $SUPPLY @ATTACH &DVDD => @PLACE(0, -4);
// &DVDD @WIRE {#MPB0:3 %t17:p};
// &HIB @WIRE {#MPB1:2 (11, -8)};
// (10.7, -8) @TEXT("HIB", size=1.05, halign="end", valign="middle");
// %t19 = $SUPPLY @ATTACH &DVDD => @PLACE(16, -4);
// &DVDD @WIRE {#MPB1:3 %t19:p};
// &EN @WIRE {#MNB0:2 (3, -24)};
// (2.7, -24) @TEXT("EN", size=1.05, halign="end", valign="middle");
// &HIB @WIRE {#MNB1:2 (3, -32)};
// (2.7, -32) @TEXT("HIB", size=1.05, halign="end", valign="middle");
// %t22 = $GROUND @ATTACH &VREFN => @PLACE(8, -36);
// &VREFN @WIRE {#MNB1:3 %t22:p};
// %t23 = $SUPPLY @ATTACH &VREFP => @PLACE(76, 22);
// &VREFP @WIRE {#MPOUT:3 %t23:p};
// %t24 = $GROUND @ATTACH &VREFN => @PLACE(76, -22);
// &VREFN @WIRE {#MNOUT:3 %t24:p};
// %t25 = $GROUND @ATTACH &VREFN => @PLACE(43, 5);
// &VREFN @WIRE {#MGPN:3 %t25:p};
// %t26 = $SUPPLY @ATTACH &VREFP => @PLACE(43, 27);
// &VREFP @WIRE {#MGPP:3 %t26:p};
// %t27 = $GROUND @ATTACH &VREFN => @PLACE(43, -27);
// &VREFN @WIRE {#MGNN:3 %t27:p};
// %t28 = $SUPPLY @ATTACH &VREFP => @PLACE(43, -5);
// &VREFP @WIRE {#MGNP:3 %t28:p};
// &ENB @WIRE {#MNDAP:2 (95, 24)};
// (94.7, 24) @TEXT("ENB", size=1.05, halign="end", valign="middle");
// %t30 = $GROUND @ATTACH &VREFN => @PLACE(100, 20);
// &VREFN @WIRE {#MNDAP:3 %t30:p};
// %t31 = $GROUND @ATTACH &VSS => @PLACE(113, 20);
// &VSS @WIRE {#C_APLOAD:1 %t31:p};
// %t32 = $GROUND @ATTACH &VSS => @PLACE(128, 20);
// &VSS @WIRE {#CP_APLOAD:2 %t32:p};
// &ENB @WIRE {#MNCANCEL:2 (104, -14)};
// (103.7, -14) @TEXT("ENB", size=1.05, halign="end", valign="middle");
// $JUNCTION @ATTACH %j1;
// $JUNCTION @ATTACH %j2;
// $JUNCTION @ATTACH %j3;
// $JUNCTION @ATTACH %j4;
// $JUNCTION @ATTACH %j5;
// $JUNCTION @ATTACH %j6;
// $JUNCTION @ATTACH %j7;
// $JUNCTION @ATTACH %j8;
// (-7, 51) @TEXT("V29 diagnostic only / NOT qualified | mq_cdac_drv6 | isolated DVDD logic / VREFP output", size=1.4, bold=true, textcolor="#17365d");
// (-7, 48.6) @TEXT("Drawing only | N bulk = VSS; L = 30 nm. P bulk DVDD: MPA0, MPA1, MPB0, MPB1; VREFP: MGPP, MGNP, MPOUT", size=1.05, textcolor="#52606d");
// }
ends mq_cdac_drv6

subckt mq_cdac_drv5 (HIB EN ENB BP VREFP VREFN VSS DVDD)
// DVDD prelogic: PCOND = NOR(ENB,HIB); NOFF = NAND(EN,HIB).
// Reference-powered final inverters restore GP and GN to VREFP/VREFN.
// Actual current overlap, settling and device stress require measurement.
MPA0 (AP ENB DVDD DVDD) pch_ulvt_mac w=2.4e-07 l=3e-08 nf=1
MPA1 (PCOND HIB AP DVDD) pch_ulvt_mac w=2.4e-07 l=3e-08 nf=1
MNA0 (PCOND ENB VREFN VSS) nch_ulvt_mac w=1.2e-07 l=3e-08 nf=1
MNA1 (PCOND HIB VREFN VSS) nch_ulvt_mac w=1.2e-07 l=3e-08 nf=1
MPB0 (NOFF EN DVDD DVDD) pch_ulvt_mac w=1.2e-07 l=3e-08 nf=1
MPB1 (NOFF HIB DVDD DVDD) pch_ulvt_mac w=1.2e-07 l=3e-08 nf=1
MNB0 (NOFF EN BN VSS) nch_ulvt_mac w=1.2e-07 l=3e-08 nf=1
MNB1 (BN HIB VREFN VSS) nch_ulvt_mac w=3.25e-07 l=3e-08 nf=1
MGPN (GP PCOND VREFN VSS) nch_mac w=2.4e-07 l=3e-08 nf=1
MGPP (GP PCOND VREFP VREFP) pch_mac w=3.6e-07 l=3e-08 nf=1
MGNN (GN NOFF VREFN VSS) nch_mac w=2.4e-07 l=3e-08 nf=1
MGNP (GN NOFF VREFP VREFP) pch_mac w=1.2e-07 l=3e-08 nf=1
MNOUT (BP GN VREFN VSS) nch_mac w=6.1e-07 l=3e-08 nf=1
MPOUT (BP GP VREFP VREFP) pch_mac w=1.215e-06 l=3e-08 nf=1
// Actively discharge AP while ENB turns the upper PMOS off.
MNDAP (AP ENB VREFN VSS) nch_ulvt_mac w=1.2e-07 l=3e-08 nf=1
// 1 existing physical MOM units, with 5% bottom Cp, slow AP feedthrough.
C_APLOAD (VSS AP) cfmom_2t w=5e-08 s=2.4e-07 nr=6 lr=1.69e-06 stm=2 spm=4 multi=1
CP_APLOAD (AP VSS) capacitor c=5.01145e-17
MNCANCEL (NOFF ENB NOFF VSS) nch_ulvt_mac w=1.2e-07 l=3e-08 nf=1
// @RNL {
// {&HIB &EN &ENB &BP &VREFP &VREFN &VSS &DVDD} @REMOVE-FROM $PORT_FILL_SET;
// &VSS @ADD-TO $GROUND_NET_SET;
// &VREFN @ADD-TO $GROUND_NET_SET;
// #MPA0 @PLACE(8, 32) => @ORIENT("R0");
// #MPA0 @SET-SYMBOL $PMOS;
// #MPA0 @TEXT("ULVT 0.24u", key="model", size=1.05, dx=1.5, dy=-1);
// #MPA0 @TEXT("MPA0", key="name", size=1.1, dx=1.5, dy=1);
// #MPA1 @PLACE(8, 24) => @ORIENT("R0");
// #MPA1 @SET-SYMBOL $PMOS;
// #MPA1 @TEXT("ULVT 0.24u", key="model", size=1.05, dx=1.5, dy=-1);
// #MPA1 @TEXT("MPA1", key="name", size=1.1, dx=1.5, dy=1);
// #MNA0 @PLACE(0, 8) => @ORIENT("R0");
// #MNA0 @SET-SYMBOL $NMOS;
// #MNA0 @TEXT("ULVT 0.12u", key="model", size=1.05, dx=1.5, dy=-1);
// #MNA0 @TEXT("MNA0", key="name", size=1.1, dx=1.5, dy=1);
// #MNA1 @PLACE(16, 8) => @ORIENT("R0");
// #MNA1 @SET-SYMBOL $NMOS;
// #MNA1 @TEXT("ULVT 0.12u", key="model", size=1.05, dx=1.5, dy=-1);
// #MNA1 @TEXT("MNA1", key="name", size=1.1, dx=1.5, dy=1);
// #MPB0 @PLACE(0, -8) => @ORIENT("R0");
// #MPB0 @SET-SYMBOL $PMOS;
// #MPB0 @TEXT("ULVT 0.12u", key="model", size=1.05, dx=1.5, dy=-1);
// #MPB0 @TEXT("MPB0", key="name", size=1.1, dx=1.5, dy=1);
// #MPB1 @PLACE(16, -8) => @ORIENT("R0");
// #MPB1 @SET-SYMBOL $PMOS;
// #MPB1 @TEXT("ULVT 0.12u", key="model", size=1.05, dx=1.5, dy=-1);
// #MPB1 @TEXT("MPB1", key="name", size=1.1, dx=1.5, dy=1);
// #MNB0 @PLACE(8, -24) => @ORIENT("R0");
// #MNB0 @SET-SYMBOL $NMOS;
// #MNB0 @TEXT("ULVT 0.12u", key="model", size=1.05, dx=1.5, dy=-1);
// #MNB0 @TEXT("MNB0", key="name", size=1.1, dx=1.5, dy=1);
// #MNB1 @PLACE(8, -32) => @ORIENT("R0");
// #MNB1 @SET-SYMBOL $NMOS;
// #MNB1 @TEXT("ULVT 0.325u", key="model", size=1.05, dx=1.5, dy=-1);
// #MNB1 @TEXT("MNB1", key="name", size=1.1, dx=1.5, dy=1);
// #MPOUT @PLACE(76, 18) => @ORIENT("R0");
// #MPOUT @SET-SYMBOL $PMOS;
// #MPOUT @TEXT("SVT 1.215u", key="model", size=1.05, dx=1.5, dy=-1);
// #MPOUT @TEXT("MPOUT", key="name", size=1.1, dx=1.5, dy=1);
// #MNOUT @PLACE(76, -18) => @ORIENT("R0");
// #MNOUT @SET-SYMBOL $NMOS;
// #MNOUT @TEXT("SVT 0.61u", key="model", size=1.05, dx=1.5, dy=-1);
// #MNOUT @TEXT("MNOUT", key="name", size=1.1, dx=1.5, dy=1);
// &AP @WIRE {#MPA0:1 #MPA1:3};
// (10, 28) @TEXT("AP", size=1.05);
// %j1 = (8, 16);
// &PCOND @WIRE {#MNA0:1 (0, 16) %j1 (16, 16) #MNA1:1};
// &PCOND @WIRE {#MPA1:1 %j1};
// #MGPN @PLACE(43, 9) => @ORIENT("R0");
// #MGPN @SET-SYMBOL $NMOS;
// #MGPN @TEXT("SVT 0.24u", key="model", size=1.05, dx=1.5, dy=-1);
// #MGPN @TEXT("MGPN", key="name", size=1.1, dx=1.5, dy=1);
// #MGPP @PLACE(43, 23) => @ORIENT("R0");
// #MGPP @SET-SYMBOL $PMOS;
// #MGPP @TEXT("SVT 0.36u", key="model", size=1.05, dx=1.5, dy=-1);
// #MGPP @TEXT("MGPP", key="name", size=1.1, dx=1.5, dy=1);
// %j2 = (43, 16);
// %j3 = (38, 16);
// &GP @WIRE {#MGPN:1 %j2 #MGPP:1};
// &PCOND @WIRE {#MGPN:2 (38, 9) %j3 (38, 23) #MGPP:2};
// &PCOND @WIRE {%j1 %j3};
// &GP @WIRE {%j2 (65, 16) (65, 18) #MPOUT:2};
// %j4 = (8, -16);
// &NOFF @WIRE {#MPB0:1 (0, -16) %j4 (16, -16) #MPB1:1};
// &NOFF @WIRE {#MNB0:1 %j4};
// &BN @WIRE {#MNB0:3 #MNB1:1};
// (18, -14) @TEXT("NOFF", size=1.05);
// #MGNN @PLACE(43, -23) => @ORIENT("R0");
// #MGNN @SET-SYMBOL $NMOS;
// #MGNN @TEXT("SVT 0.24u", key="model", size=1.05, dx=1.5, dy=-1);
// #MGNN @TEXT("MGNN", key="name", size=1.1, dx=1.5, dy=1);
// #MGNP @PLACE(43, -9) => @ORIENT("R0");
// #MGNP @SET-SYMBOL $PMOS;
// #MGNP @TEXT("SVT 0.12u", key="model", size=1.05, dx=1.5, dy=-1);
// #MGNP @TEXT("MGNP", key="name", size=1.1, dx=1.5, dy=1);
// %j5 = (43, -16);
// %j6 = (38, -16);
// &GN @WIRE {#MGNN:1 %j5 #MGNP:1};
// &NOFF @WIRE {#MGNN:2 (38, -23) %j6 (38, -9) #MGNP:2};
// &NOFF @WIRE {%j4 %j6};
// &GN @WIRE {%j5 (65, -16) (65, -18) #MNOUT:2};
// %j7 = (76, 0);
// &BP @WIRE {#MPOUT:1 %j7 #MNOUT:1};
// &BP @WIRE {%j7 (85, 0)};
// (85, 1) @TEXT("BP", size=1.05);
// (-5, 42) @TEXT("NOR: PCOND = ~(ENB | HIB)", size=1.05);
// (-5, -42) @TEXT("NAND: NOFF = ~(EN & HIB)", size=1.05);
// (31, 39) @TEXT("Reference gate drivers", size=1.05);
// (67, 39) @TEXT("Output rail switch", size=1.05);
// #MNDAP @PLACE(100, 24) => @ORIENT("R0");
// #MNDAP @SET-SYMBOL $NMOS;
// #MNDAP @TEXT("ULVT 0.12u", key="model", size=1.05, dx=1.5, dy=-1);
// #MNDAP @TEXT("MNDAP", key="name", size=1.1, dx=1.5, dy=1);
// #C_APLOAD @PLACE(113, 24) => @ORIENT("MX");
// #C_APLOAD @TEXT("", key="value");
// #C_APLOAD @TEXT("", key="name");
// (115, 25) @TEXT("C_APLOAD", size=1.05);
// (115, 23) @TEXT("1 Cu", size=1.05);
// #CP_APLOAD @PLACE(128, 24) => @ORIENT("R0");
// #CP_APLOAD @TEXT("", key="value");
// #CP_APLOAD @TEXT("", key="name");
// (130, 25) @TEXT("CP_APLOAD", size=1.05);
// (130, 23) @TEXT("0.05011 fF / 5%", size=1.05);
// %j8 = (113, 30);
// &AP @WIRE {#MNDAP:1 (100, 30) %j8 (128, 30) #CP_APLOAD:1};
// &AP @WIRE {#C_APLOAD:2 %j8};
// (113, 32) @TEXT("AP", size=1.05);
// #MNCANCEL @PLACE(109, -14) => @ORIENT("R0");
// #MNCANCEL @SET-SYMBOL $NMOS;
// #MNCANCEL @TEXT("ULVT 0.12u", key="model", size=1.05, dx=1.5, dy=-1);
// #MNCANCEL @TEXT("MNCANCEL", key="name", size=1.1, dx=1.5, dy=1);
// &NOFF @WIRE {#MNCANCEL:1 (115, -12) (115, -16) #MNCANCEL:3};
// (117, -14) @TEXT("NOFF", size=1.05);
// (96, 39) @TEXT("AP keeper + physical MOM load", size=1.05);
// (96, -25) @TEXT("ENB feedthrough cancellation", size=1.05);
// &ENB @WIRE {#MPA0:2 (3, 32)};
// (2.7, 32) @TEXT("ENB", size=1.05, halign="end", valign="middle");
// %t10 = $SUPPLY @ATTACH &DVDD => @PLACE(8, 36);
// &DVDD @WIRE {#MPA0:3 %t10:p};
// &HIB @WIRE {#MPA1:2 (3, 24)};
// (2.7, 24) @TEXT("HIB", size=1.05, halign="end", valign="middle");
// &ENB @WIRE {#MNA0:2 (-5, 8)};
// (-5.3, 8) @TEXT("ENB", size=1.05, halign="end", valign="middle");
// %t13 = $GROUND @ATTACH &VREFN => @PLACE(0, 4);
// &VREFN @WIRE {#MNA0:3 %t13:p};
// &HIB @WIRE {#MNA1:2 (11, 8)};
// (10.7, 8) @TEXT("HIB", size=1.05, halign="end", valign="middle");
// %t15 = $GROUND @ATTACH &VREFN => @PLACE(16, 4);
// &VREFN @WIRE {#MNA1:3 %t15:p};
// &EN @WIRE {#MPB0:2 (-5, -8)};
// (-5.3, -8) @TEXT("EN", size=1.05, halign="end", valign="middle");
// %t17 = $SUPPLY @ATTACH &DVDD => @PLACE(0, -4);
// &DVDD @WIRE {#MPB0:3 %t17:p};
// &HIB @WIRE {#MPB1:2 (11, -8)};
// (10.7, -8) @TEXT("HIB", size=1.05, halign="end", valign="middle");
// %t19 = $SUPPLY @ATTACH &DVDD => @PLACE(16, -4);
// &DVDD @WIRE {#MPB1:3 %t19:p};
// &EN @WIRE {#MNB0:2 (3, -24)};
// (2.7, -24) @TEXT("EN", size=1.05, halign="end", valign="middle");
// &HIB @WIRE {#MNB1:2 (3, -32)};
// (2.7, -32) @TEXT("HIB", size=1.05, halign="end", valign="middle");
// %t22 = $GROUND @ATTACH &VREFN => @PLACE(8, -36);
// &VREFN @WIRE {#MNB1:3 %t22:p};
// %t23 = $SUPPLY @ATTACH &VREFP => @PLACE(76, 22);
// &VREFP @WIRE {#MPOUT:3 %t23:p};
// %t24 = $GROUND @ATTACH &VREFN => @PLACE(76, -22);
// &VREFN @WIRE {#MNOUT:3 %t24:p};
// %t25 = $GROUND @ATTACH &VREFN => @PLACE(43, 5);
// &VREFN @WIRE {#MGPN:3 %t25:p};
// %t26 = $SUPPLY @ATTACH &VREFP => @PLACE(43, 27);
// &VREFP @WIRE {#MGPP:3 %t26:p};
// %t27 = $GROUND @ATTACH &VREFN => @PLACE(43, -27);
// &VREFN @WIRE {#MGNN:3 %t27:p};
// %t28 = $SUPPLY @ATTACH &VREFP => @PLACE(43, -5);
// &VREFP @WIRE {#MGNP:3 %t28:p};
// &ENB @WIRE {#MNDAP:2 (95, 24)};
// (94.7, 24) @TEXT("ENB", size=1.05, halign="end", valign="middle");
// %t30 = $GROUND @ATTACH &VREFN => @PLACE(100, 20);
// &VREFN @WIRE {#MNDAP:3 %t30:p};
// %t31 = $GROUND @ATTACH &VSS => @PLACE(113, 20);
// &VSS @WIRE {#C_APLOAD:1 %t31:p};
// %t32 = $GROUND @ATTACH &VSS => @PLACE(128, 20);
// &VSS @WIRE {#CP_APLOAD:2 %t32:p};
// &ENB @WIRE {#MNCANCEL:2 (104, -14)};
// (103.7, -14) @TEXT("ENB", size=1.05, halign="end", valign="middle");
// $JUNCTION @ATTACH %j1;
// $JUNCTION @ATTACH %j2;
// $JUNCTION @ATTACH %j3;
// $JUNCTION @ATTACH %j4;
// $JUNCTION @ATTACH %j5;
// $JUNCTION @ATTACH %j6;
// $JUNCTION @ATTACH %j7;
// $JUNCTION @ATTACH %j8;
// (-7, 51) @TEXT("V29 diagnostic only / NOT qualified | mq_cdac_drv5 | isolated DVDD logic / VREFP output", size=1.4, bold=true, textcolor="#17365d");
// (-7, 48.6) @TEXT("Drawing only | N bulk = VSS; L = 30 nm. P bulk DVDD: MPA0, MPA1, MPB0, MPB1; VREFP: MGPP, MGNP, MPOUT", size=1.05, textcolor="#52606d");
// }
ends mq_cdac_drv5

subckt mq_cdac_drv4 (HIB EN ENB BP VREFP VREFN VSS DVDD)
// DVDD prelogic: PCOND = NOR(ENB,HIB); NOFF = NAND(EN,HIB).
// Reference-powered final inverters restore GP and GN to VREFP/VREFN.
// Actual current overlap, settling and device stress require measurement.
MPA0 (AP ENB DVDD DVDD) pch_ulvt_mac w=2.4e-07 l=3e-08 nf=1
MPA1 (PCOND HIB AP DVDD) pch_ulvt_mac w=2.4e-07 l=3e-08 nf=1
MNA0 (PCOND ENB VREFN VSS) nch_ulvt_mac w=1.2e-07 l=3e-08 nf=1
MNA1 (PCOND HIB VREFN VSS) nch_ulvt_mac w=1.2e-07 l=3e-08 nf=1
MPB0 (NOFF EN DVDD DVDD) pch_ulvt_mac w=1.2e-07 l=3e-08 nf=1
MPB1 (NOFF HIB DVDD DVDD) pch_ulvt_mac w=1.2e-07 l=3e-08 nf=1
MNB0 (NOFF EN BN VSS) nch_ulvt_mac w=1.2e-07 l=3e-08 nf=1
MNB1 (BN HIB VREFN VSS) nch_ulvt_mac w=3.25e-07 l=3e-08 nf=1
MGPN (GP PCOND VREFN VSS) nch_mac w=2.4e-07 l=3e-08 nf=1
MGPP (GP PCOND VREFP VREFP) pch_mac w=3.6e-07 l=3e-08 nf=1
MGNN (GN NOFF VREFN VSS) nch_mac w=2.4e-07 l=3e-08 nf=1
MGNP (GN NOFF VREFP VREFP) pch_mac w=1.2e-07 l=3e-08 nf=1
MNOUT (BP GN VREFN VSS) nch_mac w=6.1e-07 l=3e-08 nf=1
MPOUT (BP GP VREFP VREFP) pch_mac w=1.215e-06 l=3e-08 nf=1
// Actively discharge AP while ENB turns the upper PMOS off.
MNDAP (AP ENB VREFN VSS) nch_ulvt_mac w=1.2e-07 l=3e-08 nf=1
// 1 existing physical MOM units, with 5% bottom Cp, slow AP feedthrough.
C_APLOAD (VSS AP) cfmom_2t w=5e-08 s=2.4e-07 nr=6 lr=1.69e-06 stm=2 spm=4 multi=1
CP_APLOAD (AP VSS) capacitor c=5.01145e-17
MNCANCEL (NOFF ENB NOFF VSS) nch_ulvt_mac w=1.2e-07 l=3e-08 nf=1
// @RNL {
// {&HIB &EN &ENB &BP &VREFP &VREFN &VSS &DVDD} @REMOVE-FROM $PORT_FILL_SET;
// &VSS @ADD-TO $GROUND_NET_SET;
// &VREFN @ADD-TO $GROUND_NET_SET;
// #MPA0 @PLACE(8, 32) => @ORIENT("R0");
// #MPA0 @SET-SYMBOL $PMOS;
// #MPA0 @TEXT("ULVT 0.24u", key="model", size=1.05, dx=1.5, dy=-1);
// #MPA0 @TEXT("MPA0", key="name", size=1.1, dx=1.5, dy=1);
// #MPA1 @PLACE(8, 24) => @ORIENT("R0");
// #MPA1 @SET-SYMBOL $PMOS;
// #MPA1 @TEXT("ULVT 0.24u", key="model", size=1.05, dx=1.5, dy=-1);
// #MPA1 @TEXT("MPA1", key="name", size=1.1, dx=1.5, dy=1);
// #MNA0 @PLACE(0, 8) => @ORIENT("R0");
// #MNA0 @SET-SYMBOL $NMOS;
// #MNA0 @TEXT("ULVT 0.12u", key="model", size=1.05, dx=1.5, dy=-1);
// #MNA0 @TEXT("MNA0", key="name", size=1.1, dx=1.5, dy=1);
// #MNA1 @PLACE(16, 8) => @ORIENT("R0");
// #MNA1 @SET-SYMBOL $NMOS;
// #MNA1 @TEXT("ULVT 0.12u", key="model", size=1.05, dx=1.5, dy=-1);
// #MNA1 @TEXT("MNA1", key="name", size=1.1, dx=1.5, dy=1);
// #MPB0 @PLACE(0, -8) => @ORIENT("R0");
// #MPB0 @SET-SYMBOL $PMOS;
// #MPB0 @TEXT("ULVT 0.12u", key="model", size=1.05, dx=1.5, dy=-1);
// #MPB0 @TEXT("MPB0", key="name", size=1.1, dx=1.5, dy=1);
// #MPB1 @PLACE(16, -8) => @ORIENT("R0");
// #MPB1 @SET-SYMBOL $PMOS;
// #MPB1 @TEXT("ULVT 0.12u", key="model", size=1.05, dx=1.5, dy=-1);
// #MPB1 @TEXT("MPB1", key="name", size=1.1, dx=1.5, dy=1);
// #MNB0 @PLACE(8, -24) => @ORIENT("R0");
// #MNB0 @SET-SYMBOL $NMOS;
// #MNB0 @TEXT("ULVT 0.12u", key="model", size=1.05, dx=1.5, dy=-1);
// #MNB0 @TEXT("MNB0", key="name", size=1.1, dx=1.5, dy=1);
// #MNB1 @PLACE(8, -32) => @ORIENT("R0");
// #MNB1 @SET-SYMBOL $NMOS;
// #MNB1 @TEXT("ULVT 0.325u", key="model", size=1.05, dx=1.5, dy=-1);
// #MNB1 @TEXT("MNB1", key="name", size=1.1, dx=1.5, dy=1);
// #MPOUT @PLACE(76, 18) => @ORIENT("R0");
// #MPOUT @SET-SYMBOL $PMOS;
// #MPOUT @TEXT("SVT 1.215u", key="model", size=1.05, dx=1.5, dy=-1);
// #MPOUT @TEXT("MPOUT", key="name", size=1.1, dx=1.5, dy=1);
// #MNOUT @PLACE(76, -18) => @ORIENT("R0");
// #MNOUT @SET-SYMBOL $NMOS;
// #MNOUT @TEXT("SVT 0.61u", key="model", size=1.05, dx=1.5, dy=-1);
// #MNOUT @TEXT("MNOUT", key="name", size=1.1, dx=1.5, dy=1);
// &AP @WIRE {#MPA0:1 #MPA1:3};
// (10, 28) @TEXT("AP", size=1.05);
// %j1 = (8, 16);
// &PCOND @WIRE {#MNA0:1 (0, 16) %j1 (16, 16) #MNA1:1};
// &PCOND @WIRE {#MPA1:1 %j1};
// #MGPN @PLACE(43, 9) => @ORIENT("R0");
// #MGPN @SET-SYMBOL $NMOS;
// #MGPN @TEXT("SVT 0.24u", key="model", size=1.05, dx=1.5, dy=-1);
// #MGPN @TEXT("MGPN", key="name", size=1.1, dx=1.5, dy=1);
// #MGPP @PLACE(43, 23) => @ORIENT("R0");
// #MGPP @SET-SYMBOL $PMOS;
// #MGPP @TEXT("SVT 0.36u", key="model", size=1.05, dx=1.5, dy=-1);
// #MGPP @TEXT("MGPP", key="name", size=1.1, dx=1.5, dy=1);
// %j2 = (43, 16);
// %j3 = (38, 16);
// &GP @WIRE {#MGPN:1 %j2 #MGPP:1};
// &PCOND @WIRE {#MGPN:2 (38, 9) %j3 (38, 23) #MGPP:2};
// &PCOND @WIRE {%j1 %j3};
// &GP @WIRE {%j2 (65, 16) (65, 18) #MPOUT:2};
// %j4 = (8, -16);
// &NOFF @WIRE {#MPB0:1 (0, -16) %j4 (16, -16) #MPB1:1};
// &NOFF @WIRE {#MNB0:1 %j4};
// &BN @WIRE {#MNB0:3 #MNB1:1};
// (18, -14) @TEXT("NOFF", size=1.05);
// #MGNN @PLACE(43, -23) => @ORIENT("R0");
// #MGNN @SET-SYMBOL $NMOS;
// #MGNN @TEXT("SVT 0.24u", key="model", size=1.05, dx=1.5, dy=-1);
// #MGNN @TEXT("MGNN", key="name", size=1.1, dx=1.5, dy=1);
// #MGNP @PLACE(43, -9) => @ORIENT("R0");
// #MGNP @SET-SYMBOL $PMOS;
// #MGNP @TEXT("SVT 0.12u", key="model", size=1.05, dx=1.5, dy=-1);
// #MGNP @TEXT("MGNP", key="name", size=1.1, dx=1.5, dy=1);
// %j5 = (43, -16);
// %j6 = (38, -16);
// &GN @WIRE {#MGNN:1 %j5 #MGNP:1};
// &NOFF @WIRE {#MGNN:2 (38, -23) %j6 (38, -9) #MGNP:2};
// &NOFF @WIRE {%j4 %j6};
// &GN @WIRE {%j5 (65, -16) (65, -18) #MNOUT:2};
// %j7 = (76, 0);
// &BP @WIRE {#MPOUT:1 %j7 #MNOUT:1};
// &BP @WIRE {%j7 (85, 0)};
// (85, 1) @TEXT("BP", size=1.05);
// (-5, 42) @TEXT("NOR: PCOND = ~(ENB | HIB)", size=1.05);
// (-5, -42) @TEXT("NAND: NOFF = ~(EN & HIB)", size=1.05);
// (31, 39) @TEXT("Reference gate drivers", size=1.05);
// (67, 39) @TEXT("Output rail switch", size=1.05);
// #MNDAP @PLACE(100, 24) => @ORIENT("R0");
// #MNDAP @SET-SYMBOL $NMOS;
// #MNDAP @TEXT("ULVT 0.12u", key="model", size=1.05, dx=1.5, dy=-1);
// #MNDAP @TEXT("MNDAP", key="name", size=1.1, dx=1.5, dy=1);
// #C_APLOAD @PLACE(113, 24) => @ORIENT("MX");
// #C_APLOAD @TEXT("", key="value");
// #C_APLOAD @TEXT("", key="name");
// (115, 25) @TEXT("C_APLOAD", size=1.05);
// (115, 23) @TEXT("1 Cu", size=1.05);
// #CP_APLOAD @PLACE(128, 24) => @ORIENT("R0");
// #CP_APLOAD @TEXT("", key="value");
// #CP_APLOAD @TEXT("", key="name");
// (130, 25) @TEXT("CP_APLOAD", size=1.05);
// (130, 23) @TEXT("0.05011 fF / 5%", size=1.05);
// %j8 = (113, 30);
// &AP @WIRE {#MNDAP:1 (100, 30) %j8 (128, 30) #CP_APLOAD:1};
// &AP @WIRE {#C_APLOAD:2 %j8};
// (113, 32) @TEXT("AP", size=1.05);
// #MNCANCEL @PLACE(109, -14) => @ORIENT("R0");
// #MNCANCEL @SET-SYMBOL $NMOS;
// #MNCANCEL @TEXT("ULVT 0.12u", key="model", size=1.05, dx=1.5, dy=-1);
// #MNCANCEL @TEXT("MNCANCEL", key="name", size=1.1, dx=1.5, dy=1);
// &NOFF @WIRE {#MNCANCEL:1 (115, -12) (115, -16) #MNCANCEL:3};
// (117, -14) @TEXT("NOFF", size=1.05);
// (96, 39) @TEXT("AP keeper + physical MOM load", size=1.05);
// (96, -25) @TEXT("ENB feedthrough cancellation", size=1.05);
// &ENB @WIRE {#MPA0:2 (3, 32)};
// (2.7, 32) @TEXT("ENB", size=1.05, halign="end", valign="middle");
// %t10 = $SUPPLY @ATTACH &DVDD => @PLACE(8, 36);
// &DVDD @WIRE {#MPA0:3 %t10:p};
// &HIB @WIRE {#MPA1:2 (3, 24)};
// (2.7, 24) @TEXT("HIB", size=1.05, halign="end", valign="middle");
// &ENB @WIRE {#MNA0:2 (-5, 8)};
// (-5.3, 8) @TEXT("ENB", size=1.05, halign="end", valign="middle");
// %t13 = $GROUND @ATTACH &VREFN => @PLACE(0, 4);
// &VREFN @WIRE {#MNA0:3 %t13:p};
// &HIB @WIRE {#MNA1:2 (11, 8)};
// (10.7, 8) @TEXT("HIB", size=1.05, halign="end", valign="middle");
// %t15 = $GROUND @ATTACH &VREFN => @PLACE(16, 4);
// &VREFN @WIRE {#MNA1:3 %t15:p};
// &EN @WIRE {#MPB0:2 (-5, -8)};
// (-5.3, -8) @TEXT("EN", size=1.05, halign="end", valign="middle");
// %t17 = $SUPPLY @ATTACH &DVDD => @PLACE(0, -4);
// &DVDD @WIRE {#MPB0:3 %t17:p};
// &HIB @WIRE {#MPB1:2 (11, -8)};
// (10.7, -8) @TEXT("HIB", size=1.05, halign="end", valign="middle");
// %t19 = $SUPPLY @ATTACH &DVDD => @PLACE(16, -4);
// &DVDD @WIRE {#MPB1:3 %t19:p};
// &EN @WIRE {#MNB0:2 (3, -24)};
// (2.7, -24) @TEXT("EN", size=1.05, halign="end", valign="middle");
// &HIB @WIRE {#MNB1:2 (3, -32)};
// (2.7, -32) @TEXT("HIB", size=1.05, halign="end", valign="middle");
// %t22 = $GROUND @ATTACH &VREFN => @PLACE(8, -36);
// &VREFN @WIRE {#MNB1:3 %t22:p};
// %t23 = $SUPPLY @ATTACH &VREFP => @PLACE(76, 22);
// &VREFP @WIRE {#MPOUT:3 %t23:p};
// %t24 = $GROUND @ATTACH &VREFN => @PLACE(76, -22);
// &VREFN @WIRE {#MNOUT:3 %t24:p};
// %t25 = $GROUND @ATTACH &VREFN => @PLACE(43, 5);
// &VREFN @WIRE {#MGPN:3 %t25:p};
// %t26 = $SUPPLY @ATTACH &VREFP => @PLACE(43, 27);
// &VREFP @WIRE {#MGPP:3 %t26:p};
// %t27 = $GROUND @ATTACH &VREFN => @PLACE(43, -27);
// &VREFN @WIRE {#MGNN:3 %t27:p};
// %t28 = $SUPPLY @ATTACH &VREFP => @PLACE(43, -5);
// &VREFP @WIRE {#MGNP:3 %t28:p};
// &ENB @WIRE {#MNDAP:2 (95, 24)};
// (94.7, 24) @TEXT("ENB", size=1.05, halign="end", valign="middle");
// %t30 = $GROUND @ATTACH &VREFN => @PLACE(100, 20);
// &VREFN @WIRE {#MNDAP:3 %t30:p};
// %t31 = $GROUND @ATTACH &VSS => @PLACE(113, 20);
// &VSS @WIRE {#C_APLOAD:1 %t31:p};
// %t32 = $GROUND @ATTACH &VSS => @PLACE(128, 20);
// &VSS @WIRE {#CP_APLOAD:2 %t32:p};
// &ENB @WIRE {#MNCANCEL:2 (104, -14)};
// (103.7, -14) @TEXT("ENB", size=1.05, halign="end", valign="middle");
// $JUNCTION @ATTACH %j1;
// $JUNCTION @ATTACH %j2;
// $JUNCTION @ATTACH %j3;
// $JUNCTION @ATTACH %j4;
// $JUNCTION @ATTACH %j5;
// $JUNCTION @ATTACH %j6;
// $JUNCTION @ATTACH %j7;
// $JUNCTION @ATTACH %j8;
// (-7, 51) @TEXT("V29 diagnostic only / NOT qualified | mq_cdac_drv4 | isolated DVDD logic / VREFP output", size=1.4, bold=true, textcolor="#17365d");
// (-7, 48.6) @TEXT("Drawing only | N bulk = VSS; L = 30 nm. P bulk DVDD: MPA0, MPA1, MPB0, MPB1; VREFP: MGPP, MGNP, MPOUT", size=1.05, textcolor="#52606d");
// }
ends mq_cdac_drv4

subckt mq_cdac_drv3 (HIB EN ENB BP VREFP VREFN VSS DVDD)
// DVDD prelogic: PCOND = NOR(ENB,HIB); NOFF = NAND(EN,HIB).
// Reference-powered final inverters restore GP and GN to VREFP/VREFN.
// Actual current overlap, settling and device stress require measurement.
MPA0 (AP ENB DVDD DVDD) pch_ulvt_mac w=2.4e-07 l=3e-08 nf=1
MPA1 (PCOND HIB AP DVDD) pch_ulvt_mac w=2.4e-07 l=3e-08 nf=1
MNA0 (PCOND ENB VREFN VSS) nch_ulvt_mac w=1.2e-07 l=3e-08 nf=1
MNA1 (PCOND HIB VREFN VSS) nch_ulvt_mac w=1.2e-07 l=3e-08 nf=1
MPB0 (NOFF EN DVDD DVDD) pch_ulvt_mac w=1.2e-07 l=3e-08 nf=1
MPB1 (NOFF HIB DVDD DVDD) pch_ulvt_mac w=1.2e-07 l=3e-08 nf=1
MNB0 (NOFF EN BN VSS) nch_ulvt_mac w=1.2e-07 l=3e-08 nf=1
MNB1 (BN HIB VREFN VSS) nch_ulvt_mac w=3.25e-07 l=3e-08 nf=1
MGPN (GP PCOND VREFN VSS) nch_mac w=2.4e-07 l=3e-08 nf=1
MGPP (GP PCOND VREFP VREFP) pch_mac w=3.6e-07 l=3e-08 nf=1
MGNN (GN NOFF VREFN VSS) nch_mac w=2.4e-07 l=3e-08 nf=1
MGNP (GN NOFF VREFP VREFP) pch_mac w=1.2e-07 l=3e-08 nf=1
MNOUT (BP GN VREFN VSS) nch_mac w=6.1e-07 l=3e-08 nf=1
MPOUT (BP GP VREFP VREFP) pch_mac w=1.215e-06 l=3e-08 nf=1
// Actively discharge AP while ENB turns the upper PMOS off.
MNDAP (AP ENB VREFN VSS) nch_ulvt_mac w=1.2e-07 l=3e-08 nf=1
// 1 existing physical MOM units, with 5% bottom Cp, slow AP feedthrough.
C_APLOAD (VSS AP) cfmom_2t w=5e-08 s=2.4e-07 nr=6 lr=1.69e-06 stm=2 spm=4 multi=1
CP_APLOAD (AP VSS) capacitor c=5.01145e-17
MNCANCEL (NOFF ENB NOFF VSS) nch_ulvt_mac w=1.2e-07 l=3e-08 nf=1
// @RNL {
// {&HIB &EN &ENB &BP &VREFP &VREFN &VSS &DVDD} @REMOVE-FROM $PORT_FILL_SET;
// &VSS @ADD-TO $GROUND_NET_SET;
// &VREFN @ADD-TO $GROUND_NET_SET;
// #MPA0 @PLACE(8, 32) => @ORIENT("R0");
// #MPA0 @SET-SYMBOL $PMOS;
// #MPA0 @TEXT("ULVT 0.24u", key="model", size=1.05, dx=1.5, dy=-1);
// #MPA0 @TEXT("MPA0", key="name", size=1.1, dx=1.5, dy=1);
// #MPA1 @PLACE(8, 24) => @ORIENT("R0");
// #MPA1 @SET-SYMBOL $PMOS;
// #MPA1 @TEXT("ULVT 0.24u", key="model", size=1.05, dx=1.5, dy=-1);
// #MPA1 @TEXT("MPA1", key="name", size=1.1, dx=1.5, dy=1);
// #MNA0 @PLACE(0, 8) => @ORIENT("R0");
// #MNA0 @SET-SYMBOL $NMOS;
// #MNA0 @TEXT("ULVT 0.12u", key="model", size=1.05, dx=1.5, dy=-1);
// #MNA0 @TEXT("MNA0", key="name", size=1.1, dx=1.5, dy=1);
// #MNA1 @PLACE(16, 8) => @ORIENT("R0");
// #MNA1 @SET-SYMBOL $NMOS;
// #MNA1 @TEXT("ULVT 0.12u", key="model", size=1.05, dx=1.5, dy=-1);
// #MNA1 @TEXT("MNA1", key="name", size=1.1, dx=1.5, dy=1);
// #MPB0 @PLACE(0, -8) => @ORIENT("R0");
// #MPB0 @SET-SYMBOL $PMOS;
// #MPB0 @TEXT("ULVT 0.12u", key="model", size=1.05, dx=1.5, dy=-1);
// #MPB0 @TEXT("MPB0", key="name", size=1.1, dx=1.5, dy=1);
// #MPB1 @PLACE(16, -8) => @ORIENT("R0");
// #MPB1 @SET-SYMBOL $PMOS;
// #MPB1 @TEXT("ULVT 0.12u", key="model", size=1.05, dx=1.5, dy=-1);
// #MPB1 @TEXT("MPB1", key="name", size=1.1, dx=1.5, dy=1);
// #MNB0 @PLACE(8, -24) => @ORIENT("R0");
// #MNB0 @SET-SYMBOL $NMOS;
// #MNB0 @TEXT("ULVT 0.12u", key="model", size=1.05, dx=1.5, dy=-1);
// #MNB0 @TEXT("MNB0", key="name", size=1.1, dx=1.5, dy=1);
// #MNB1 @PLACE(8, -32) => @ORIENT("R0");
// #MNB1 @SET-SYMBOL $NMOS;
// #MNB1 @TEXT("ULVT 0.325u", key="model", size=1.05, dx=1.5, dy=-1);
// #MNB1 @TEXT("MNB1", key="name", size=1.1, dx=1.5, dy=1);
// #MPOUT @PLACE(76, 18) => @ORIENT("R0");
// #MPOUT @SET-SYMBOL $PMOS;
// #MPOUT @TEXT("SVT 1.215u", key="model", size=1.05, dx=1.5, dy=-1);
// #MPOUT @TEXT("MPOUT", key="name", size=1.1, dx=1.5, dy=1);
// #MNOUT @PLACE(76, -18) => @ORIENT("R0");
// #MNOUT @SET-SYMBOL $NMOS;
// #MNOUT @TEXT("SVT 0.61u", key="model", size=1.05, dx=1.5, dy=-1);
// #MNOUT @TEXT("MNOUT", key="name", size=1.1, dx=1.5, dy=1);
// &AP @WIRE {#MPA0:1 #MPA1:3};
// (10, 28) @TEXT("AP", size=1.05);
// %j1 = (8, 16);
// &PCOND @WIRE {#MNA0:1 (0, 16) %j1 (16, 16) #MNA1:1};
// &PCOND @WIRE {#MPA1:1 %j1};
// #MGPN @PLACE(43, 9) => @ORIENT("R0");
// #MGPN @SET-SYMBOL $NMOS;
// #MGPN @TEXT("SVT 0.24u", key="model", size=1.05, dx=1.5, dy=-1);
// #MGPN @TEXT("MGPN", key="name", size=1.1, dx=1.5, dy=1);
// #MGPP @PLACE(43, 23) => @ORIENT("R0");
// #MGPP @SET-SYMBOL $PMOS;
// #MGPP @TEXT("SVT 0.36u", key="model", size=1.05, dx=1.5, dy=-1);
// #MGPP @TEXT("MGPP", key="name", size=1.1, dx=1.5, dy=1);
// %j2 = (43, 16);
// %j3 = (38, 16);
// &GP @WIRE {#MGPN:1 %j2 #MGPP:1};
// &PCOND @WIRE {#MGPN:2 (38, 9) %j3 (38, 23) #MGPP:2};
// &PCOND @WIRE {%j1 %j3};
// &GP @WIRE {%j2 (65, 16) (65, 18) #MPOUT:2};
// %j4 = (8, -16);
// &NOFF @WIRE {#MPB0:1 (0, -16) %j4 (16, -16) #MPB1:1};
// &NOFF @WIRE {#MNB0:1 %j4};
// &BN @WIRE {#MNB0:3 #MNB1:1};
// (18, -14) @TEXT("NOFF", size=1.05);
// #MGNN @PLACE(43, -23) => @ORIENT("R0");
// #MGNN @SET-SYMBOL $NMOS;
// #MGNN @TEXT("SVT 0.24u", key="model", size=1.05, dx=1.5, dy=-1);
// #MGNN @TEXT("MGNN", key="name", size=1.1, dx=1.5, dy=1);
// #MGNP @PLACE(43, -9) => @ORIENT("R0");
// #MGNP @SET-SYMBOL $PMOS;
// #MGNP @TEXT("SVT 0.12u", key="model", size=1.05, dx=1.5, dy=-1);
// #MGNP @TEXT("MGNP", key="name", size=1.1, dx=1.5, dy=1);
// %j5 = (43, -16);
// %j6 = (38, -16);
// &GN @WIRE {#MGNN:1 %j5 #MGNP:1};
// &NOFF @WIRE {#MGNN:2 (38, -23) %j6 (38, -9) #MGNP:2};
// &NOFF @WIRE {%j4 %j6};
// &GN @WIRE {%j5 (65, -16) (65, -18) #MNOUT:2};
// %j7 = (76, 0);
// &BP @WIRE {#MPOUT:1 %j7 #MNOUT:1};
// &BP @WIRE {%j7 (85, 0)};
// (85, 1) @TEXT("BP", size=1.05);
// (-5, 42) @TEXT("NOR: PCOND = ~(ENB | HIB)", size=1.05);
// (-5, -42) @TEXT("NAND: NOFF = ~(EN & HIB)", size=1.05);
// (31, 39) @TEXT("Reference gate drivers", size=1.05);
// (67, 39) @TEXT("Output rail switch", size=1.05);
// #MNDAP @PLACE(100, 24) => @ORIENT("R0");
// #MNDAP @SET-SYMBOL $NMOS;
// #MNDAP @TEXT("ULVT 0.12u", key="model", size=1.05, dx=1.5, dy=-1);
// #MNDAP @TEXT("MNDAP", key="name", size=1.1, dx=1.5, dy=1);
// #C_APLOAD @PLACE(113, 24) => @ORIENT("MX");
// #C_APLOAD @TEXT("", key="value");
// #C_APLOAD @TEXT("", key="name");
// (115, 25) @TEXT("C_APLOAD", size=1.05);
// (115, 23) @TEXT("1 Cu", size=1.05);
// #CP_APLOAD @PLACE(128, 24) => @ORIENT("R0");
// #CP_APLOAD @TEXT("", key="value");
// #CP_APLOAD @TEXT("", key="name");
// (130, 25) @TEXT("CP_APLOAD", size=1.05);
// (130, 23) @TEXT("0.05011 fF / 5%", size=1.05);
// %j8 = (113, 30);
// &AP @WIRE {#MNDAP:1 (100, 30) %j8 (128, 30) #CP_APLOAD:1};
// &AP @WIRE {#C_APLOAD:2 %j8};
// (113, 32) @TEXT("AP", size=1.05);
// #MNCANCEL @PLACE(109, -14) => @ORIENT("R0");
// #MNCANCEL @SET-SYMBOL $NMOS;
// #MNCANCEL @TEXT("ULVT 0.12u", key="model", size=1.05, dx=1.5, dy=-1);
// #MNCANCEL @TEXT("MNCANCEL", key="name", size=1.1, dx=1.5, dy=1);
// &NOFF @WIRE {#MNCANCEL:1 (115, -12) (115, -16) #MNCANCEL:3};
// (117, -14) @TEXT("NOFF", size=1.05);
// (96, 39) @TEXT("AP keeper + physical MOM load", size=1.05);
// (96, -25) @TEXT("ENB feedthrough cancellation", size=1.05);
// &ENB @WIRE {#MPA0:2 (3, 32)};
// (2.7, 32) @TEXT("ENB", size=1.05, halign="end", valign="middle");
// %t10 = $SUPPLY @ATTACH &DVDD => @PLACE(8, 36);
// &DVDD @WIRE {#MPA0:3 %t10:p};
// &HIB @WIRE {#MPA1:2 (3, 24)};
// (2.7, 24) @TEXT("HIB", size=1.05, halign="end", valign="middle");
// &ENB @WIRE {#MNA0:2 (-5, 8)};
// (-5.3, 8) @TEXT("ENB", size=1.05, halign="end", valign="middle");
// %t13 = $GROUND @ATTACH &VREFN => @PLACE(0, 4);
// &VREFN @WIRE {#MNA0:3 %t13:p};
// &HIB @WIRE {#MNA1:2 (11, 8)};
// (10.7, 8) @TEXT("HIB", size=1.05, halign="end", valign="middle");
// %t15 = $GROUND @ATTACH &VREFN => @PLACE(16, 4);
// &VREFN @WIRE {#MNA1:3 %t15:p};
// &EN @WIRE {#MPB0:2 (-5, -8)};
// (-5.3, -8) @TEXT("EN", size=1.05, halign="end", valign="middle");
// %t17 = $SUPPLY @ATTACH &DVDD => @PLACE(0, -4);
// &DVDD @WIRE {#MPB0:3 %t17:p};
// &HIB @WIRE {#MPB1:2 (11, -8)};
// (10.7, -8) @TEXT("HIB", size=1.05, halign="end", valign="middle");
// %t19 = $SUPPLY @ATTACH &DVDD => @PLACE(16, -4);
// &DVDD @WIRE {#MPB1:3 %t19:p};
// &EN @WIRE {#MNB0:2 (3, -24)};
// (2.7, -24) @TEXT("EN", size=1.05, halign="end", valign="middle");
// &HIB @WIRE {#MNB1:2 (3, -32)};
// (2.7, -32) @TEXT("HIB", size=1.05, halign="end", valign="middle");
// %t22 = $GROUND @ATTACH &VREFN => @PLACE(8, -36);
// &VREFN @WIRE {#MNB1:3 %t22:p};
// %t23 = $SUPPLY @ATTACH &VREFP => @PLACE(76, 22);
// &VREFP @WIRE {#MPOUT:3 %t23:p};
// %t24 = $GROUND @ATTACH &VREFN => @PLACE(76, -22);
// &VREFN @WIRE {#MNOUT:3 %t24:p};
// %t25 = $GROUND @ATTACH &VREFN => @PLACE(43, 5);
// &VREFN @WIRE {#MGPN:3 %t25:p};
// %t26 = $SUPPLY @ATTACH &VREFP => @PLACE(43, 27);
// &VREFP @WIRE {#MGPP:3 %t26:p};
// %t27 = $GROUND @ATTACH &VREFN => @PLACE(43, -27);
// &VREFN @WIRE {#MGNN:3 %t27:p};
// %t28 = $SUPPLY @ATTACH &VREFP => @PLACE(43, -5);
// &VREFP @WIRE {#MGNP:3 %t28:p};
// &ENB @WIRE {#MNDAP:2 (95, 24)};
// (94.7, 24) @TEXT("ENB", size=1.05, halign="end", valign="middle");
// %t30 = $GROUND @ATTACH &VREFN => @PLACE(100, 20);
// &VREFN @WIRE {#MNDAP:3 %t30:p};
// %t31 = $GROUND @ATTACH &VSS => @PLACE(113, 20);
// &VSS @WIRE {#C_APLOAD:1 %t31:p};
// %t32 = $GROUND @ATTACH &VSS => @PLACE(128, 20);
// &VSS @WIRE {#CP_APLOAD:2 %t32:p};
// &ENB @WIRE {#MNCANCEL:2 (104, -14)};
// (103.7, -14) @TEXT("ENB", size=1.05, halign="end", valign="middle");
// $JUNCTION @ATTACH %j1;
// $JUNCTION @ATTACH %j2;
// $JUNCTION @ATTACH %j3;
// $JUNCTION @ATTACH %j4;
// $JUNCTION @ATTACH %j5;
// $JUNCTION @ATTACH %j6;
// $JUNCTION @ATTACH %j7;
// $JUNCTION @ATTACH %j8;
// (-7, 51) @TEXT("V29 diagnostic only / NOT qualified | mq_cdac_drv3 | isolated DVDD logic / VREFP output", size=1.4, bold=true, textcolor="#17365d");
// (-7, 48.6) @TEXT("Drawing only | N bulk = VSS; L = 30 nm. P bulk DVDD: MPA0, MPA1, MPB0, MPB1; VREFP: MGPP, MGNP, MPOUT", size=1.05, textcolor="#52606d");
// }
ends mq_cdac_drv3

subckt mq_cdac_drv2 (HIB EN ENB BP VREFP VREFN VSS DVDD)
// DVDD prelogic: PCOND = NOR(ENB,HIB); NOFF = NAND(EN,HIB).
// Reference-powered final inverters restore GP and GN to VREFP/VREFN.
// Actual current overlap, settling and device stress require measurement.
MPA0 (AP ENB DVDD DVDD) pch_ulvt_mac w=2.4e-07 l=3e-08 nf=1
MPA1 (PCOND HIB AP DVDD) pch_ulvt_mac w=2.4e-07 l=3e-08 nf=1
MNA0 (PCOND ENB VREFN VSS) nch_ulvt_mac w=1.2e-07 l=3e-08 nf=1
MNA1 (PCOND HIB VREFN VSS) nch_ulvt_mac w=1.2e-07 l=3e-08 nf=1
MPB0 (NOFF EN DVDD DVDD) pch_ulvt_mac w=1.2e-07 l=3e-08 nf=1
MPB1 (NOFF HIB DVDD DVDD) pch_ulvt_mac w=1.2e-07 l=3e-08 nf=1
MNB0 (NOFF EN BN VSS) nch_ulvt_mac w=1.2e-07 l=3e-08 nf=1
MNB1 (BN HIB VREFN VSS) nch_ulvt_mac w=3.25e-07 l=3e-08 nf=1
MGPN (GP PCOND VREFN VSS) nch_mac w=2.4e-07 l=3e-08 nf=1
MGPP (GP PCOND VREFP VREFP) pch_mac w=3.6e-07 l=3e-08 nf=1
MGNN (GN NOFF VREFN VSS) nch_mac w=2.4e-07 l=3e-08 nf=1
MGNP (GN NOFF VREFP VREFP) pch_mac w=1.2e-07 l=3e-08 nf=1
MNOUT (BP GN VREFN VSS) nch_mac w=6.1e-07 l=3e-08 nf=1
MPOUT (BP GP VREFP VREFP) pch_mac w=1.215e-06 l=3e-08 nf=1
// Actively discharge AP while ENB turns the upper PMOS off.
MNDAP (AP ENB VREFN VSS) nch_ulvt_mac w=1.2e-07 l=3e-08 nf=1
// 1 existing physical MOM units, with 5% bottom Cp, slow AP feedthrough.
C_APLOAD (VSS AP) cfmom_2t w=5e-08 s=2.4e-07 nr=6 lr=1.69e-06 stm=2 spm=4 multi=1
CP_APLOAD (AP VSS) capacitor c=5.01145e-17
MNCANCEL (NOFF ENB NOFF VSS) nch_ulvt_mac w=1.2e-07 l=3e-08 nf=1
// @RNL {
// {&HIB &EN &ENB &BP &VREFP &VREFN &VSS &DVDD} @REMOVE-FROM $PORT_FILL_SET;
// &VSS @ADD-TO $GROUND_NET_SET;
// &VREFN @ADD-TO $GROUND_NET_SET;
// #MPA0 @PLACE(8, 32) => @ORIENT("R0");
// #MPA0 @SET-SYMBOL $PMOS;
// #MPA0 @TEXT("ULVT 0.24u", key="model", size=1.05, dx=1.5, dy=-1);
// #MPA0 @TEXT("MPA0", key="name", size=1.1, dx=1.5, dy=1);
// #MPA1 @PLACE(8, 24) => @ORIENT("R0");
// #MPA1 @SET-SYMBOL $PMOS;
// #MPA1 @TEXT("ULVT 0.24u", key="model", size=1.05, dx=1.5, dy=-1);
// #MPA1 @TEXT("MPA1", key="name", size=1.1, dx=1.5, dy=1);
// #MNA0 @PLACE(0, 8) => @ORIENT("R0");
// #MNA0 @SET-SYMBOL $NMOS;
// #MNA0 @TEXT("ULVT 0.12u", key="model", size=1.05, dx=1.5, dy=-1);
// #MNA0 @TEXT("MNA0", key="name", size=1.1, dx=1.5, dy=1);
// #MNA1 @PLACE(16, 8) => @ORIENT("R0");
// #MNA1 @SET-SYMBOL $NMOS;
// #MNA1 @TEXT("ULVT 0.12u", key="model", size=1.05, dx=1.5, dy=-1);
// #MNA1 @TEXT("MNA1", key="name", size=1.1, dx=1.5, dy=1);
// #MPB0 @PLACE(0, -8) => @ORIENT("R0");
// #MPB0 @SET-SYMBOL $PMOS;
// #MPB0 @TEXT("ULVT 0.12u", key="model", size=1.05, dx=1.5, dy=-1);
// #MPB0 @TEXT("MPB0", key="name", size=1.1, dx=1.5, dy=1);
// #MPB1 @PLACE(16, -8) => @ORIENT("R0");
// #MPB1 @SET-SYMBOL $PMOS;
// #MPB1 @TEXT("ULVT 0.12u", key="model", size=1.05, dx=1.5, dy=-1);
// #MPB1 @TEXT("MPB1", key="name", size=1.1, dx=1.5, dy=1);
// #MNB0 @PLACE(8, -24) => @ORIENT("R0");
// #MNB0 @SET-SYMBOL $NMOS;
// #MNB0 @TEXT("ULVT 0.12u", key="model", size=1.05, dx=1.5, dy=-1);
// #MNB0 @TEXT("MNB0", key="name", size=1.1, dx=1.5, dy=1);
// #MNB1 @PLACE(8, -32) => @ORIENT("R0");
// #MNB1 @SET-SYMBOL $NMOS;
// #MNB1 @TEXT("ULVT 0.325u", key="model", size=1.05, dx=1.5, dy=-1);
// #MNB1 @TEXT("MNB1", key="name", size=1.1, dx=1.5, dy=1);
// #MPOUT @PLACE(76, 18) => @ORIENT("R0");
// #MPOUT @SET-SYMBOL $PMOS;
// #MPOUT @TEXT("SVT 1.215u", key="model", size=1.05, dx=1.5, dy=-1);
// #MPOUT @TEXT("MPOUT", key="name", size=1.1, dx=1.5, dy=1);
// #MNOUT @PLACE(76, -18) => @ORIENT("R0");
// #MNOUT @SET-SYMBOL $NMOS;
// #MNOUT @TEXT("SVT 0.61u", key="model", size=1.05, dx=1.5, dy=-1);
// #MNOUT @TEXT("MNOUT", key="name", size=1.1, dx=1.5, dy=1);
// &AP @WIRE {#MPA0:1 #MPA1:3};
// (10, 28) @TEXT("AP", size=1.05);
// %j1 = (8, 16);
// &PCOND @WIRE {#MNA0:1 (0, 16) %j1 (16, 16) #MNA1:1};
// &PCOND @WIRE {#MPA1:1 %j1};
// #MGPN @PLACE(43, 9) => @ORIENT("R0");
// #MGPN @SET-SYMBOL $NMOS;
// #MGPN @TEXT("SVT 0.24u", key="model", size=1.05, dx=1.5, dy=-1);
// #MGPN @TEXT("MGPN", key="name", size=1.1, dx=1.5, dy=1);
// #MGPP @PLACE(43, 23) => @ORIENT("R0");
// #MGPP @SET-SYMBOL $PMOS;
// #MGPP @TEXT("SVT 0.36u", key="model", size=1.05, dx=1.5, dy=-1);
// #MGPP @TEXT("MGPP", key="name", size=1.1, dx=1.5, dy=1);
// %j2 = (43, 16);
// %j3 = (38, 16);
// &GP @WIRE {#MGPN:1 %j2 #MGPP:1};
// &PCOND @WIRE {#MGPN:2 (38, 9) %j3 (38, 23) #MGPP:2};
// &PCOND @WIRE {%j1 %j3};
// &GP @WIRE {%j2 (65, 16) (65, 18) #MPOUT:2};
// %j4 = (8, -16);
// &NOFF @WIRE {#MPB0:1 (0, -16) %j4 (16, -16) #MPB1:1};
// &NOFF @WIRE {#MNB0:1 %j4};
// &BN @WIRE {#MNB0:3 #MNB1:1};
// (18, -14) @TEXT("NOFF", size=1.05);
// #MGNN @PLACE(43, -23) => @ORIENT("R0");
// #MGNN @SET-SYMBOL $NMOS;
// #MGNN @TEXT("SVT 0.24u", key="model", size=1.05, dx=1.5, dy=-1);
// #MGNN @TEXT("MGNN", key="name", size=1.1, dx=1.5, dy=1);
// #MGNP @PLACE(43, -9) => @ORIENT("R0");
// #MGNP @SET-SYMBOL $PMOS;
// #MGNP @TEXT("SVT 0.12u", key="model", size=1.05, dx=1.5, dy=-1);
// #MGNP @TEXT("MGNP", key="name", size=1.1, dx=1.5, dy=1);
// %j5 = (43, -16);
// %j6 = (38, -16);
// &GN @WIRE {#MGNN:1 %j5 #MGNP:1};
// &NOFF @WIRE {#MGNN:2 (38, -23) %j6 (38, -9) #MGNP:2};
// &NOFF @WIRE {%j4 %j6};
// &GN @WIRE {%j5 (65, -16) (65, -18) #MNOUT:2};
// %j7 = (76, 0);
// &BP @WIRE {#MPOUT:1 %j7 #MNOUT:1};
// &BP @WIRE {%j7 (85, 0)};
// (85, 1) @TEXT("BP", size=1.05);
// (-5, 42) @TEXT("NOR: PCOND = ~(ENB | HIB)", size=1.05);
// (-5, -42) @TEXT("NAND: NOFF = ~(EN & HIB)", size=1.05);
// (31, 39) @TEXT("Reference gate drivers", size=1.05);
// (67, 39) @TEXT("Output rail switch", size=1.05);
// #MNDAP @PLACE(100, 24) => @ORIENT("R0");
// #MNDAP @SET-SYMBOL $NMOS;
// #MNDAP @TEXT("ULVT 0.12u", key="model", size=1.05, dx=1.5, dy=-1);
// #MNDAP @TEXT("MNDAP", key="name", size=1.1, dx=1.5, dy=1);
// #C_APLOAD @PLACE(113, 24) => @ORIENT("MX");
// #C_APLOAD @TEXT("", key="value");
// #C_APLOAD @TEXT("", key="name");
// (115, 25) @TEXT("C_APLOAD", size=1.05);
// (115, 23) @TEXT("1 Cu", size=1.05);
// #CP_APLOAD @PLACE(128, 24) => @ORIENT("R0");
// #CP_APLOAD @TEXT("", key="value");
// #CP_APLOAD @TEXT("", key="name");
// (130, 25) @TEXT("CP_APLOAD", size=1.05);
// (130, 23) @TEXT("0.05011 fF / 5%", size=1.05);
// %j8 = (113, 30);
// &AP @WIRE {#MNDAP:1 (100, 30) %j8 (128, 30) #CP_APLOAD:1};
// &AP @WIRE {#C_APLOAD:2 %j8};
// (113, 32) @TEXT("AP", size=1.05);
// #MNCANCEL @PLACE(109, -14) => @ORIENT("R0");
// #MNCANCEL @SET-SYMBOL $NMOS;
// #MNCANCEL @TEXT("ULVT 0.12u", key="model", size=1.05, dx=1.5, dy=-1);
// #MNCANCEL @TEXT("MNCANCEL", key="name", size=1.1, dx=1.5, dy=1);
// &NOFF @WIRE {#MNCANCEL:1 (115, -12) (115, -16) #MNCANCEL:3};
// (117, -14) @TEXT("NOFF", size=1.05);
// (96, 39) @TEXT("AP keeper + physical MOM load", size=1.05);
// (96, -25) @TEXT("ENB feedthrough cancellation", size=1.05);
// &ENB @WIRE {#MPA0:2 (3, 32)};
// (2.7, 32) @TEXT("ENB", size=1.05, halign="end", valign="middle");
// %t10 = $SUPPLY @ATTACH &DVDD => @PLACE(8, 36);
// &DVDD @WIRE {#MPA0:3 %t10:p};
// &HIB @WIRE {#MPA1:2 (3, 24)};
// (2.7, 24) @TEXT("HIB", size=1.05, halign="end", valign="middle");
// &ENB @WIRE {#MNA0:2 (-5, 8)};
// (-5.3, 8) @TEXT("ENB", size=1.05, halign="end", valign="middle");
// %t13 = $GROUND @ATTACH &VREFN => @PLACE(0, 4);
// &VREFN @WIRE {#MNA0:3 %t13:p};
// &HIB @WIRE {#MNA1:2 (11, 8)};
// (10.7, 8) @TEXT("HIB", size=1.05, halign="end", valign="middle");
// %t15 = $GROUND @ATTACH &VREFN => @PLACE(16, 4);
// &VREFN @WIRE {#MNA1:3 %t15:p};
// &EN @WIRE {#MPB0:2 (-5, -8)};
// (-5.3, -8) @TEXT("EN", size=1.05, halign="end", valign="middle");
// %t17 = $SUPPLY @ATTACH &DVDD => @PLACE(0, -4);
// &DVDD @WIRE {#MPB0:3 %t17:p};
// &HIB @WIRE {#MPB1:2 (11, -8)};
// (10.7, -8) @TEXT("HIB", size=1.05, halign="end", valign="middle");
// %t19 = $SUPPLY @ATTACH &DVDD => @PLACE(16, -4);
// &DVDD @WIRE {#MPB1:3 %t19:p};
// &EN @WIRE {#MNB0:2 (3, -24)};
// (2.7, -24) @TEXT("EN", size=1.05, halign="end", valign="middle");
// &HIB @WIRE {#MNB1:2 (3, -32)};
// (2.7, -32) @TEXT("HIB", size=1.05, halign="end", valign="middle");
// %t22 = $GROUND @ATTACH &VREFN => @PLACE(8, -36);
// &VREFN @WIRE {#MNB1:3 %t22:p};
// %t23 = $SUPPLY @ATTACH &VREFP => @PLACE(76, 22);
// &VREFP @WIRE {#MPOUT:3 %t23:p};
// %t24 = $GROUND @ATTACH &VREFN => @PLACE(76, -22);
// &VREFN @WIRE {#MNOUT:3 %t24:p};
// %t25 = $GROUND @ATTACH &VREFN => @PLACE(43, 5);
// &VREFN @WIRE {#MGPN:3 %t25:p};
// %t26 = $SUPPLY @ATTACH &VREFP => @PLACE(43, 27);
// &VREFP @WIRE {#MGPP:3 %t26:p};
// %t27 = $GROUND @ATTACH &VREFN => @PLACE(43, -27);
// &VREFN @WIRE {#MGNN:3 %t27:p};
// %t28 = $SUPPLY @ATTACH &VREFP => @PLACE(43, -5);
// &VREFP @WIRE {#MGNP:3 %t28:p};
// &ENB @WIRE {#MNDAP:2 (95, 24)};
// (94.7, 24) @TEXT("ENB", size=1.05, halign="end", valign="middle");
// %t30 = $GROUND @ATTACH &VREFN => @PLACE(100, 20);
// &VREFN @WIRE {#MNDAP:3 %t30:p};
// %t31 = $GROUND @ATTACH &VSS => @PLACE(113, 20);
// &VSS @WIRE {#C_APLOAD:1 %t31:p};
// %t32 = $GROUND @ATTACH &VSS => @PLACE(128, 20);
// &VSS @WIRE {#CP_APLOAD:2 %t32:p};
// &ENB @WIRE {#MNCANCEL:2 (104, -14)};
// (103.7, -14) @TEXT("ENB", size=1.05, halign="end", valign="middle");
// $JUNCTION @ATTACH %j1;
// $JUNCTION @ATTACH %j2;
// $JUNCTION @ATTACH %j3;
// $JUNCTION @ATTACH %j4;
// $JUNCTION @ATTACH %j5;
// $JUNCTION @ATTACH %j6;
// $JUNCTION @ATTACH %j7;
// $JUNCTION @ATTACH %j8;
// (-7, 51) @TEXT("V29 diagnostic only / NOT qualified | mq_cdac_drv2 | isolated DVDD logic / VREFP output", size=1.4, bold=true, textcolor="#17365d");
// (-7, 48.6) @TEXT("Drawing only | N bulk = VSS; L = 30 nm. P bulk DVDD: MPA0, MPA1, MPB0, MPB1; VREFP: MGPP, MGNP, MPOUT", size=1.05, textcolor="#52606d");
// }
ends mq_cdac_drv2

subckt mq_cdac_drv1 (HIB EN ENB BP VREFP VREFN VSS DVDD)
// DVDD prelogic: PCOND = NOR(ENB,HIB); NOFF = NAND(EN,HIB).
// Reference-powered final inverters restore GP and GN to VREFP/VREFN.
// Actual current overlap, settling and device stress require measurement.
MPA0 (AP ENB DVDD DVDD) pch_ulvt_mac w=2.4e-07 l=3e-08 nf=1
MPA1 (PCOND HIB AP DVDD) pch_ulvt_mac w=2.4e-07 l=3e-08 nf=1
MNA0 (PCOND ENB VREFN VSS) nch_ulvt_mac w=1.2e-07 l=3e-08 nf=1
MNA1 (PCOND HIB VREFN VSS) nch_ulvt_mac w=1.2e-07 l=3e-08 nf=1
MPB0 (NOFF EN DVDD DVDD) pch_ulvt_mac w=1.2e-07 l=3e-08 nf=1
MPB1 (NOFF HIB DVDD DVDD) pch_ulvt_mac w=1.2e-07 l=3e-08 nf=1
MNB0 (NOFF EN BN VSS) nch_ulvt_mac w=1.2e-07 l=3e-08 nf=1
MNB1 (BN HIB VREFN VSS) nch_ulvt_mac w=3.25e-07 l=3e-08 nf=1
MGPN (GP PCOND VREFN VSS) nch_mac w=2.4e-07 l=3e-08 nf=1
MGPP (GP PCOND VREFP VREFP) pch_mac w=3.6e-07 l=3e-08 nf=1
MGNN (GN NOFF VREFN VSS) nch_mac w=2.4e-07 l=3e-08 nf=1
MGNP (GN NOFF VREFP VREFP) pch_mac w=1.2e-07 l=3e-08 nf=1
MNOUT (BP GN VREFN VSS) nch_mac w=1.6e-07 l=3e-08 nf=1
MPOUT (BP GP VREFP VREFP) pch_mac w=3.25e-07 l=3e-08 nf=1
// Actively discharge AP while ENB turns the upper PMOS off.
MNDAP (AP ENB VREFN VSS) nch_ulvt_mac w=1.2e-07 l=3e-08 nf=1
// 1 existing physical MOM units, with 5% bottom Cp, slow AP feedthrough.
C_APLOAD (VSS AP) cfmom_2t w=5e-08 s=2.4e-07 nr=6 lr=1.69e-06 stm=2 spm=4 multi=1
CP_APLOAD (AP VSS) capacitor c=5.01145e-17
MNCANCEL (NOFF ENB NOFF VSS) nch_ulvt_mac w=1.2e-07 l=3e-08 nf=1
// @RNL {
// {&HIB &EN &ENB &BP &VREFP &VREFN &VSS &DVDD} @REMOVE-FROM $PORT_FILL_SET;
// &VSS @ADD-TO $GROUND_NET_SET;
// &VREFN @ADD-TO $GROUND_NET_SET;
// #MPA0 @PLACE(8, 32) => @ORIENT("R0");
// #MPA0 @SET-SYMBOL $PMOS;
// #MPA0 @TEXT("ULVT 0.24u", key="model", size=1.05, dx=1.5, dy=-1);
// #MPA0 @TEXT("MPA0", key="name", size=1.1, dx=1.5, dy=1);
// #MPA1 @PLACE(8, 24) => @ORIENT("R0");
// #MPA1 @SET-SYMBOL $PMOS;
// #MPA1 @TEXT("ULVT 0.24u", key="model", size=1.05, dx=1.5, dy=-1);
// #MPA1 @TEXT("MPA1", key="name", size=1.1, dx=1.5, dy=1);
// #MNA0 @PLACE(0, 8) => @ORIENT("R0");
// #MNA0 @SET-SYMBOL $NMOS;
// #MNA0 @TEXT("ULVT 0.12u", key="model", size=1.05, dx=1.5, dy=-1);
// #MNA0 @TEXT("MNA0", key="name", size=1.1, dx=1.5, dy=1);
// #MNA1 @PLACE(16, 8) => @ORIENT("R0");
// #MNA1 @SET-SYMBOL $NMOS;
// #MNA1 @TEXT("ULVT 0.12u", key="model", size=1.05, dx=1.5, dy=-1);
// #MNA1 @TEXT("MNA1", key="name", size=1.1, dx=1.5, dy=1);
// #MPB0 @PLACE(0, -8) => @ORIENT("R0");
// #MPB0 @SET-SYMBOL $PMOS;
// #MPB0 @TEXT("ULVT 0.12u", key="model", size=1.05, dx=1.5, dy=-1);
// #MPB0 @TEXT("MPB0", key="name", size=1.1, dx=1.5, dy=1);
// #MPB1 @PLACE(16, -8) => @ORIENT("R0");
// #MPB1 @SET-SYMBOL $PMOS;
// #MPB1 @TEXT("ULVT 0.12u", key="model", size=1.05, dx=1.5, dy=-1);
// #MPB1 @TEXT("MPB1", key="name", size=1.1, dx=1.5, dy=1);
// #MNB0 @PLACE(8, -24) => @ORIENT("R0");
// #MNB0 @SET-SYMBOL $NMOS;
// #MNB0 @TEXT("ULVT 0.12u", key="model", size=1.05, dx=1.5, dy=-1);
// #MNB0 @TEXT("MNB0", key="name", size=1.1, dx=1.5, dy=1);
// #MNB1 @PLACE(8, -32) => @ORIENT("R0");
// #MNB1 @SET-SYMBOL $NMOS;
// #MNB1 @TEXT("ULVT 0.325u", key="model", size=1.05, dx=1.5, dy=-1);
// #MNB1 @TEXT("MNB1", key="name", size=1.1, dx=1.5, dy=1);
// #MPOUT @PLACE(76, 18) => @ORIENT("R0");
// #MPOUT @SET-SYMBOL $PMOS;
// #MPOUT @TEXT("SVT 0.325u", key="model", size=1.05, dx=1.5, dy=-1);
// #MPOUT @TEXT("MPOUT", key="name", size=1.1, dx=1.5, dy=1);
// #MNOUT @PLACE(76, -18) => @ORIENT("R0");
// #MNOUT @SET-SYMBOL $NMOS;
// #MNOUT @TEXT("SVT 0.16u", key="model", size=1.05, dx=1.5, dy=-1);
// #MNOUT @TEXT("MNOUT", key="name", size=1.1, dx=1.5, dy=1);
// &AP @WIRE {#MPA0:1 #MPA1:3};
// (10, 28) @TEXT("AP", size=1.05);
// %j1 = (8, 16);
// &PCOND @WIRE {#MNA0:1 (0, 16) %j1 (16, 16) #MNA1:1};
// &PCOND @WIRE {#MPA1:1 %j1};
// #MGPN @PLACE(43, 9) => @ORIENT("R0");
// #MGPN @SET-SYMBOL $NMOS;
// #MGPN @TEXT("SVT 0.24u", key="model", size=1.05, dx=1.5, dy=-1);
// #MGPN @TEXT("MGPN", key="name", size=1.1, dx=1.5, dy=1);
// #MGPP @PLACE(43, 23) => @ORIENT("R0");
// #MGPP @SET-SYMBOL $PMOS;
// #MGPP @TEXT("SVT 0.36u", key="model", size=1.05, dx=1.5, dy=-1);
// #MGPP @TEXT("MGPP", key="name", size=1.1, dx=1.5, dy=1);
// %j2 = (43, 16);
// %j3 = (38, 16);
// &GP @WIRE {#MGPN:1 %j2 #MGPP:1};
// &PCOND @WIRE {#MGPN:2 (38, 9) %j3 (38, 23) #MGPP:2};
// &PCOND @WIRE {%j1 %j3};
// &GP @WIRE {%j2 (65, 16) (65, 18) #MPOUT:2};
// %j4 = (8, -16);
// &NOFF @WIRE {#MPB0:1 (0, -16) %j4 (16, -16) #MPB1:1};
// &NOFF @WIRE {#MNB0:1 %j4};
// &BN @WIRE {#MNB0:3 #MNB1:1};
// (18, -14) @TEXT("NOFF", size=1.05);
// #MGNN @PLACE(43, -23) => @ORIENT("R0");
// #MGNN @SET-SYMBOL $NMOS;
// #MGNN @TEXT("SVT 0.24u", key="model", size=1.05, dx=1.5, dy=-1);
// #MGNN @TEXT("MGNN", key="name", size=1.1, dx=1.5, dy=1);
// #MGNP @PLACE(43, -9) => @ORIENT("R0");
// #MGNP @SET-SYMBOL $PMOS;
// #MGNP @TEXT("SVT 0.12u", key="model", size=1.05, dx=1.5, dy=-1);
// #MGNP @TEXT("MGNP", key="name", size=1.1, dx=1.5, dy=1);
// %j5 = (43, -16);
// %j6 = (38, -16);
// &GN @WIRE {#MGNN:1 %j5 #MGNP:1};
// &NOFF @WIRE {#MGNN:2 (38, -23) %j6 (38, -9) #MGNP:2};
// &NOFF @WIRE {%j4 %j6};
// &GN @WIRE {%j5 (65, -16) (65, -18) #MNOUT:2};
// %j7 = (76, 0);
// &BP @WIRE {#MPOUT:1 %j7 #MNOUT:1};
// &BP @WIRE {%j7 (85, 0)};
// (85, 1) @TEXT("BP", size=1.05);
// (-5, 42) @TEXT("NOR: PCOND = ~(ENB | HIB)", size=1.05);
// (-5, -42) @TEXT("NAND: NOFF = ~(EN & HIB)", size=1.05);
// (31, 39) @TEXT("Reference gate drivers", size=1.05);
// (67, 39) @TEXT("Output rail switch", size=1.05);
// #MNDAP @PLACE(100, 24) => @ORIENT("R0");
// #MNDAP @SET-SYMBOL $NMOS;
// #MNDAP @TEXT("ULVT 0.12u", key="model", size=1.05, dx=1.5, dy=-1);
// #MNDAP @TEXT("MNDAP", key="name", size=1.1, dx=1.5, dy=1);
// #C_APLOAD @PLACE(113, 24) => @ORIENT("MX");
// #C_APLOAD @TEXT("", key="value");
// #C_APLOAD @TEXT("", key="name");
// (115, 25) @TEXT("C_APLOAD", size=1.05);
// (115, 23) @TEXT("1 Cu", size=1.05);
// #CP_APLOAD @PLACE(128, 24) => @ORIENT("R0");
// #CP_APLOAD @TEXT("", key="value");
// #CP_APLOAD @TEXT("", key="name");
// (130, 25) @TEXT("CP_APLOAD", size=1.05);
// (130, 23) @TEXT("0.05011 fF / 5%", size=1.05);
// %j8 = (113, 30);
// &AP @WIRE {#MNDAP:1 (100, 30) %j8 (128, 30) #CP_APLOAD:1};
// &AP @WIRE {#C_APLOAD:2 %j8};
// (113, 32) @TEXT("AP", size=1.05);
// #MNCANCEL @PLACE(109, -14) => @ORIENT("R0");
// #MNCANCEL @SET-SYMBOL $NMOS;
// #MNCANCEL @TEXT("ULVT 0.12u", key="model", size=1.05, dx=1.5, dy=-1);
// #MNCANCEL @TEXT("MNCANCEL", key="name", size=1.1, dx=1.5, dy=1);
// &NOFF @WIRE {#MNCANCEL:1 (115, -12) (115, -16) #MNCANCEL:3};
// (117, -14) @TEXT("NOFF", size=1.05);
// (96, 39) @TEXT("AP keeper + physical MOM load", size=1.05);
// (96, -25) @TEXT("ENB feedthrough cancellation", size=1.05);
// &ENB @WIRE {#MPA0:2 (3, 32)};
// (2.7, 32) @TEXT("ENB", size=1.05, halign="end", valign="middle");
// %t10 = $SUPPLY @ATTACH &DVDD => @PLACE(8, 36);
// &DVDD @WIRE {#MPA0:3 %t10:p};
// &HIB @WIRE {#MPA1:2 (3, 24)};
// (2.7, 24) @TEXT("HIB", size=1.05, halign="end", valign="middle");
// &ENB @WIRE {#MNA0:2 (-5, 8)};
// (-5.3, 8) @TEXT("ENB", size=1.05, halign="end", valign="middle");
// %t13 = $GROUND @ATTACH &VREFN => @PLACE(0, 4);
// &VREFN @WIRE {#MNA0:3 %t13:p};
// &HIB @WIRE {#MNA1:2 (11, 8)};
// (10.7, 8) @TEXT("HIB", size=1.05, halign="end", valign="middle");
// %t15 = $GROUND @ATTACH &VREFN => @PLACE(16, 4);
// &VREFN @WIRE {#MNA1:3 %t15:p};
// &EN @WIRE {#MPB0:2 (-5, -8)};
// (-5.3, -8) @TEXT("EN", size=1.05, halign="end", valign="middle");
// %t17 = $SUPPLY @ATTACH &DVDD => @PLACE(0, -4);
// &DVDD @WIRE {#MPB0:3 %t17:p};
// &HIB @WIRE {#MPB1:2 (11, -8)};
// (10.7, -8) @TEXT("HIB", size=1.05, halign="end", valign="middle");
// %t19 = $SUPPLY @ATTACH &DVDD => @PLACE(16, -4);
// &DVDD @WIRE {#MPB1:3 %t19:p};
// &EN @WIRE {#MNB0:2 (3, -24)};
// (2.7, -24) @TEXT("EN", size=1.05, halign="end", valign="middle");
// &HIB @WIRE {#MNB1:2 (3, -32)};
// (2.7, -32) @TEXT("HIB", size=1.05, halign="end", valign="middle");
// %t22 = $GROUND @ATTACH &VREFN => @PLACE(8, -36);
// &VREFN @WIRE {#MNB1:3 %t22:p};
// %t23 = $SUPPLY @ATTACH &VREFP => @PLACE(76, 22);
// &VREFP @WIRE {#MPOUT:3 %t23:p};
// %t24 = $GROUND @ATTACH &VREFN => @PLACE(76, -22);
// &VREFN @WIRE {#MNOUT:3 %t24:p};
// %t25 = $GROUND @ATTACH &VREFN => @PLACE(43, 5);
// &VREFN @WIRE {#MGPN:3 %t25:p};
// %t26 = $SUPPLY @ATTACH &VREFP => @PLACE(43, 27);
// &VREFP @WIRE {#MGPP:3 %t26:p};
// %t27 = $GROUND @ATTACH &VREFN => @PLACE(43, -27);
// &VREFN @WIRE {#MGNN:3 %t27:p};
// %t28 = $SUPPLY @ATTACH &VREFP => @PLACE(43, -5);
// &VREFP @WIRE {#MGNP:3 %t28:p};
// &ENB @WIRE {#MNDAP:2 (95, 24)};
// (94.7, 24) @TEXT("ENB", size=1.05, halign="end", valign="middle");
// %t30 = $GROUND @ATTACH &VREFN => @PLACE(100, 20);
// &VREFN @WIRE {#MNDAP:3 %t30:p};
// %t31 = $GROUND @ATTACH &VSS => @PLACE(113, 20);
// &VSS @WIRE {#C_APLOAD:1 %t31:p};
// %t32 = $GROUND @ATTACH &VSS => @PLACE(128, 20);
// &VSS @WIRE {#CP_APLOAD:2 %t32:p};
// &ENB @WIRE {#MNCANCEL:2 (104, -14)};
// (103.7, -14) @TEXT("ENB", size=1.05, halign="end", valign="middle");
// $JUNCTION @ATTACH %j1;
// $JUNCTION @ATTACH %j2;
// $JUNCTION @ATTACH %j3;
// $JUNCTION @ATTACH %j4;
// $JUNCTION @ATTACH %j5;
// $JUNCTION @ATTACH %j6;
// $JUNCTION @ATTACH %j7;
// $JUNCTION @ATTACH %j8;
// (-7, 51) @TEXT("V29 diagnostic only / NOT qualified | mq_cdac_drv1 | isolated DVDD logic / VREFP output", size=1.4, bold=true, textcolor="#17365d");
// (-7, 48.6) @TEXT("Drawing only | N bulk = VSS; L = 30 nm. P bulk DVDD: MPA0, MPA1, MPB0, MPB1; VREFP: MGPP, MGNP, MPOUT", size=1.05, textcolor="#52606d");
// }
ends mq_cdac_drv1

subckt mq_cdac_drv0 (HIB EN ENB BP VREFP VREFN VSS DVDD)
// DVDD prelogic: PCOND = NOR(ENB,HIB); NOFF = NAND(EN,HIB).
// Reference-powered final inverters restore GP and GN to VREFP/VREFN.
// Actual current overlap, settling and device stress require measurement.
MPA0 (AP ENB DVDD DVDD) pch_ulvt_mac w=2.4e-07 l=3e-08 nf=1
MPA1 (PCOND HIB AP DVDD) pch_ulvt_mac w=2.4e-07 l=3e-08 nf=1
MNA0 (PCOND ENB VREFN VSS) nch_ulvt_mac w=1.2e-07 l=3e-08 nf=1
MNA1 (PCOND HIB VREFN VSS) nch_ulvt_mac w=1.2e-07 l=3e-08 nf=1
MPB0 (NOFF EN DVDD DVDD) pch_ulvt_mac w=1.2e-07 l=3e-08 nf=1
MPB1 (NOFF HIB DVDD DVDD) pch_ulvt_mac w=1.2e-07 l=3e-08 nf=1
MNB0 (NOFF EN BN VSS) nch_ulvt_mac w=1.2e-07 l=3e-08 nf=1
MNB1 (BN HIB VREFN VSS) nch_ulvt_mac w=3.25e-07 l=3e-08 nf=1
MGPN (GP PCOND VREFN VSS) nch_mac w=2.4e-07 l=3e-08 nf=1
MGPP (GP PCOND VREFP VREFP) pch_mac w=3.6e-07 l=3e-08 nf=1
MGNN (GN NOFF VREFN VSS) nch_mac w=2.4e-07 l=3e-08 nf=1
MGNP (GN NOFF VREFP VREFP) pch_mac w=1.2e-07 l=3e-08 nf=1
MNOUT (BP GN VREFN VSS) nch_mac w=1.6e-07 l=3e-08 nf=1
MPOUT (BP GP VREFP VREFP) pch_mac w=3.25e-07 l=3e-08 nf=1
// Actively discharge AP while ENB turns the upper PMOS off.
MNDAP (AP ENB VREFN VSS) nch_ulvt_mac w=1.2e-07 l=3e-08 nf=1
// 1 existing physical MOM units, with 5% bottom Cp, slow AP feedthrough.
C_APLOAD (VSS AP) cfmom_2t w=5e-08 s=2.4e-07 nr=6 lr=1.69e-06 stm=2 spm=4 multi=1
CP_APLOAD (AP VSS) capacitor c=5.01145e-17
MNCANCEL (NOFF ENB NOFF VSS) nch_ulvt_mac w=1.2e-07 l=3e-08 nf=1
// @RNL {
// {&HIB &EN &ENB &BP &VREFP &VREFN &VSS &DVDD} @REMOVE-FROM $PORT_FILL_SET;
// &VSS @ADD-TO $GROUND_NET_SET;
// &VREFN @ADD-TO $GROUND_NET_SET;
// #MPA0 @PLACE(8, 32) => @ORIENT("R0");
// #MPA0 @SET-SYMBOL $PMOS;
// #MPA0 @TEXT("ULVT 0.24u", key="model", size=1.05, dx=1.5, dy=-1);
// #MPA0 @TEXT("MPA0", key="name", size=1.1, dx=1.5, dy=1);
// #MPA1 @PLACE(8, 24) => @ORIENT("R0");
// #MPA1 @SET-SYMBOL $PMOS;
// #MPA1 @TEXT("ULVT 0.24u", key="model", size=1.05, dx=1.5, dy=-1);
// #MPA1 @TEXT("MPA1", key="name", size=1.1, dx=1.5, dy=1);
// #MNA0 @PLACE(0, 8) => @ORIENT("R0");
// #MNA0 @SET-SYMBOL $NMOS;
// #MNA0 @TEXT("ULVT 0.12u", key="model", size=1.05, dx=1.5, dy=-1);
// #MNA0 @TEXT("MNA0", key="name", size=1.1, dx=1.5, dy=1);
// #MNA1 @PLACE(16, 8) => @ORIENT("R0");
// #MNA1 @SET-SYMBOL $NMOS;
// #MNA1 @TEXT("ULVT 0.12u", key="model", size=1.05, dx=1.5, dy=-1);
// #MNA1 @TEXT("MNA1", key="name", size=1.1, dx=1.5, dy=1);
// #MPB0 @PLACE(0, -8) => @ORIENT("R0");
// #MPB0 @SET-SYMBOL $PMOS;
// #MPB0 @TEXT("ULVT 0.12u", key="model", size=1.05, dx=1.5, dy=-1);
// #MPB0 @TEXT("MPB0", key="name", size=1.1, dx=1.5, dy=1);
// #MPB1 @PLACE(16, -8) => @ORIENT("R0");
// #MPB1 @SET-SYMBOL $PMOS;
// #MPB1 @TEXT("ULVT 0.12u", key="model", size=1.05, dx=1.5, dy=-1);
// #MPB1 @TEXT("MPB1", key="name", size=1.1, dx=1.5, dy=1);
// #MNB0 @PLACE(8, -24) => @ORIENT("R0");
// #MNB0 @SET-SYMBOL $NMOS;
// #MNB0 @TEXT("ULVT 0.12u", key="model", size=1.05, dx=1.5, dy=-1);
// #MNB0 @TEXT("MNB0", key="name", size=1.1, dx=1.5, dy=1);
// #MNB1 @PLACE(8, -32) => @ORIENT("R0");
// #MNB1 @SET-SYMBOL $NMOS;
// #MNB1 @TEXT("ULVT 0.325u", key="model", size=1.05, dx=1.5, dy=-1);
// #MNB1 @TEXT("MNB1", key="name", size=1.1, dx=1.5, dy=1);
// #MPOUT @PLACE(76, 18) => @ORIENT("R0");
// #MPOUT @SET-SYMBOL $PMOS;
// #MPOUT @TEXT("SVT 0.325u", key="model", size=1.05, dx=1.5, dy=-1);
// #MPOUT @TEXT("MPOUT", key="name", size=1.1, dx=1.5, dy=1);
// #MNOUT @PLACE(76, -18) => @ORIENT("R0");
// #MNOUT @SET-SYMBOL $NMOS;
// #MNOUT @TEXT("SVT 0.16u", key="model", size=1.05, dx=1.5, dy=-1);
// #MNOUT @TEXT("MNOUT", key="name", size=1.1, dx=1.5, dy=1);
// &AP @WIRE {#MPA0:1 #MPA1:3};
// (10, 28) @TEXT("AP", size=1.05);
// %j1 = (8, 16);
// &PCOND @WIRE {#MNA0:1 (0, 16) %j1 (16, 16) #MNA1:1};
// &PCOND @WIRE {#MPA1:1 %j1};
// #MGPN @PLACE(43, 9) => @ORIENT("R0");
// #MGPN @SET-SYMBOL $NMOS;
// #MGPN @TEXT("SVT 0.24u", key="model", size=1.05, dx=1.5, dy=-1);
// #MGPN @TEXT("MGPN", key="name", size=1.1, dx=1.5, dy=1);
// #MGPP @PLACE(43, 23) => @ORIENT("R0");
// #MGPP @SET-SYMBOL $PMOS;
// #MGPP @TEXT("SVT 0.36u", key="model", size=1.05, dx=1.5, dy=-1);
// #MGPP @TEXT("MGPP", key="name", size=1.1, dx=1.5, dy=1);
// %j2 = (43, 16);
// %j3 = (38, 16);
// &GP @WIRE {#MGPN:1 %j2 #MGPP:1};
// &PCOND @WIRE {#MGPN:2 (38, 9) %j3 (38, 23) #MGPP:2};
// &PCOND @WIRE {%j1 %j3};
// &GP @WIRE {%j2 (65, 16) (65, 18) #MPOUT:2};
// %j4 = (8, -16);
// &NOFF @WIRE {#MPB0:1 (0, -16) %j4 (16, -16) #MPB1:1};
// &NOFF @WIRE {#MNB0:1 %j4};
// &BN @WIRE {#MNB0:3 #MNB1:1};
// (18, -14) @TEXT("NOFF", size=1.05);
// #MGNN @PLACE(43, -23) => @ORIENT("R0");
// #MGNN @SET-SYMBOL $NMOS;
// #MGNN @TEXT("SVT 0.24u", key="model", size=1.05, dx=1.5, dy=-1);
// #MGNN @TEXT("MGNN", key="name", size=1.1, dx=1.5, dy=1);
// #MGNP @PLACE(43, -9) => @ORIENT("R0");
// #MGNP @SET-SYMBOL $PMOS;
// #MGNP @TEXT("SVT 0.12u", key="model", size=1.05, dx=1.5, dy=-1);
// #MGNP @TEXT("MGNP", key="name", size=1.1, dx=1.5, dy=1);
// %j5 = (43, -16);
// %j6 = (38, -16);
// &GN @WIRE {#MGNN:1 %j5 #MGNP:1};
// &NOFF @WIRE {#MGNN:2 (38, -23) %j6 (38, -9) #MGNP:2};
// &NOFF @WIRE {%j4 %j6};
// &GN @WIRE {%j5 (65, -16) (65, -18) #MNOUT:2};
// %j7 = (76, 0);
// &BP @WIRE {#MPOUT:1 %j7 #MNOUT:1};
// &BP @WIRE {%j7 (85, 0)};
// (85, 1) @TEXT("BP", size=1.05);
// (-5, 42) @TEXT("NOR: PCOND = ~(ENB | HIB)", size=1.05);
// (-5, -42) @TEXT("NAND: NOFF = ~(EN & HIB)", size=1.05);
// (31, 39) @TEXT("Reference gate drivers", size=1.05);
// (67, 39) @TEXT("Output rail switch", size=1.05);
// #MNDAP @PLACE(100, 24) => @ORIENT("R0");
// #MNDAP @SET-SYMBOL $NMOS;
// #MNDAP @TEXT("ULVT 0.12u", key="model", size=1.05, dx=1.5, dy=-1);
// #MNDAP @TEXT("MNDAP", key="name", size=1.1, dx=1.5, dy=1);
// #C_APLOAD @PLACE(113, 24) => @ORIENT("MX");
// #C_APLOAD @TEXT("", key="value");
// #C_APLOAD @TEXT("", key="name");
// (115, 25) @TEXT("C_APLOAD", size=1.05);
// (115, 23) @TEXT("1 Cu", size=1.05);
// #CP_APLOAD @PLACE(128, 24) => @ORIENT("R0");
// #CP_APLOAD @TEXT("", key="value");
// #CP_APLOAD @TEXT("", key="name");
// (130, 25) @TEXT("CP_APLOAD", size=1.05);
// (130, 23) @TEXT("0.05011 fF / 5%", size=1.05);
// %j8 = (113, 30);
// &AP @WIRE {#MNDAP:1 (100, 30) %j8 (128, 30) #CP_APLOAD:1};
// &AP @WIRE {#C_APLOAD:2 %j8};
// (113, 32) @TEXT("AP", size=1.05);
// #MNCANCEL @PLACE(109, -14) => @ORIENT("R0");
// #MNCANCEL @SET-SYMBOL $NMOS;
// #MNCANCEL @TEXT("ULVT 0.12u", key="model", size=1.05, dx=1.5, dy=-1);
// #MNCANCEL @TEXT("MNCANCEL", key="name", size=1.1, dx=1.5, dy=1);
// &NOFF @WIRE {#MNCANCEL:1 (115, -12) (115, -16) #MNCANCEL:3};
// (117, -14) @TEXT("NOFF", size=1.05);
// (96, 39) @TEXT("AP keeper + physical MOM load", size=1.05);
// (96, -25) @TEXT("ENB feedthrough cancellation", size=1.05);
// &ENB @WIRE {#MPA0:2 (3, 32)};
// (2.7, 32) @TEXT("ENB", size=1.05, halign="end", valign="middle");
// %t10 = $SUPPLY @ATTACH &DVDD => @PLACE(8, 36);
// &DVDD @WIRE {#MPA0:3 %t10:p};
// &HIB @WIRE {#MPA1:2 (3, 24)};
// (2.7, 24) @TEXT("HIB", size=1.05, halign="end", valign="middle");
// &ENB @WIRE {#MNA0:2 (-5, 8)};
// (-5.3, 8) @TEXT("ENB", size=1.05, halign="end", valign="middle");
// %t13 = $GROUND @ATTACH &VREFN => @PLACE(0, 4);
// &VREFN @WIRE {#MNA0:3 %t13:p};
// &HIB @WIRE {#MNA1:2 (11, 8)};
// (10.7, 8) @TEXT("HIB", size=1.05, halign="end", valign="middle");
// %t15 = $GROUND @ATTACH &VREFN => @PLACE(16, 4);
// &VREFN @WIRE {#MNA1:3 %t15:p};
// &EN @WIRE {#MPB0:2 (-5, -8)};
// (-5.3, -8) @TEXT("EN", size=1.05, halign="end", valign="middle");
// %t17 = $SUPPLY @ATTACH &DVDD => @PLACE(0, -4);
// &DVDD @WIRE {#MPB0:3 %t17:p};
// &HIB @WIRE {#MPB1:2 (11, -8)};
// (10.7, -8) @TEXT("HIB", size=1.05, halign="end", valign="middle");
// %t19 = $SUPPLY @ATTACH &DVDD => @PLACE(16, -4);
// &DVDD @WIRE {#MPB1:3 %t19:p};
// &EN @WIRE {#MNB0:2 (3, -24)};
// (2.7, -24) @TEXT("EN", size=1.05, halign="end", valign="middle");
// &HIB @WIRE {#MNB1:2 (3, -32)};
// (2.7, -32) @TEXT("HIB", size=1.05, halign="end", valign="middle");
// %t22 = $GROUND @ATTACH &VREFN => @PLACE(8, -36);
// &VREFN @WIRE {#MNB1:3 %t22:p};
// %t23 = $SUPPLY @ATTACH &VREFP => @PLACE(76, 22);
// &VREFP @WIRE {#MPOUT:3 %t23:p};
// %t24 = $GROUND @ATTACH &VREFN => @PLACE(76, -22);
// &VREFN @WIRE {#MNOUT:3 %t24:p};
// %t25 = $GROUND @ATTACH &VREFN => @PLACE(43, 5);
// &VREFN @WIRE {#MGPN:3 %t25:p};
// %t26 = $SUPPLY @ATTACH &VREFP => @PLACE(43, 27);
// &VREFP @WIRE {#MGPP:3 %t26:p};
// %t27 = $GROUND @ATTACH &VREFN => @PLACE(43, -27);
// &VREFN @WIRE {#MGNN:3 %t27:p};
// %t28 = $SUPPLY @ATTACH &VREFP => @PLACE(43, -5);
// &VREFP @WIRE {#MGNP:3 %t28:p};
// &ENB @WIRE {#MNDAP:2 (95, 24)};
// (94.7, 24) @TEXT("ENB", size=1.05, halign="end", valign="middle");
// %t30 = $GROUND @ATTACH &VREFN => @PLACE(100, 20);
// &VREFN @WIRE {#MNDAP:3 %t30:p};
// %t31 = $GROUND @ATTACH &VSS => @PLACE(113, 20);
// &VSS @WIRE {#C_APLOAD:1 %t31:p};
// %t32 = $GROUND @ATTACH &VSS => @PLACE(128, 20);
// &VSS @WIRE {#CP_APLOAD:2 %t32:p};
// &ENB @WIRE {#MNCANCEL:2 (104, -14)};
// (103.7, -14) @TEXT("ENB", size=1.05, halign="end", valign="middle");
// $JUNCTION @ATTACH %j1;
// $JUNCTION @ATTACH %j2;
// $JUNCTION @ATTACH %j3;
// $JUNCTION @ATTACH %j4;
// $JUNCTION @ATTACH %j5;
// $JUNCTION @ATTACH %j6;
// $JUNCTION @ATTACH %j7;
// $JUNCTION @ATTACH %j8;
// (-7, 51) @TEXT("V29 diagnostic only / NOT qualified | mq_cdac_drv0 | isolated DVDD logic / VREFP output", size=1.4, bold=true, textcolor="#17365d");
// (-7, 48.6) @TEXT("Drawing only | N bulk = VSS; L = 30 nm. P bulk DVDD: MPA0, MPA1, MPB0, MPB1; VREFP: MGPP, MGNP, MPOUT", size=1.05, textcolor="#52606d");
// }
ends mq_cdac_drv0

subckt mq_cdac_assist_pulse (PHI_S PHI_SB AGATE DVDD VREFN VSS VREFP)
// MOS gate loads delay a PHI_S inverter; two inverters restore the delayed control.
// The pass TG uses a physical PHI_S inverter powered by VREFP; MPUP holds AGATE at VREFP. Phase delay, reference current and overlap must be measured.
// The pulse duration and overlap require PVT, startup and full-circuit verification.
M0N (D0 PHI_S VREFN VSS) nch_ulvt_mac w=4e-07 l=3e-08 nf=1
M0P (D0 PHI_S DVDD DVDD) pch_mac w=8e-07 l=3e-08 nf=1
MLOAD0 (VREFN D0 VREFN VSS) nch_ulvt_mac w=2.4e-05 l=3e-08 nf=12
MLOAD1 (VREFN D0 VREFN VSS) nch_ulvt_mac w=2.4e-05 l=3e-08 nf=12
MLOAD2 (VREFN D0 VREFN VSS) nch_ulvt_mac w=2.4e-05 l=3e-08 nf=12
MLOAD3 (VREFN D0 VREFN VSS) nch_ulvt_mac w=2.4e-05 l=3e-08 nf=12
M1N (D1 D0 VREFN VSS) nch_ulvt_mac w=2.4e-05 l=3e-08 nf=12
M1P (D1 D0 DVDD DVDD) pch_ulvt_mac w=1.6e-05 l=3e-08 nf=8
M2N (D2 D1 VREFN VSS) nch_ulvt_mac w=4e-06 l=3e-08 nf=2
M2P (D2 D1 DVDD DVDD) pch_mac w=8e-06 l=3e-08 nf=4
MNPASS (AGATE D2 PHI_SB_REF VSS) nch_ulvt_mac w=4e-06 l=3e-08 nf=2
MPPASS (AGATE D1 PHI_SB_REF DVDD) pch_mac w=8e-06 l=3e-08 nf=4
MPUP (AGATE D2 VREFP VREFP) pch_mac w=8e-06 l=3e-08 nf=4
MREFN (PHI_SB_REF PHI_S VREFN VSS) nch_ulvt_mac w=1.2e-05 l=3e-08 nf=6
MREFP (PHI_SB_REF PHI_S VREFP VREFP) pch_mac w=8e-06 l=3e-08 nf=4
// @RNL {
// {&PHI_S &PHI_SB &AGATE &DVDD &VREFN &VSS &VREFP} @REMOVE-FROM $PORT_FILL_SET;
// &VSS @ADD-TO $GROUND_NET_SET;
// &VREFN @ADD-TO $GROUND_NET_SET;
// #M0N @PLACE(8, 7) => @ORIENT("R0");
// #M0N @SET-SYMBOL $NMOS;
// #M0N @TEXT("ULVT 0.4u", key="model", size=1.05, dx=1.5, dy=-1);
// #M0N @TEXT("M0N", key="name", size=1.1, dx=1.5, dy=1);
// #M0P @PLACE(8, 21) => @ORIENT("R0");
// #M0P @SET-SYMBOL $PMOS;
// #M0P @TEXT("SVT 0.8u", key="model", size=1.05, dx=1.5, dy=-1);
// #M0P @TEXT("M0P", key="name", size=1.1, dx=1.5, dy=1);
// %j1 = (8, 14);
// %j2 = (3, 14);
// &D0 @WIRE {#M0N:1 %j1 #M0P:1};
// &PHI_S @WIRE {#M0N:2 (3, 7) %j2 (3, 21) #M0P:2};
// #M1N @PLACE(34, 7) => @ORIENT("R0");
// #M1N @SET-SYMBOL $NMOS;
// #M1N @TEXT("ULVT 24u", key="model", size=1.05, dx=1.5, dy=-1);
// #M1N @TEXT("M1N", key="name", size=1.1, dx=1.5, dy=1);
// #M1P @PLACE(34, 21) => @ORIENT("R0");
// #M1P @SET-SYMBOL $PMOS;
// #M1P @TEXT("ULVT 16u", key="model", size=1.05, dx=1.5, dy=-1);
// #M1P @TEXT("M1P", key="name", size=1.1, dx=1.5, dy=1);
// %j3 = (34, 14);
// %j4 = (29, 14);
// &D1 @WIRE {#M1N:1 %j3 #M1P:1};
// &D0 @WIRE {#M1N:2 (29, 7) %j4 (29, 21) #M1P:2};
// &D0 @WIRE {%j1 %j4};
// #M2N @PLACE(60, 7) => @ORIENT("R0");
// #M2N @SET-SYMBOL $NMOS;
// #M2N @TEXT("ULVT 4u", key="model", size=1.05, dx=1.5, dy=-1);
// #M2N @TEXT("M2N", key="name", size=1.1, dx=1.5, dy=1);
// #M2P @PLACE(60, 21) => @ORIENT("R0");
// #M2P @SET-SYMBOL $PMOS;
// #M2P @TEXT("SVT 8u", key="model", size=1.05, dx=1.5, dy=-1);
// #M2P @TEXT("M2P", key="name", size=1.1, dx=1.5, dy=1);
// %j5 = (60, 14);
// %j6 = (55, 14);
// &D2 @WIRE {#M2N:1 %j5 #M2P:1};
// &D1 @WIRE {#M2N:2 (55, 7) %j6 (55, 21) #M2P:2};
// &D1 @WIRE {%j3 %j6};
// #MLOAD0 @PLACE(0, -16) => @ORIENT("R0");
// #MLOAD0 @SET-SYMBOL $NMOS;
// #MLOAD0 @TEXT("ULVT 24u", key="model", size=1.05, dx=1.5, dy=-1);
// #MLOAD0 @TEXT("MLOAD0", key="name", size=1.1, dx=1.5, dy=1);
// %j7 = (7, -18);
// &VREFN @WIRE {#MLOAD0:1 (7, -14) %j7 #MLOAD0:3};
// &VREFN @WIRE {%j7 (7, -21)};
// $GROUND @ATTACH &VREFN => @PLACE(7, -21);
// #MLOAD1 @PLACE(16, -16) => @ORIENT("R0");
// #MLOAD1 @SET-SYMBOL $NMOS;
// #MLOAD1 @TEXT("ULVT 24u", key="model", size=1.05, dx=1.5, dy=-1);
// #MLOAD1 @TEXT("MLOAD1", key="name", size=1.1, dx=1.5, dy=1);
// %j8 = (23, -18);
// &VREFN @WIRE {#MLOAD1:1 (23, -14) %j8 #MLOAD1:3};
// &VREFN @WIRE {%j8 (23, -21)};
// $GROUND @ATTACH &VREFN => @PLACE(23, -21);
// #MLOAD2 @PLACE(32, -16) => @ORIENT("R0");
// #MLOAD2 @SET-SYMBOL $NMOS;
// #MLOAD2 @TEXT("ULVT 24u", key="model", size=1.05, dx=1.5, dy=-1);
// #MLOAD2 @TEXT("MLOAD2", key="name", size=1.1, dx=1.5, dy=1);
// %j9 = (39, -18);
// &VREFN @WIRE {#MLOAD2:1 (39, -14) %j9 #MLOAD2:3};
// &VREFN @WIRE {%j9 (39, -21)};
// $GROUND @ATTACH &VREFN => @PLACE(39, -21);
// #MLOAD3 @PLACE(48, -16) => @ORIENT("R0");
// #MLOAD3 @SET-SYMBOL $NMOS;
// #MLOAD3 @TEXT("ULVT 24u", key="model", size=1.05, dx=1.5, dy=-1);
// #MLOAD3 @TEXT("MLOAD3", key="name", size=1.1, dx=1.5, dy=1);
// %j10 = (55, -18);
// &VREFN @WIRE {#MLOAD3:1 (55, -14) %j10 #MLOAD3:3};
// &VREFN @WIRE {%j10 (55, -21)};
// $GROUND @ATTACH &VREFN => @PLACE(55, -21);
// (10, 15) @TEXT("D0", size=1.05);
// (36, 15) @TEXT("D1", size=1.05);
// (62, 15) @TEXT("D2", size=1.05);
// &PHI_S @WIRE {%j2 (-3, 14)};
// (-3, 15) @TEXT("PHI_S", size=1.05);
// (-5, -28) @TEXT("D0 delay load: four physical MOS gates", size=1.05);
// #MPPASS @PLACE(89, 12) => @ORIENT("MX");
// #MPPASS @SET-SYMBOL $PMOS;
// #MPPASS @TEXT("SVT 8u", key="model", size=1.05, dx=1.5, dy=-1);
// #MPPASS @TEXT("MPPASS", key="name", size=1.1, dx=1.5, dy=1);
// #MNPASS @PLACE(89, -2) => @ORIENT("R0");
// #MNPASS @SET-SYMBOL $NMOS;
// #MNPASS @TEXT("ULVT 4u", key="model", size=1.05, dx=1.5, dy=-1);
// #MNPASS @TEXT("MNPASS", key="name", size=1.1, dx=1.5, dy=1);
// #MPUP @PLACE(112, 21) => @ORIENT("R0");
// #MPUP @SET-SYMBOL $PMOS;
// #MPUP @TEXT("SVT 8u", key="model", size=1.05, dx=1.5, dy=-1);
// #MPUP @TEXT("MPUP", key="name", size=1.1, dx=1.5, dy=1);
// %j11 = (101, 7);
// &AGATE @WIRE {#MPPASS:1 (101, 14) %j11 (101, 0) #MNPASS:1};
// &AGATE @WIRE {%j11 (112, 7) #MPUP:1};
// (116, 7) @TEXT("AGATE", size=1.05);
// (79, 32) @TEXT("Delayed transmission gate + pull-up", size=1.05);
// #MREFN @PLACE(140, 7) => @ORIENT("R0");
// #MREFN @SET-SYMBOL $NMOS;
// #MREFN @TEXT("ULVT 12u", key="model", size=1.05, dx=1.5, dy=-1);
// #MREFN @TEXT("MREFN", key="name", size=1.1, dx=1.5, dy=1);
// #MREFP @PLACE(140, 21) => @ORIENT("R0");
// #MREFP @SET-SYMBOL $PMOS;
// #MREFP @TEXT("SVT 8u", key="model", size=1.05, dx=1.5, dy=-1);
// #MREFP @TEXT("MREFP", key="name", size=1.1, dx=1.5, dy=1);
// %j12 = (140, 14);
// %j13 = (135, 14);
// &PHI_SB_REF @WIRE {#MREFN:1 %j12 #MREFP:1};
// &PHI_S @WIRE {#MREFN:2 (135, 7) %j13 (135, 21) #MREFP:2};
// (142, 15) @TEXT("PHI_SB_REF", size=1.05);
// (126, -4) @TEXT("Local phase inverter", size=1.05);
// (126, -7) @TEXT("Supply: VREFP", size=1.05);
// %t14 = $GROUND @ATTACH &VREFN => @PLACE(8, 3);
// &VREFN @WIRE {#M0N:3 %t14:p};
// %t15 = $SUPPLY @ATTACH &DVDD => @PLACE(8, 25);
// &DVDD @WIRE {#M0P:3 %t15:p};
// %t16 = $GROUND @ATTACH &VREFN => @PLACE(34, 3);
// &VREFN @WIRE {#M1N:3 %t16:p};
// %t17 = $SUPPLY @ATTACH &DVDD => @PLACE(34, 25);
// &DVDD @WIRE {#M1P:3 %t17:p};
// %t18 = $GROUND @ATTACH &VREFN => @PLACE(60, 3);
// &VREFN @WIRE {#M2N:3 %t18:p};
// %t19 = $SUPPLY @ATTACH &DVDD => @PLACE(60, 25);
// &DVDD @WIRE {#M2P:3 %t19:p};
// &D0 @WIRE {#MLOAD0:2 (-5, -16)};
// (-5.3, -16) @TEXT("D0", size=1.05, halign="end", valign="middle");
// &D0 @WIRE {#MLOAD1:2 (11, -16)};
// (10.7, -16) @TEXT("D0", size=1.05, halign="end", valign="middle");
// &D0 @WIRE {#MLOAD2:2 (27, -16)};
// (26.7, -16) @TEXT("D0", size=1.05, halign="end", valign="middle");
// &D0 @WIRE {#MLOAD3:2 (43, -16)};
// (42.7, -16) @TEXT("D0", size=1.05, halign="end", valign="middle");
// &D1 @WIRE {#MPPASS:2 (84, 12)};
// (83.7, 12) @TEXT("D1", size=1.05, halign="end", valign="middle");
// &PHI_SB_REF @WIRE {#MPPASS:3 (89, 8)};
// (89, 7.4) @TEXT("PHI_SB_REF", size=1.05, halign="middle", valign="top");
// &D2 @WIRE {#MNPASS:2 (84, -2)};
// (83.7, -2) @TEXT("D2", size=1.05, halign="end", valign="middle");
// &PHI_SB_REF @WIRE {#MNPASS:3 (89, -6)};
// (89, -6.6) @TEXT("PHI_SB_REF", size=1.05, halign="middle", valign="top");
// &D2 @WIRE {#MPUP:2 (107, 21)};
// (106.7, 21) @TEXT("D2", size=1.05, halign="end", valign="middle");
// %t29 = $SUPPLY @ATTACH &VREFP => @PLACE(112, 25);
// &VREFP @WIRE {#MPUP:3 %t29:p};
// %t30 = $GROUND @ATTACH &VREFN => @PLACE(140, 3);
// &VREFN @WIRE {#MREFN:3 %t30:p};
// %t31 = $SUPPLY @ATTACH &VREFP => @PLACE(140, 25);
// &VREFP @WIRE {#MREFP:3 %t31:p};
// $JUNCTION @ATTACH %j1;
// $JUNCTION @ATTACH %j2;
// $JUNCTION @ATTACH %j3;
// $JUNCTION @ATTACH %j4;
// $JUNCTION @ATTACH %j6;
// $JUNCTION @ATTACH %j7;
// $JUNCTION @ATTACH %j8;
// $JUNCTION @ATTACH %j9;
// $JUNCTION @ATTACH %j10;
// $JUNCTION @ATTACH %j11;
// (-7, 44) @TEXT("V29 diagnostic only / NOT qualified | sampling-entry assist | three delay stages", size=1.4, bold=true, textcolor="#17365d");
// (-7, 41.6) @TEXT("Drawing only | N bulk = VSS; L = 30 nm. P bulk DVDD: M0P, M1P, M2P, MPPASS; VREFP: MPUP, MREFP", size=1.05, textcolor="#52606d");
// }
ends mq_cdac_assist_pulse

subckt adc_cdac (VIN VG TOP VCM VREFP VREFN PHI_S PHI_SB CONV DH12 DH11 DH10 DH9 DH8 DH7 DH6 DH5 DH4 DH3 DH2 DH1 DH0 RL12 RL11 RL10 RL9 RL8 RL7 RL6 RL5 RL4 RL3 RL2 RL1 RL0 DVDD VSS)
XSW (VIN VG VREFP VREFN PHI_S PHI_SB CONV DH12 DH11 DH10 DH9 DH8 DH7 DH6 DH5 DH4 DH3 DH2 DH1 DH0 RL12 RL11 RL10 RL9 RL8 RL7 RL6 RL5 RL4 RL3 RL2 RL1 RL0 DVDD VSS BPH12 BPL12 BPH11 BPL11 BPH10 BPL10 BPH9 BPL9 BPH8 BPL8 BPH7 BPL7 BPH6 BPL6 BPH5 BPL5 BPH4 BPL4 BPH3 BPL3 BPH2 BPL2 BPH1 BPL1 BPH0 BPL0 MIDH7 MIDL7 MIDH2 MIDL2 MIDH0 MIDL0) mq_cdac_switch_array
XCAP (TOP BPH12 BPL12 BPH11 BPL11 BPH10 BPL10 BPH9 BPL9 BPH8 BPL8 BPH7 BPL7 BPH6 BPL6 BPH5 BPL5 BPH4 BPL4 BPH3 BPL3 BPH2 BPL2 BPH1 BPL1 BPH0 BPL0 MIDH7 MIDL7 MIDH2 MIDL2 MIDH0 MIDL0 VSS) mq_cdac_cap_array
MTN (TOP GBST VCM VSS) nch_lvt_mac w=1.4e-05 l=4e-08 nf=7
XBOOST (PHI_SB GBST DVDD VCM VSS) mq_cdac_reset_booster
// @RNL {
// {&VIN &VG &TOP &VCM &VREFP &VREFN &PHI_S &PHI_SB &CONV &DH12 &DH11 &DH10 &DH9 &DH8 &DH7 &DH6 &DH5 &DH4 &DH3 &DH2 &DH1 &DH0 &RL12 &RL11 &RL10 &RL9 &RL8 &RL7 &RL6 &RL5 &RL4 &RL3 &RL2 &RL1 &RL0 &DVDD &VSS} @REMOVE-FROM $PORT_FILL_SET;
// &VSS @ADD-TO $GROUND_NET_SET;
// &VREFN @ADD-TO $GROUND_NET_SET;
// #XSW @PLACE(0, 0) => @ORIENT("R0");
// #XCAP @PLACE(112, 0) => @ORIENT("R0");
// &BPH12 @WIRE {#XSW:36 #XCAP:2};
// (46, 49) @TEXT("BPH12", size=1.8);
// &BPL12 @WIRE {#XSW:37 #XCAP:3};
// (46, 46) @TEXT("BPL12", size=1.8);
// &BPH11 @WIRE {#XSW:38 #XCAP:4};
// (46, 43) @TEXT("BPH11", size=1.8);
// &BPL11 @WIRE {#XSW:39 #XCAP:5};
// (46, 40) @TEXT("BPL11", size=1.8);
// &BPH10 @WIRE {#XSW:40 #XCAP:6};
// (46, 37) @TEXT("BPH10", size=1.8);
// &BPL10 @WIRE {#XSW:41 #XCAP:7};
// (46, 34) @TEXT("BPL10", size=1.8);
// &BPH9 @WIRE {#XSW:42 #XCAP:8};
// (46, 31) @TEXT("BPH9", size=1.8);
// &BPL9 @WIRE {#XSW:43 #XCAP:9};
// (46, 28) @TEXT("BPL9", size=1.8);
// &BPH8 @WIRE {#XSW:44 #XCAP:10};
// (46, 25) @TEXT("BPH8", size=1.8);
// &BPL8 @WIRE {#XSW:45 #XCAP:11};
// (46, 22) @TEXT("BPL8", size=1.8);
// &BPH7 @WIRE {#XSW:46 #XCAP:12};
// (46, 19) @TEXT("BPH7", size=1.8);
// &BPL7 @WIRE {#XSW:47 #XCAP:13};
// (46, 16) @TEXT("BPL7", size=1.8);
// &BPH6 @WIRE {#XSW:48 #XCAP:14};
// (46, 13) @TEXT("BPH6", size=1.8);
// &BPL6 @WIRE {#XSW:49 #XCAP:15};
// (46, 10) @TEXT("BPL6", size=1.8);
// &BPH5 @WIRE {#XSW:50 #XCAP:16};
// (46, 7) @TEXT("BPH5", size=1.8);
// &BPL5 @WIRE {#XSW:51 #XCAP:17};
// (46, 4) @TEXT("BPL5", size=1.8);
// &BPH4 @WIRE {#XSW:52 #XCAP:18};
// (46, 1) @TEXT("BPH4", size=1.8);
// &BPL4 @WIRE {#XSW:53 #XCAP:19};
// (46, -2) @TEXT("BPL4", size=1.8);
// &BPH3 @WIRE {#XSW:54 #XCAP:20};
// (46, -5) @TEXT("BPH3", size=1.8);
// &BPL3 @WIRE {#XSW:55 #XCAP:21};
// (46, -8) @TEXT("BPL3", size=1.8);
// &BPH2 @WIRE {#XSW:56 #XCAP:22};
// (46, -11) @TEXT("BPH2", size=1.8);
// &BPL2 @WIRE {#XSW:57 #XCAP:23};
// (46, -14) @TEXT("BPL2", size=1.8);
// &BPH1 @WIRE {#XSW:58 #XCAP:24};
// (46, -17) @TEXT("BPH1", size=1.8);
// &BPL1 @WIRE {#XSW:59 #XCAP:25};
// (46, -20) @TEXT("BPL1", size=1.8);
// &BPH0 @WIRE {#XSW:60 #XCAP:26};
// (46, -23) @TEXT("BPH0", size=1.8);
// &BPL0 @WIRE {#XSW:61 #XCAP:27};
// (46, -26) @TEXT("BPL0", size=1.8);
// &MIDH7 @WIRE {#XSW:62 #XCAP:28};
// (46, -29) @TEXT("MIDH7", size=1.8);
// &MIDL7 @WIRE {#XSW:63 #XCAP:29};
// (46, -32) @TEXT("MIDL7", size=1.8);
// &MIDH2 @WIRE {#XSW:64 #XCAP:30};
// (46, -35) @TEXT("MIDH2", size=1.8);
// &MIDL2 @WIRE {#XSW:65 #XCAP:31};
// (46, -38) @TEXT("MIDL2", size=1.8);
// &MIDH0 @WIRE {#XSW:66 #XCAP:32};
// (46, -41) @TEXT("MIDH0", size=1.8);
// &MIDL0 @WIRE {#XSW:67 #XCAP:33};
// (46, -44) @TEXT("MIDL0", size=1.8);
// &VIN @WIRE {#XSW:1 (-30, 48)};
// (-30.3, 48) @TEXT("VIN", size=1.8, halign="end", valign="middle");
// &VG @WIRE {#XSW:2 (-30, 45)};
// (-30.3, 45) @TEXT("VG", size=1.8, halign="end", valign="middle");
// &PHI_S @WIRE {#XSW:5 (-30, 42)};
// (-30.3, 42) @TEXT("PHI_S", size=1.8, halign="end", valign="middle");
// &PHI_SB @WIRE {#XSW:6 (-30, 39)};
// (-30.3, 39) @TEXT("PHI_SB", size=1.8, halign="end", valign="middle");
// &CONV @WIRE {#XSW:7 (-30, 36)};
// (-30.3, 36) @TEXT("CONV", size=1.8, halign="end", valign="middle");
// &DH12 @WIRE {#XSW:8 (-30, 33)};
// (-30.3, 33) @TEXT("DH12", size=1.8, halign="end", valign="middle");
// &DH11 @WIRE {#XSW:9 (-30, 30)};
// (-30.3, 30) @TEXT("DH11", size=1.8, halign="end", valign="middle");
// &DH10 @WIRE {#XSW:10 (-30, 27)};
// (-30.3, 27) @TEXT("DH10", size=1.8, halign="end", valign="middle");
// &DH9 @WIRE {#XSW:11 (-30, 24)};
// (-30.3, 24) @TEXT("DH9", size=1.8, halign="end", valign="middle");
// &DH8 @WIRE {#XSW:12 (-30, 21)};
// (-30.3, 21) @TEXT("DH8", size=1.8, halign="end", valign="middle");
// &DH7 @WIRE {#XSW:13 (-30, 18)};
// (-30.3, 18) @TEXT("DH7", size=1.8, halign="end", valign="middle");
// &DH6 @WIRE {#XSW:14 (-30, 15)};
// (-30.3, 15) @TEXT("DH6", size=1.8, halign="end", valign="middle");
// &DH5 @WIRE {#XSW:15 (-30, 12)};
// (-30.3, 12) @TEXT("DH5", size=1.8, halign="end", valign="middle");
// &DH4 @WIRE {#XSW:16 (-30, 9)};
// (-30.3, 9) @TEXT("DH4", size=1.8, halign="end", valign="middle");
// &DH3 @WIRE {#XSW:17 (-30, 6)};
// (-30.3, 6) @TEXT("DH3", size=1.8, halign="end", valign="middle");
// &DH2 @WIRE {#XSW:18 (-30, 3)};
// (-30.3, 3) @TEXT("DH2", size=1.8, halign="end", valign="middle");
// &DH1 @WIRE {#XSW:19 (-30, 0)};
// (-30.3, 0) @TEXT("DH1", size=1.8, halign="end", valign="middle");
// &DH0 @WIRE {#XSW:20 (-30, -3)};
// (-30.3, -3) @TEXT("DH0", size=1.8, halign="end", valign="middle");
// &RL12 @WIRE {#XSW:21 (-30, -6)};
// (-30.3, -6) @TEXT("RL12", size=1.8, halign="end", valign="middle");
// &RL11 @WIRE {#XSW:22 (-30, -9)};
// (-30.3, -9) @TEXT("RL11", size=1.8, halign="end", valign="middle");
// &RL10 @WIRE {#XSW:23 (-30, -12)};
// (-30.3, -12) @TEXT("RL10", size=1.8, halign="end", valign="middle");
// &RL9 @WIRE {#XSW:24 (-30, -15)};
// (-30.3, -15) @TEXT("RL9", size=1.8, halign="end", valign="middle");
// &RL8 @WIRE {#XSW:25 (-30, -18)};
// (-30.3, -18) @TEXT("RL8", size=1.8, halign="end", valign="middle");
// &RL7 @WIRE {#XSW:26 (-30, -21)};
// (-30.3, -21) @TEXT("RL7", size=1.8, halign="end", valign="middle");
// &RL6 @WIRE {#XSW:27 (-30, -24)};
// (-30.3, -24) @TEXT("RL6", size=1.8, halign="end", valign="middle");
// &RL5 @WIRE {#XSW:28 (-30, -27)};
// (-30.3, -27) @TEXT("RL5", size=1.8, halign="end", valign="middle");
// &RL4 @WIRE {#XSW:29 (-30, -30)};
// (-30.3, -30) @TEXT("RL4", size=1.8, halign="end", valign="middle");
// &RL3 @WIRE {#XSW:30 (-30, -33)};
// (-30.3, -33) @TEXT("RL3", size=1.8, halign="end", valign="middle");
// &RL2 @WIRE {#XSW:31 (-30, -36)};
// (-30.3, -36) @TEXT("RL2", size=1.8, halign="end", valign="middle");
// &RL1 @WIRE {#XSW:32 (-30, -39)};
// (-30.3, -39) @TEXT("RL1", size=1.8, halign="end", valign="middle");
// &RL0 @WIRE {#XSW:33 (-30, -42)};
// (-30.3, -42) @TEXT("RL0", size=1.8, halign="end", valign="middle");
// %t36 = $SUPPLY @ATTACH &DVDD => @PLACE(-10, 65);
// &DVDD @WIRE {#XSW:34 %t36:p};
// %t37 = $SUPPLY @ATTACH &VREFP => @PLACE(10, 65);
// &VREFP @WIRE {#XSW:3 %t37:p};
// %t38 = $GROUND @ATTACH &VREFN => @PLACE(-10, -65);
// &VREFN @WIRE {#XSW:4 %t38:p};
// %t39 = $GROUND @ATTACH &VSS => @PLACE(10, -65);
// &VSS @WIRE {#XSW:35 %t39:p};
// %t40 = $GROUND @ATTACH &VSS => @PLACE(112, -65);
// &VSS @WIRE {#XCAP:34 %t40:p};
// }
// @RNL {
// #XBOOST @PLACE(150,-28);
// #MTN @PLACE(184,0) => @ORIENT("R0");
// #MTN @SET-SYMBOL $NMOS;
// #MTN @TEXT("LVT 14u / 40n", key="model", size=1, dx=1.5, dy=-1);
// &GBST @WIRE {#XBOOST:2 (181,-28) #MTN:2};
// &VCM @WIRE {#MTN:3 (184,-10) (198,-10)};
// (198.4,-10) @TEXT("VCM", size=1, valign="middle");
// %jn = (184,20);
// &TOP @WIRE {%jn #MTN:1};
// &TOP @WIRE {%jn (215,20)};
// (215.4,20) @TEXT("TOP", size=1.2, valign="middle");
// $JUNCTION @ATTACH %jn;
// &PHI_SB @WIRE {#XBOOST:1 (128,-28)};
// (127.6,-28) @TEXT("PHI_SB", size=1, halign="end", valign="middle");
// %vd = $SUPPLY @ATTACH &DVDD => @PLACE(146,-11);
// &DVDD @WIRE {#XBOOST:3 %vd:p};
// &VCM @WIRE {#XBOOST:4 (154,-11)};
// (154,-9) @TEXT("VCM -> VB", size=0.9, halign="middle");
// %vg = $GROUND @ATTACH &VSS => @PLACE(150,-45);
// &VSS @WIRE {#XBOOST:5 %vg:p};
// (128,38) @TEXT("Boosted real NMOS reset / experimental", size=1.3, bold=true);
// (128,-54) @TEXT("MTN bulk=VSS. MTP removed. MTD removed in primary.", size=1);
// &TOP @WIRE {#XCAP:1 (184,32) %jn};
// }
ends adc_cdac
subckt mq_cdac_sw12 (VIN VG DH RL EN ENB VREFP VREFN VSS DVDD EQBUS APGATE SAMP_ON BH BL)
XHCTL (DH HHIB DVDD VREFN VSS) mq_cdac_ctl_h
XLCTL (RL LHIB DVDD VREFN VSS) mq_cdac_ctl_l
XDH (HHIB EN ENB BH VREFP VREFN VSS DVDD) mq_cdac_drv12
MSH (BH VG VIN VSS) nch_lvt_mac w=1.143e-05 l=4e-08 nf=6
XDL (LHIB EN ENB BL VREFP VREFN VSS DVDD) mq_cdac_drv12
MSL (BL VG VIN VSS) nch_lvt_mac w=1.143e-05 l=4e-08 nf=6
MEQ1 (BH APGATE VIN VREFP) pch_ulvt_mac w=1.143e-05 l=3e-08 nf=6
MEQ2 (BL APGATE VIN VREFP) pch_ulvt_mac w=1.143e-05 l=3e-08 nf=6
MSHAREH (BH SAMP_ON EQBUS VSS) nch_ulvt_mac w=1.143e-05 l=3e-08 nf=6
MSHAREL (BL SAMP_ON EQBUS VSS) nch_ulvt_mac w=1.143e-05 l=3e-08 nf=6
// @RNL {
// {&VIN &VG &DH &RL &EN &ENB &VREFP &VREFN &VSS &DVDD &EQBUS &APGATE &SAMP_ON &BH &BL} @REMOVE-FROM $PORT_FILL_SET;
// &VSS @ADD-TO $GROUND_NET_SET;
// &VREFN @ADD-TO $GROUND_NET_SET;
// #XHCTL @PLACE(0, 20) => @ORIENT("R0");
// #XDH @PLACE(22, 18) => @ORIENT("R0");
// &HHIB @WIRE {#XHCTL:2 #XDH:1};
// #MSH @PLACE(45, 7) => @ORIENT("R0");
// #MSH @SET-SYMBOL $NMOS;
// #MSH @TEXT("LVT 40n 11.43u", key="model", size=1.05, dx=1.5, dy=-1);
// #MSH @TEXT("MSH", key="name", size=1.1, dx=1.5, dy=1);
// %j1 = (45, 20);
// &BH @WIRE {#XDH:4 %j1};
// &BH @WIRE {%j1 #MSH:1};
// #MEQ1 @PLACE(66, 7) => @ORIENT("MX");
// #MEQ1 @SET-SYMBOL $PMOS;
// #MEQ1 @TEXT("ULVT 11.43u", key="model", size=1.05, dx=1.5, dy=-1);
// #MEQ1 @TEXT("MEQ1", key="name", size=1.1, dx=1.5, dy=1);
// %j2 = (66, 20);
// &BH @WIRE {%j1 %j2};
// &BH @WIRE {%j2 #MEQ1:1};
// #MSHAREH @PLACE(87, 7) => @ORIENT("R0");
// #MSHAREH @SET-SYMBOL $NMOS;
// #MSHAREH @TEXT("ULVT 11.43u", key="model", size=1.05, dx=1.5, dy=-1);
// #MSHAREH @TEXT("MSHAREH", key="name", size=1.1, dx=1.5, dy=1);
// %j3 = (87, 20);
// &BH @WIRE {%j2 %j3};
// &BH @WIRE {%j3 #MSHAREH:1};
// &BH @WIRE {%j3 (105, 20)};
// (105, 22) @TEXT("BH", size=1.3);
// (-8, 36) @TEXT("H reference / sampling switches", size=1.2);
// #XLCTL @PLACE(0, -30) => @ORIENT("R0");
// #XDL @PLACE(22, -32) => @ORIENT("R0");
// &LHIB @WIRE {#XLCTL:2 #XDL:1};
// #MSL @PLACE(45, -43) => @ORIENT("R0");
// #MSL @SET-SYMBOL $NMOS;
// #MSL @TEXT("LVT 40n 11.43u", key="model", size=1.05, dx=1.5, dy=-1);
// #MSL @TEXT("MSL", key="name", size=1.1, dx=1.5, dy=1);
// %j4 = (45, -30);
// &BL @WIRE {#XDL:4 %j4};
// &BL @WIRE {%j4 #MSL:1};
// #MEQ2 @PLACE(66, -43) => @ORIENT("MX");
// #MEQ2 @SET-SYMBOL $PMOS;
// #MEQ2 @TEXT("ULVT 11.43u", key="model", size=1.05, dx=1.5, dy=-1);
// #MEQ2 @TEXT("MEQ2", key="name", size=1.1, dx=1.5, dy=1);
// %j5 = (66, -30);
// &BL @WIRE {%j4 %j5};
// &BL @WIRE {%j5 #MEQ2:1};
// #MSHAREL @PLACE(87, -43) => @ORIENT("R0");
// #MSHAREL @SET-SYMBOL $NMOS;
// #MSHAREL @TEXT("ULVT 11.43u", key="model", size=1.05, dx=1.5, dy=-1);
// #MSHAREL @TEXT("MSHAREL", key="name", size=1.1, dx=1.5, dy=1);
// %j6 = (87, -30);
// &BL @WIRE {%j5 %j6};
// &BL @WIRE {%j6 #MSHAREL:1};
// &BL @WIRE {%j6 (105, -30)};
// (105, -28) @TEXT("BL", size=1.3);
// (-8, -14) @TEXT("L reference / sampling switches", size=1.2);
// (-8, -56) @TEXT("Capacitors and 5% Cp are in sibling XCAP.", size=1.3);
// (-8, -60) @TEXT("N bulk = VSS; P assist / MID bulk = VREFP. L = 30 nm.", size=1.1);
// &DH @WIRE {#XHCTL:1 (-6, 20)};
// (-6.3, 20) @TEXT("DH", size=1.05, halign="end", valign="middle");
// &EN @WIRE {#XDH:2 (12, 16)};
// (11.7, 16) @TEXT("EN", size=1.05, halign="end", valign="middle");
// &ENB @WIRE {#XDH:3 (12, 13)};
// (11.7, 13) @TEXT("ENB", size=1.05, halign="end", valign="middle");
// %t10 = $SUPPLY @ATTACH &VREFP => @PLACE(25, 29);
// &VREFP @WIRE {#XDH:5 %t10:p};
// %t11 = $GROUND @ATTACH &VREFN => @PLACE(25, 7);
// &VREFN @WIRE {#XDH:6 %t11:p};
// %t12 = $GROUND @ATTACH &VSS => @PLACE(19, 7);
// &VSS @WIRE {#XDH:7 %t12:p};
// %t13 = $SUPPLY @ATTACH &DVDD => @PLACE(19, 29);
// &DVDD @WIRE {#XDH:8 %t13:p};
// &VG @WIRE {#MSH:2 (40, 7)};
// (39.7, 7) @TEXT("VG", size=1.05, halign="end", valign="middle");
// &VIN @WIRE {#MSH:3 (45, 3)};
// (45, 2.4) @TEXT("VIN", size=1.05, halign="middle", valign="top");
// &APGATE @WIRE {#MEQ1:2 (61, 7)};
// (60.7, 7) @TEXT("APGATE", size=1.05, halign="end", valign="middle");
// &VIN @WIRE {#MEQ1:3 (66, 3)};
// (66, 2.4) @TEXT("VIN", size=1.05, halign="middle", valign="top");
// &SAMP_ON @WIRE {#MSHAREH:2 (82, 7)};
// (81.7, 7) @TEXT("SAMP_ON", size=1.05, halign="end", valign="middle");
// &EQBUS @WIRE {#MSHAREH:3 (87, 3)};
// (87, 2.4) @TEXT("EQBUS", size=1.05, halign="middle", valign="top");
// &RL @WIRE {#XLCTL:1 (-6, -30)};
// (-6.3, -30) @TEXT("RL", size=1.05, halign="end", valign="middle");
// &EN @WIRE {#XDL:2 (12, -34)};
// (11.7, -34) @TEXT("EN", size=1.05, halign="end", valign="middle");
// &ENB @WIRE {#XDL:3 (12, -37)};
// (11.7, -37) @TEXT("ENB", size=1.05, halign="end", valign="middle");
// %t23 = $SUPPLY @ATTACH &VREFP => @PLACE(25, -21);
// &VREFP @WIRE {#XDL:5 %t23:p};
// %t24 = $GROUND @ATTACH &VREFN => @PLACE(25, -43);
// &VREFN @WIRE {#XDL:6 %t24:p};
// %t25 = $GROUND @ATTACH &VSS => @PLACE(19, -43);
// &VSS @WIRE {#XDL:7 %t25:p};
// %t26 = $SUPPLY @ATTACH &DVDD => @PLACE(19, -21);
// &DVDD @WIRE {#XDL:8 %t26:p};
// &VG @WIRE {#MSL:2 (40, -43)};
// (39.7, -43) @TEXT("VG", size=1.05, halign="end", valign="middle");
// &VIN @WIRE {#MSL:3 (45, -47)};
// (45, -47.6) @TEXT("VIN", size=1.05, halign="middle", valign="top");
// &APGATE @WIRE {#MEQ2:2 (61, -43)};
// (60.7, -43) @TEXT("APGATE", size=1.05, halign="end", valign="middle");
// &VIN @WIRE {#MEQ2:3 (66, -47)};
// (66, -47.6) @TEXT("VIN", size=1.05, halign="middle", valign="top");
// &SAMP_ON @WIRE {#MSHAREL:2 (82, -43)};
// (81.7, -43) @TEXT("SAMP_ON", size=1.05, halign="end", valign="middle");
// &EQBUS @WIRE {#MSHAREL:3 (87, -47)};
// (87, -47.6) @TEXT("EQBUS", size=1.05, halign="middle", valign="top");
// $JUNCTION @ATTACH %j1;
// $JUNCTION @ATTACH %j2;
// $JUNCTION @ATTACH %j3;
// $JUNCTION @ATTACH %j4;
// $JUNCTION @ATTACH %j5;
// $JUNCTION @ATTACH %j6;
// (-8, 48) @TEXT("V29 / WIP | bit 12 switches | no MOM capacitors", size=1.4, bold=true, textcolor="#17365d");
// }
ends mq_cdac_sw12
subckt mq_cdac_sw11 (VIN VG DH RL EN ENB VREFP VREFN VSS DVDD EQBUS APGATE SAMP_ON BH BL)
XHCTL (DH HHIB DVDD VREFN VSS) mq_cdac_ctl_h
XLCTL (RL LHIB DVDD VREFN VSS) mq_cdac_ctl_l
XDH (HHIB EN ENB BH VREFP VREFN VSS DVDD) mq_cdac_drv11
MSH (BH VG VIN VSS) nch_lvt_mac w=6.54e-06 l=4e-08 nf=4
XDL (LHIB EN ENB BL VREFP VREFN VSS DVDD) mq_cdac_drv11
MSL (BL VG VIN VSS) nch_lvt_mac w=6.54e-06 l=4e-08 nf=4
MEQ1 (BH APGATE VIN VREFP) pch_ulvt_mac w=6.54e-06 l=3e-08 nf=4
MEQ2 (BL APGATE VIN VREFP) pch_ulvt_mac w=6.54e-06 l=3e-08 nf=4
MSHAREH (BH SAMP_ON EQBUS VSS) nch_ulvt_mac w=6.54e-06 l=3e-08 nf=4
MSHAREL (BL SAMP_ON EQBUS VSS) nch_ulvt_mac w=6.54e-06 l=3e-08 nf=4
// @RNL {
// {&VIN &VG &DH &RL &EN &ENB &VREFP &VREFN &VSS &DVDD &EQBUS &APGATE &SAMP_ON &BH &BL} @REMOVE-FROM $PORT_FILL_SET;
// &VSS @ADD-TO $GROUND_NET_SET;
// &VREFN @ADD-TO $GROUND_NET_SET;
// #XHCTL @PLACE(0, 20) => @ORIENT("R0");
// #XDH @PLACE(22, 18) => @ORIENT("R0");
// &HHIB @WIRE {#XHCTL:2 #XDH:1};
// #MSH @PLACE(45, 7) => @ORIENT("R0");
// #MSH @SET-SYMBOL $NMOS;
// #MSH @TEXT("LVT 40n 6.54u", key="model", size=1.05, dx=1.5, dy=-1);
// #MSH @TEXT("MSH", key="name", size=1.1, dx=1.5, dy=1);
// %j1 = (45, 20);
// &BH @WIRE {#XDH:4 %j1};
// &BH @WIRE {%j1 #MSH:1};
// #MEQ1 @PLACE(66, 7) => @ORIENT("MX");
// #MEQ1 @SET-SYMBOL $PMOS;
// #MEQ1 @TEXT("ULVT 6.54u", key="model", size=1.05, dx=1.5, dy=-1);
// #MEQ1 @TEXT("MEQ1", key="name", size=1.1, dx=1.5, dy=1);
// %j2 = (66, 20);
// &BH @WIRE {%j1 %j2};
// &BH @WIRE {%j2 #MEQ1:1};
// #MSHAREH @PLACE(87, 7) => @ORIENT("R0");
// #MSHAREH @SET-SYMBOL $NMOS;
// #MSHAREH @TEXT("ULVT 6.54u", key="model", size=1.05, dx=1.5, dy=-1);
// #MSHAREH @TEXT("MSHAREH", key="name", size=1.1, dx=1.5, dy=1);
// %j3 = (87, 20);
// &BH @WIRE {%j2 %j3};
// &BH @WIRE {%j3 #MSHAREH:1};
// &BH @WIRE {%j3 (105, 20)};
// (105, 22) @TEXT("BH", size=1.3);
// (-8, 36) @TEXT("H reference / sampling switches", size=1.2);
// #XLCTL @PLACE(0, -30) => @ORIENT("R0");
// #XDL @PLACE(22, -32) => @ORIENT("R0");
// &LHIB @WIRE {#XLCTL:2 #XDL:1};
// #MSL @PLACE(45, -43) => @ORIENT("R0");
// #MSL @SET-SYMBOL $NMOS;
// #MSL @TEXT("LVT 40n 6.54u", key="model", size=1.05, dx=1.5, dy=-1);
// #MSL @TEXT("MSL", key="name", size=1.1, dx=1.5, dy=1);
// %j4 = (45, -30);
// &BL @WIRE {#XDL:4 %j4};
// &BL @WIRE {%j4 #MSL:1};
// #MEQ2 @PLACE(66, -43) => @ORIENT("MX");
// #MEQ2 @SET-SYMBOL $PMOS;
// #MEQ2 @TEXT("ULVT 6.54u", key="model", size=1.05, dx=1.5, dy=-1);
// #MEQ2 @TEXT("MEQ2", key="name", size=1.1, dx=1.5, dy=1);
// %j5 = (66, -30);
// &BL @WIRE {%j4 %j5};
// &BL @WIRE {%j5 #MEQ2:1};
// #MSHAREL @PLACE(87, -43) => @ORIENT("R0");
// #MSHAREL @SET-SYMBOL $NMOS;
// #MSHAREL @TEXT("ULVT 6.54u", key="model", size=1.05, dx=1.5, dy=-1);
// #MSHAREL @TEXT("MSHAREL", key="name", size=1.1, dx=1.5, dy=1);
// %j6 = (87, -30);
// &BL @WIRE {%j5 %j6};
// &BL @WIRE {%j6 #MSHAREL:1};
// &BL @WIRE {%j6 (105, -30)};
// (105, -28) @TEXT("BL", size=1.3);
// (-8, -14) @TEXT("L reference / sampling switches", size=1.2);
// (-8, -56) @TEXT("Capacitors and 5% Cp are in sibling XCAP.", size=1.3);
// (-8, -60) @TEXT("N bulk = VSS; P assist / MID bulk = VREFP. L = 30 nm.", size=1.1);
// &DH @WIRE {#XHCTL:1 (-6, 20)};
// (-6.3, 20) @TEXT("DH", size=1.05, halign="end", valign="middle");
// &EN @WIRE {#XDH:2 (12, 16)};
// (11.7, 16) @TEXT("EN", size=1.05, halign="end", valign="middle");
// &ENB @WIRE {#XDH:3 (12, 13)};
// (11.7, 13) @TEXT("ENB", size=1.05, halign="end", valign="middle");
// %t10 = $SUPPLY @ATTACH &VREFP => @PLACE(25, 29);
// &VREFP @WIRE {#XDH:5 %t10:p};
// %t11 = $GROUND @ATTACH &VREFN => @PLACE(25, 7);
// &VREFN @WIRE {#XDH:6 %t11:p};
// %t12 = $GROUND @ATTACH &VSS => @PLACE(19, 7);
// &VSS @WIRE {#XDH:7 %t12:p};
// %t13 = $SUPPLY @ATTACH &DVDD => @PLACE(19, 29);
// &DVDD @WIRE {#XDH:8 %t13:p};
// &VG @WIRE {#MSH:2 (40, 7)};
// (39.7, 7) @TEXT("VG", size=1.05, halign="end", valign="middle");
// &VIN @WIRE {#MSH:3 (45, 3)};
// (45, 2.4) @TEXT("VIN", size=1.05, halign="middle", valign="top");
// &APGATE @WIRE {#MEQ1:2 (61, 7)};
// (60.7, 7) @TEXT("APGATE", size=1.05, halign="end", valign="middle");
// &VIN @WIRE {#MEQ1:3 (66, 3)};
// (66, 2.4) @TEXT("VIN", size=1.05, halign="middle", valign="top");
// &SAMP_ON @WIRE {#MSHAREH:2 (82, 7)};
// (81.7, 7) @TEXT("SAMP_ON", size=1.05, halign="end", valign="middle");
// &EQBUS @WIRE {#MSHAREH:3 (87, 3)};
// (87, 2.4) @TEXT("EQBUS", size=1.05, halign="middle", valign="top");
// &RL @WIRE {#XLCTL:1 (-6, -30)};
// (-6.3, -30) @TEXT("RL", size=1.05, halign="end", valign="middle");
// &EN @WIRE {#XDL:2 (12, -34)};
// (11.7, -34) @TEXT("EN", size=1.05, halign="end", valign="middle");
// &ENB @WIRE {#XDL:3 (12, -37)};
// (11.7, -37) @TEXT("ENB", size=1.05, halign="end", valign="middle");
// %t23 = $SUPPLY @ATTACH &VREFP => @PLACE(25, -21);
// &VREFP @WIRE {#XDL:5 %t23:p};
// %t24 = $GROUND @ATTACH &VREFN => @PLACE(25, -43);
// &VREFN @WIRE {#XDL:6 %t24:p};
// %t25 = $GROUND @ATTACH &VSS => @PLACE(19, -43);
// &VSS @WIRE {#XDL:7 %t25:p};
// %t26 = $SUPPLY @ATTACH &DVDD => @PLACE(19, -21);
// &DVDD @WIRE {#XDL:8 %t26:p};
// &VG @WIRE {#MSL:2 (40, -43)};
// (39.7, -43) @TEXT("VG", size=1.05, halign="end", valign="middle");
// &VIN @WIRE {#MSL:3 (45, -47)};
// (45, -47.6) @TEXT("VIN", size=1.05, halign="middle", valign="top");
// &APGATE @WIRE {#MEQ2:2 (61, -43)};
// (60.7, -43) @TEXT("APGATE", size=1.05, halign="end", valign="middle");
// &VIN @WIRE {#MEQ2:3 (66, -47)};
// (66, -47.6) @TEXT("VIN", size=1.05, halign="middle", valign="top");
// &SAMP_ON @WIRE {#MSHAREL:2 (82, -43)};
// (81.7, -43) @TEXT("SAMP_ON", size=1.05, halign="end", valign="middle");
// &EQBUS @WIRE {#MSHAREL:3 (87, -47)};
// (87, -47.6) @TEXT("EQBUS", size=1.05, halign="middle", valign="top");
// $JUNCTION @ATTACH %j1;
// $JUNCTION @ATTACH %j2;
// $JUNCTION @ATTACH %j3;
// $JUNCTION @ATTACH %j4;
// $JUNCTION @ATTACH %j5;
// $JUNCTION @ATTACH %j6;
// (-8, 48) @TEXT("V29 / WIP | bit 11 switches | no MOM capacitors", size=1.4, bold=true, textcolor="#17365d");
// }
ends mq_cdac_sw11
subckt mq_cdac_sw10 (VIN VG DH RL EN ENB VREFP VREFN VSS DVDD EQBUS APGATE SAMP_ON BH BL)
XHCTL (DH HHIB DVDD VREFN VSS) mq_cdac_ctl_h
XLCTL (RL LHIB DVDD VREFN VSS) mq_cdac_ctl_l
XDH (HHIB EN ENB BH VREFP VREFN VSS DVDD) mq_cdac_drv10
MSH (BH VG VIN VSS) nch_ulvt_mac w=3.71e-06 l=3e-08 nf=2
XDL (LHIB EN ENB BL VREFP VREFN VSS DVDD) mq_cdac_drv10
MSL (BL VG VIN VSS) nch_ulvt_mac w=3.71e-06 l=3e-08 nf=2
MEQ1 (BH APGATE VIN VREFP) pch_ulvt_mac w=3.71e-06 l=3e-08 nf=2
MEQ2 (BL APGATE VIN VREFP) pch_ulvt_mac w=3.71e-06 l=3e-08 nf=2
MSHAREH (BH SAMP_ON EQBUS VSS) nch_ulvt_mac w=3.71e-06 l=3e-08 nf=2
MSHAREL (BL SAMP_ON EQBUS VSS) nch_ulvt_mac w=3.71e-06 l=3e-08 nf=2
// @RNL {
// {&VIN &VG &DH &RL &EN &ENB &VREFP &VREFN &VSS &DVDD &EQBUS &APGATE &SAMP_ON &BH &BL} @REMOVE-FROM $PORT_FILL_SET;
// &VSS @ADD-TO $GROUND_NET_SET;
// &VREFN @ADD-TO $GROUND_NET_SET;
// #XHCTL @PLACE(0, 20) => @ORIENT("R0");
// #XDH @PLACE(22, 18) => @ORIENT("R0");
// &HHIB @WIRE {#XHCTL:2 #XDH:1};
// #MSH @PLACE(45, 7) => @ORIENT("R0");
// #MSH @SET-SYMBOL $NMOS;
// #MSH @TEXT("ULVT 3.71u", key="model", size=1.05, dx=1.5, dy=-1);
// #MSH @TEXT("MSH", key="name", size=1.1, dx=1.5, dy=1);
// %j1 = (45, 20);
// &BH @WIRE {#XDH:4 %j1};
// &BH @WIRE {%j1 #MSH:1};
// #MEQ1 @PLACE(66, 7) => @ORIENT("MX");
// #MEQ1 @SET-SYMBOL $PMOS;
// #MEQ1 @TEXT("ULVT 3.71u", key="model", size=1.05, dx=1.5, dy=-1);
// #MEQ1 @TEXT("MEQ1", key="name", size=1.1, dx=1.5, dy=1);
// %j2 = (66, 20);
// &BH @WIRE {%j1 %j2};
// &BH @WIRE {%j2 #MEQ1:1};
// #MSHAREH @PLACE(87, 7) => @ORIENT("R0");
// #MSHAREH @SET-SYMBOL $NMOS;
// #MSHAREH @TEXT("ULVT 3.71u", key="model", size=1.05, dx=1.5, dy=-1);
// #MSHAREH @TEXT("MSHAREH", key="name", size=1.1, dx=1.5, dy=1);
// %j3 = (87, 20);
// &BH @WIRE {%j2 %j3};
// &BH @WIRE {%j3 #MSHAREH:1};
// &BH @WIRE {%j3 (105, 20)};
// (105, 22) @TEXT("BH", size=1.3);
// (-8, 36) @TEXT("H reference / sampling switches", size=1.2);
// #XLCTL @PLACE(0, -30) => @ORIENT("R0");
// #XDL @PLACE(22, -32) => @ORIENT("R0");
// &LHIB @WIRE {#XLCTL:2 #XDL:1};
// #MSL @PLACE(45, -43) => @ORIENT("R0");
// #MSL @SET-SYMBOL $NMOS;
// #MSL @TEXT("ULVT 3.71u", key="model", size=1.05, dx=1.5, dy=-1);
// #MSL @TEXT("MSL", key="name", size=1.1, dx=1.5, dy=1);
// %j4 = (45, -30);
// &BL @WIRE {#XDL:4 %j4};
// &BL @WIRE {%j4 #MSL:1};
// #MEQ2 @PLACE(66, -43) => @ORIENT("MX");
// #MEQ2 @SET-SYMBOL $PMOS;
// #MEQ2 @TEXT("ULVT 3.71u", key="model", size=1.05, dx=1.5, dy=-1);
// #MEQ2 @TEXT("MEQ2", key="name", size=1.1, dx=1.5, dy=1);
// %j5 = (66, -30);
// &BL @WIRE {%j4 %j5};
// &BL @WIRE {%j5 #MEQ2:1};
// #MSHAREL @PLACE(87, -43) => @ORIENT("R0");
// #MSHAREL @SET-SYMBOL $NMOS;
// #MSHAREL @TEXT("ULVT 3.71u", key="model", size=1.05, dx=1.5, dy=-1);
// #MSHAREL @TEXT("MSHAREL", key="name", size=1.1, dx=1.5, dy=1);
// %j6 = (87, -30);
// &BL @WIRE {%j5 %j6};
// &BL @WIRE {%j6 #MSHAREL:1};
// &BL @WIRE {%j6 (105, -30)};
// (105, -28) @TEXT("BL", size=1.3);
// (-8, -14) @TEXT("L reference / sampling switches", size=1.2);
// (-8, -56) @TEXT("Capacitors and 5% Cp are in sibling XCAP.", size=1.3);
// (-8, -60) @TEXT("N bulk = VSS; P assist / MID bulk = VREFP. L = 30 nm.", size=1.1);
// &DH @WIRE {#XHCTL:1 (-6, 20)};
// (-6.3, 20) @TEXT("DH", size=1.05, halign="end", valign="middle");
// &EN @WIRE {#XDH:2 (12, 16)};
// (11.7, 16) @TEXT("EN", size=1.05, halign="end", valign="middle");
// &ENB @WIRE {#XDH:3 (12, 13)};
// (11.7, 13) @TEXT("ENB", size=1.05, halign="end", valign="middle");
// %t10 = $SUPPLY @ATTACH &VREFP => @PLACE(25, 29);
// &VREFP @WIRE {#XDH:5 %t10:p};
// %t11 = $GROUND @ATTACH &VREFN => @PLACE(25, 7);
// &VREFN @WIRE {#XDH:6 %t11:p};
// %t12 = $GROUND @ATTACH &VSS => @PLACE(19, 7);
// &VSS @WIRE {#XDH:7 %t12:p};
// %t13 = $SUPPLY @ATTACH &DVDD => @PLACE(19, 29);
// &DVDD @WIRE {#XDH:8 %t13:p};
// &VG @WIRE {#MSH:2 (40, 7)};
// (39.7, 7) @TEXT("VG", size=1.05, halign="end", valign="middle");
// &VIN @WIRE {#MSH:3 (45, 3)};
// (45, 2.4) @TEXT("VIN", size=1.05, halign="middle", valign="top");
// &APGATE @WIRE {#MEQ1:2 (61, 7)};
// (60.7, 7) @TEXT("APGATE", size=1.05, halign="end", valign="middle");
// &VIN @WIRE {#MEQ1:3 (66, 3)};
// (66, 2.4) @TEXT("VIN", size=1.05, halign="middle", valign="top");
// &SAMP_ON @WIRE {#MSHAREH:2 (82, 7)};
// (81.7, 7) @TEXT("SAMP_ON", size=1.05, halign="end", valign="middle");
// &EQBUS @WIRE {#MSHAREH:3 (87, 3)};
// (87, 2.4) @TEXT("EQBUS", size=1.05, halign="middle", valign="top");
// &RL @WIRE {#XLCTL:1 (-6, -30)};
// (-6.3, -30) @TEXT("RL", size=1.05, halign="end", valign="middle");
// &EN @WIRE {#XDL:2 (12, -34)};
// (11.7, -34) @TEXT("EN", size=1.05, halign="end", valign="middle");
// &ENB @WIRE {#XDL:3 (12, -37)};
// (11.7, -37) @TEXT("ENB", size=1.05, halign="end", valign="middle");
// %t23 = $SUPPLY @ATTACH &VREFP => @PLACE(25, -21);
// &VREFP @WIRE {#XDL:5 %t23:p};
// %t24 = $GROUND @ATTACH &VREFN => @PLACE(25, -43);
// &VREFN @WIRE {#XDL:6 %t24:p};
// %t25 = $GROUND @ATTACH &VSS => @PLACE(19, -43);
// &VSS @WIRE {#XDL:7 %t25:p};
// %t26 = $SUPPLY @ATTACH &DVDD => @PLACE(19, -21);
// &DVDD @WIRE {#XDL:8 %t26:p};
// &VG @WIRE {#MSL:2 (40, -43)};
// (39.7, -43) @TEXT("VG", size=1.05, halign="end", valign="middle");
// &VIN @WIRE {#MSL:3 (45, -47)};
// (45, -47.6) @TEXT("VIN", size=1.05, halign="middle", valign="top");
// &APGATE @WIRE {#MEQ2:2 (61, -43)};
// (60.7, -43) @TEXT("APGATE", size=1.05, halign="end", valign="middle");
// &VIN @WIRE {#MEQ2:3 (66, -47)};
// (66, -47.6) @TEXT("VIN", size=1.05, halign="middle", valign="top");
// &SAMP_ON @WIRE {#MSHAREL:2 (82, -43)};
// (81.7, -43) @TEXT("SAMP_ON", size=1.05, halign="end", valign="middle");
// &EQBUS @WIRE {#MSHAREL:3 (87, -47)};
// (87, -47.6) @TEXT("EQBUS", size=1.05, halign="middle", valign="top");
// $JUNCTION @ATTACH %j1;
// $JUNCTION @ATTACH %j2;
// $JUNCTION @ATTACH %j3;
// $JUNCTION @ATTACH %j4;
// $JUNCTION @ATTACH %j5;
// $JUNCTION @ATTACH %j6;
// (-8, 48) @TEXT("V29 / WIP | bit 10 switches | no MOM capacitors", size=1.4, bold=true, textcolor="#17365d");
// }
ends mq_cdac_sw10
subckt mq_cdac_sw9 (DH RL EN ENB VREFP VREFN VSS DVDD BH BL)
XHCTL (DH HHIB DVDD VREFN VSS) mq_cdac_ctl_h
XLCTL (RL LHIB DVDD VREFN VSS) mq_cdac_ctl_l
XDH (HHIB EN ENB BH VREFP VREFN VSS DVDD) mq_cdac_drv9
XDL (LHIB EN ENB BL VREFP VREFN VSS DVDD) mq_cdac_drv9
// @RNL {
// {&DH &RL &EN &ENB &VREFP &VREFN &VSS &DVDD &BH &BL} @REMOVE-FROM $PORT_FILL_SET;
// &VSS @ADD-TO $GROUND_NET_SET;
// &VREFN @ADD-TO $GROUND_NET_SET;
// #XHCTL @PLACE(0, 20) => @ORIENT("R0");
// #XDH @PLACE(22, 18) => @ORIENT("R0");
// &HHIB @WIRE {#XHCTL:2 #XDH:1};
// &BH @WIRE {#XDH:4 (105, 20)};
// (105, 22) @TEXT("BH", size=1.3);
// (-8, 36) @TEXT("H reference / sampling switches", size=1.2);
// #XLCTL @PLACE(0, -30) => @ORIENT("R0");
// #XDL @PLACE(22, -32) => @ORIENT("R0");
// &LHIB @WIRE {#XLCTL:2 #XDL:1};
// &BL @WIRE {#XDL:4 (105, -30)};
// (105, -28) @TEXT("BL", size=1.3);
// (-8, -14) @TEXT("L reference / sampling switches", size=1.2);
// (-8, -56) @TEXT("Capacitors and 5% Cp are in sibling XCAP.", size=1.3);
// (-8, -60) @TEXT("N bulk = VSS; P assist / MID bulk = VREFP. L = 30 nm.", size=1.1);
// &DH @WIRE {#XHCTL:1 (-6, 20)};
// (-6.3, 20) @TEXT("DH", size=1.05, halign="end", valign="middle");
// &EN @WIRE {#XDH:2 (12, 16)};
// (11.7, 16) @TEXT("EN", size=1.05, halign="end", valign="middle");
// &ENB @WIRE {#XDH:3 (12, 13)};
// (11.7, 13) @TEXT("ENB", size=1.05, halign="end", valign="middle");
// %t4 = $SUPPLY @ATTACH &VREFP => @PLACE(25, 29);
// &VREFP @WIRE {#XDH:5 %t4:p};
// %t5 = $GROUND @ATTACH &VREFN => @PLACE(25, 7);
// &VREFN @WIRE {#XDH:6 %t5:p};
// %t6 = $GROUND @ATTACH &VSS => @PLACE(19, 7);
// &VSS @WIRE {#XDH:7 %t6:p};
// %t7 = $SUPPLY @ATTACH &DVDD => @PLACE(19, 29);
// &DVDD @WIRE {#XDH:8 %t7:p};
// &RL @WIRE {#XLCTL:1 (-6, -30)};
// (-6.3, -30) @TEXT("RL", size=1.05, halign="end", valign="middle");
// &EN @WIRE {#XDL:2 (12, -34)};
// (11.7, -34) @TEXT("EN", size=1.05, halign="end", valign="middle");
// &ENB @WIRE {#XDL:3 (12, -37)};
// (11.7, -37) @TEXT("ENB", size=1.05, halign="end", valign="middle");
// %t11 = $SUPPLY @ATTACH &VREFP => @PLACE(25, -21);
// &VREFP @WIRE {#XDL:5 %t11:p};
// %t12 = $GROUND @ATTACH &VREFN => @PLACE(25, -43);
// &VREFN @WIRE {#XDL:6 %t12:p};
// %t13 = $GROUND @ATTACH &VSS => @PLACE(19, -43);
// &VSS @WIRE {#XDL:7 %t13:p};
// %t14 = $SUPPLY @ATTACH &DVDD => @PLACE(19, -21);
// &DVDD @WIRE {#XDL:8 %t14:p};
// (-8, 48) @TEXT("V29 / WIP | bit 9 switches | no MOM capacitors", size=1.4, bold=true, textcolor="#17365d");
// }
ends mq_cdac_sw9
subckt mq_cdac_sw8 (VIN VG DH RL EN ENB VREFP VREFN VSS DVDD EQBUS APGATE SAMP_ON BH BL)
XHCTL (DH HHIB DVDD VREFN VSS) mq_cdac_ctl_h
XLCTL (RL LHIB DVDD VREFN VSS) mq_cdac_ctl_l
XDH (HHIB EN ENB BH VREFP VREFN VSS DVDD) mq_cdac_drv8
MSH (BH VG VIN VSS) nch_ulvt_mac w=1.19e-06 l=3e-08 nf=1
XDL (LHIB EN ENB BL VREFP VREFN VSS DVDD) mq_cdac_drv8
MSL (BL VG VIN VSS) nch_ulvt_mac w=1.19e-06 l=3e-08 nf=1
MEQ1 (BH APGATE VIN VREFP) pch_ulvt_mac w=1.19e-06 l=3e-08 nf=1
MEQ2 (BL APGATE VIN VREFP) pch_ulvt_mac w=1.19e-06 l=3e-08 nf=1
MSHAREH (BH SAMP_ON EQBUS VSS) nch_ulvt_mac w=1.19e-06 l=3e-08 nf=1
MSHAREL (BL SAMP_ON EQBUS VSS) nch_ulvt_mac w=1.19e-06 l=3e-08 nf=1
// @RNL {
// {&VIN &VG &DH &RL &EN &ENB &VREFP &VREFN &VSS &DVDD &EQBUS &APGATE &SAMP_ON &BH &BL} @REMOVE-FROM $PORT_FILL_SET;
// &VSS @ADD-TO $GROUND_NET_SET;
// &VREFN @ADD-TO $GROUND_NET_SET;
// #XHCTL @PLACE(0, 20) => @ORIENT("R0");
// #XDH @PLACE(22, 18) => @ORIENT("R0");
// &HHIB @WIRE {#XHCTL:2 #XDH:1};
// #MSH @PLACE(45, 7) => @ORIENT("R0");
// #MSH @SET-SYMBOL $NMOS;
// #MSH @TEXT("ULVT 1.19u", key="model", size=1.05, dx=1.5, dy=-1);
// #MSH @TEXT("MSH", key="name", size=1.1, dx=1.5, dy=1);
// %j1 = (45, 20);
// &BH @WIRE {#XDH:4 %j1};
// &BH @WIRE {%j1 #MSH:1};
// #MEQ1 @PLACE(66, 7) => @ORIENT("MX");
// #MEQ1 @SET-SYMBOL $PMOS;
// #MEQ1 @TEXT("ULVT 1.19u", key="model", size=1.05, dx=1.5, dy=-1);
// #MEQ1 @TEXT("MEQ1", key="name", size=1.1, dx=1.5, dy=1);
// %j2 = (66, 20);
// &BH @WIRE {%j1 %j2};
// &BH @WIRE {%j2 #MEQ1:1};
// #MSHAREH @PLACE(87, 7) => @ORIENT("R0");
// #MSHAREH @SET-SYMBOL $NMOS;
// #MSHAREH @TEXT("ULVT 1.19u", key="model", size=1.05, dx=1.5, dy=-1);
// #MSHAREH @TEXT("MSHAREH", key="name", size=1.1, dx=1.5, dy=1);
// %j3 = (87, 20);
// &BH @WIRE {%j2 %j3};
// &BH @WIRE {%j3 #MSHAREH:1};
// &BH @WIRE {%j3 (105, 20)};
// (105, 22) @TEXT("BH", size=1.3);
// (-8, 36) @TEXT("H reference / sampling switches", size=1.2);
// #XLCTL @PLACE(0, -30) => @ORIENT("R0");
// #XDL @PLACE(22, -32) => @ORIENT("R0");
// &LHIB @WIRE {#XLCTL:2 #XDL:1};
// #MSL @PLACE(45, -43) => @ORIENT("R0");
// #MSL @SET-SYMBOL $NMOS;
// #MSL @TEXT("ULVT 1.19u", key="model", size=1.05, dx=1.5, dy=-1);
// #MSL @TEXT("MSL", key="name", size=1.1, dx=1.5, dy=1);
// %j4 = (45, -30);
// &BL @WIRE {#XDL:4 %j4};
// &BL @WIRE {%j4 #MSL:1};
// #MEQ2 @PLACE(66, -43) => @ORIENT("MX");
// #MEQ2 @SET-SYMBOL $PMOS;
// #MEQ2 @TEXT("ULVT 1.19u", key="model", size=1.05, dx=1.5, dy=-1);
// #MEQ2 @TEXT("MEQ2", key="name", size=1.1, dx=1.5, dy=1);
// %j5 = (66, -30);
// &BL @WIRE {%j4 %j5};
// &BL @WIRE {%j5 #MEQ2:1};
// #MSHAREL @PLACE(87, -43) => @ORIENT("R0");
// #MSHAREL @SET-SYMBOL $NMOS;
// #MSHAREL @TEXT("ULVT 1.19u", key="model", size=1.05, dx=1.5, dy=-1);
// #MSHAREL @TEXT("MSHAREL", key="name", size=1.1, dx=1.5, dy=1);
// %j6 = (87, -30);
// &BL @WIRE {%j5 %j6};
// &BL @WIRE {%j6 #MSHAREL:1};
// &BL @WIRE {%j6 (105, -30)};
// (105, -28) @TEXT("BL", size=1.3);
// (-8, -14) @TEXT("L reference / sampling switches", size=1.2);
// (-8, -56) @TEXT("Capacitors and 5% Cp are in sibling XCAP.", size=1.3);
// (-8, -60) @TEXT("N bulk = VSS; P assist / MID bulk = VREFP. L = 30 nm.", size=1.1);
// &DH @WIRE {#XHCTL:1 (-6, 20)};
// (-6.3, 20) @TEXT("DH", size=1.05, halign="end", valign="middle");
// &EN @WIRE {#XDH:2 (12, 16)};
// (11.7, 16) @TEXT("EN", size=1.05, halign="end", valign="middle");
// &ENB @WIRE {#XDH:3 (12, 13)};
// (11.7, 13) @TEXT("ENB", size=1.05, halign="end", valign="middle");
// %t10 = $SUPPLY @ATTACH &VREFP => @PLACE(25, 29);
// &VREFP @WIRE {#XDH:5 %t10:p};
// %t11 = $GROUND @ATTACH &VREFN => @PLACE(25, 7);
// &VREFN @WIRE {#XDH:6 %t11:p};
// %t12 = $GROUND @ATTACH &VSS => @PLACE(19, 7);
// &VSS @WIRE {#XDH:7 %t12:p};
// %t13 = $SUPPLY @ATTACH &DVDD => @PLACE(19, 29);
// &DVDD @WIRE {#XDH:8 %t13:p};
// &VG @WIRE {#MSH:2 (40, 7)};
// (39.7, 7) @TEXT("VG", size=1.05, halign="end", valign="middle");
// &VIN @WIRE {#MSH:3 (45, 3)};
// (45, 2.4) @TEXT("VIN", size=1.05, halign="middle", valign="top");
// &APGATE @WIRE {#MEQ1:2 (61, 7)};
// (60.7, 7) @TEXT("APGATE", size=1.05, halign="end", valign="middle");
// &VIN @WIRE {#MEQ1:3 (66, 3)};
// (66, 2.4) @TEXT("VIN", size=1.05, halign="middle", valign="top");
// &SAMP_ON @WIRE {#MSHAREH:2 (82, 7)};
// (81.7, 7) @TEXT("SAMP_ON", size=1.05, halign="end", valign="middle");
// &EQBUS @WIRE {#MSHAREH:3 (87, 3)};
// (87, 2.4) @TEXT("EQBUS", size=1.05, halign="middle", valign="top");
// &RL @WIRE {#XLCTL:1 (-6, -30)};
// (-6.3, -30) @TEXT("RL", size=1.05, halign="end", valign="middle");
// &EN @WIRE {#XDL:2 (12, -34)};
// (11.7, -34) @TEXT("EN", size=1.05, halign="end", valign="middle");
// &ENB @WIRE {#XDL:3 (12, -37)};
// (11.7, -37) @TEXT("ENB", size=1.05, halign="end", valign="middle");
// %t23 = $SUPPLY @ATTACH &VREFP => @PLACE(25, -21);
// &VREFP @WIRE {#XDL:5 %t23:p};
// %t24 = $GROUND @ATTACH &VREFN => @PLACE(25, -43);
// &VREFN @WIRE {#XDL:6 %t24:p};
// %t25 = $GROUND @ATTACH &VSS => @PLACE(19, -43);
// &VSS @WIRE {#XDL:7 %t25:p};
// %t26 = $SUPPLY @ATTACH &DVDD => @PLACE(19, -21);
// &DVDD @WIRE {#XDL:8 %t26:p};
// &VG @WIRE {#MSL:2 (40, -43)};
// (39.7, -43) @TEXT("VG", size=1.05, halign="end", valign="middle");
// &VIN @WIRE {#MSL:3 (45, -47)};
// (45, -47.6) @TEXT("VIN", size=1.05, halign="middle", valign="top");
// &APGATE @WIRE {#MEQ2:2 (61, -43)};
// (60.7, -43) @TEXT("APGATE", size=1.05, halign="end", valign="middle");
// &VIN @WIRE {#MEQ2:3 (66, -47)};
// (66, -47.6) @TEXT("VIN", size=1.05, halign="middle", valign="top");
// &SAMP_ON @WIRE {#MSHAREL:2 (82, -43)};
// (81.7, -43) @TEXT("SAMP_ON", size=1.05, halign="end", valign="middle");
// &EQBUS @WIRE {#MSHAREL:3 (87, -47)};
// (87, -47.6) @TEXT("EQBUS", size=1.05, halign="middle", valign="top");
// $JUNCTION @ATTACH %j1;
// $JUNCTION @ATTACH %j2;
// $JUNCTION @ATTACH %j3;
// $JUNCTION @ATTACH %j4;
// $JUNCTION @ATTACH %j5;
// $JUNCTION @ATTACH %j6;
// (-8, 48) @TEXT("V29 / WIP | bit 8 switches | no MOM capacitors", size=1.4, bold=true, textcolor="#17365d");
// }
ends mq_cdac_sw8
subckt mq_cdac_sw7 (VIN VG DH RL EN ENB VREFP VREFN VSS PHI_S DVDD AP_OFF EQBUS APGATE SAMP_ON BH BL MIDH MIDL)
XHCTL (DH HHIB DVDD VREFN VSS) mq_cdac_ctl_h
XLCTL (RL LHIB DVDD VREFN VSS) mq_cdac_ctl_l
XDH (HHIB EN ENB BH VREFP VREFN VSS DVDD) mq_cdac_drv7
MSH (BH VG VIN VSS) nch_ulvt_mac w=6.65e-07 l=3e-08 nf=1
XDL (LHIB EN ENB BL VREFP VREFN VSS DVDD) mq_cdac_drv7
MSL (BL VG VIN VSS) nch_ulvt_mac w=6.65e-07 l=3e-08 nf=1
MEQ1 (BH APGATE VIN VREFP) pch_ulvt_mac w=6.65e-07 l=3e-08 nf=1
MEQ2 (BL APGATE VIN VREFP) pch_ulvt_mac w=6.65e-07 l=3e-08 nf=1
MMIDNH (MIDH PHI_S VIN VSS) nch_ulvt_mac w=1.2e-07 l=3e-08 nf=1
MMIDPH (MIDH AP_OFF VIN VREFP) pch_mac w=1.2e-07 l=3e-08 nf=1
MMIDNL (MIDL PHI_S VIN VSS) nch_ulvt_mac w=1.2e-07 l=3e-08 nf=1
MMIDPL (MIDL AP_OFF VIN VREFP) pch_mac w=1.2e-07 l=3e-08 nf=1
MSHAREH (BH SAMP_ON EQBUS VSS) nch_ulvt_mac w=6.65e-07 l=3e-08 nf=1
MSHAREL (BL SAMP_ON EQBUS VSS) nch_ulvt_mac w=6.65e-07 l=3e-08 nf=1
// @RNL {
// {&VIN &VG &DH &RL &EN &ENB &VREFP &VREFN &VSS &PHI_S &DVDD &AP_OFF &EQBUS &APGATE &SAMP_ON &BH &BL &MIDH &MIDL} @REMOVE-FROM $PORT_FILL_SET;
// &VSS @ADD-TO $GROUND_NET_SET;
// &VREFN @ADD-TO $GROUND_NET_SET;
// #XHCTL @PLACE(0, 20) => @ORIENT("R0");
// #XDH @PLACE(22, 18) => @ORIENT("R0");
// &HHIB @WIRE {#XHCTL:2 #XDH:1};
// #MSH @PLACE(45, 7) => @ORIENT("R0");
// #MSH @SET-SYMBOL $NMOS;
// #MSH @TEXT("ULVT 0.665u", key="model", size=1.05, dx=1.5, dy=-1);
// #MSH @TEXT("MSH", key="name", size=1.1, dx=1.5, dy=1);
// %j1 = (45, 20);
// &BH @WIRE {#XDH:4 %j1};
// &BH @WIRE {%j1 #MSH:1};
// #MEQ1 @PLACE(66, 7) => @ORIENT("MX");
// #MEQ1 @SET-SYMBOL $PMOS;
// #MEQ1 @TEXT("ULVT 0.665u", key="model", size=1.05, dx=1.5, dy=-1);
// #MEQ1 @TEXT("MEQ1", key="name", size=1.1, dx=1.5, dy=1);
// %j2 = (66, 20);
// &BH @WIRE {%j1 %j2};
// &BH @WIRE {%j2 #MEQ1:1};
// #MSHAREH @PLACE(87, 7) => @ORIENT("R0");
// #MSHAREH @SET-SYMBOL $NMOS;
// #MSHAREH @TEXT("ULVT 0.665u", key="model", size=1.05, dx=1.5, dy=-1);
// #MSHAREH @TEXT("MSHAREH", key="name", size=1.1, dx=1.5, dy=1);
// %j3 = (87, 20);
// &BH @WIRE {%j2 %j3};
// &BH @WIRE {%j3 #MSHAREH:1};
// &BH @WIRE {%j3 (105, 20)};
// (105, 22) @TEXT("BH", size=1.3);
// #MMIDNH @PLACE(125, 7) => @ORIENT("R0");
// #MMIDNH @SET-SYMBOL $NMOS;
// #MMIDNH @TEXT("ULVT 0.12u", key="model", size=1.05, dx=1.5, dy=-1);
// #MMIDNH @TEXT("MMIDNH", key="name", size=1.1, dx=1.5, dy=1);
// #MMIDPH @PLACE(147, 7) => @ORIENT("MX");
// #MMIDPH @SET-SYMBOL $PMOS;
// #MMIDPH @TEXT("SVT 0.12u", key="model", size=1.05, dx=1.5, dy=-1);
// #MMIDPH @TEXT("MMIDPH", key="name", size=1.1, dx=1.5, dy=1);
// &MIDH @WIRE {#MMIDNH:1 (125, 20) (147, 20) #MMIDPH:1};
// (128, 22) @TEXT("MIDH", size=1.2);
// (-8, 36) @TEXT("H reference / sampling switches", size=1.2);
// #XLCTL @PLACE(0, -30) => @ORIENT("R0");
// #XDL @PLACE(22, -32) => @ORIENT("R0");
// &LHIB @WIRE {#XLCTL:2 #XDL:1};
// #MSL @PLACE(45, -43) => @ORIENT("R0");
// #MSL @SET-SYMBOL $NMOS;
// #MSL @TEXT("ULVT 0.665u", key="model", size=1.05, dx=1.5, dy=-1);
// #MSL @TEXT("MSL", key="name", size=1.1, dx=1.5, dy=1);
// %j4 = (45, -30);
// &BL @WIRE {#XDL:4 %j4};
// &BL @WIRE {%j4 #MSL:1};
// #MEQ2 @PLACE(66, -43) => @ORIENT("MX");
// #MEQ2 @SET-SYMBOL $PMOS;
// #MEQ2 @TEXT("ULVT 0.665u", key="model", size=1.05, dx=1.5, dy=-1);
// #MEQ2 @TEXT("MEQ2", key="name", size=1.1, dx=1.5, dy=1);
// %j5 = (66, -30);
// &BL @WIRE {%j4 %j5};
// &BL @WIRE {%j5 #MEQ2:1};
// #MSHAREL @PLACE(87, -43) => @ORIENT("R0");
// #MSHAREL @SET-SYMBOL $NMOS;
// #MSHAREL @TEXT("ULVT 0.665u", key="model", size=1.05, dx=1.5, dy=-1);
// #MSHAREL @TEXT("MSHAREL", key="name", size=1.1, dx=1.5, dy=1);
// %j6 = (87, -30);
// &BL @WIRE {%j5 %j6};
// &BL @WIRE {%j6 #MSHAREL:1};
// &BL @WIRE {%j6 (105, -30)};
// (105, -28) @TEXT("BL", size=1.3);
// #MMIDNL @PLACE(125, -43) => @ORIENT("R0");
// #MMIDNL @SET-SYMBOL $NMOS;
// #MMIDNL @TEXT("ULVT 0.12u", key="model", size=1.05, dx=1.5, dy=-1);
// #MMIDNL @TEXT("MMIDNL", key="name", size=1.1, dx=1.5, dy=1);
// #MMIDPL @PLACE(147, -43) => @ORIENT("MX");
// #MMIDPL @SET-SYMBOL $PMOS;
// #MMIDPL @TEXT("SVT 0.12u", key="model", size=1.05, dx=1.5, dy=-1);
// #MMIDPL @TEXT("MMIDPL", key="name", size=1.1, dx=1.5, dy=1);
// &MIDL @WIRE {#MMIDNL:1 (125, -30) (147, -30) #MMIDPL:1};
// (128, -28) @TEXT("MIDL", size=1.2);
// (-8, -14) @TEXT("L reference / sampling switches", size=1.2);
// (-8, -56) @TEXT("Capacitors and 5% Cp are in sibling XCAP.", size=1.3);
// (-8, -60) @TEXT("N bulk = VSS; P assist / MID bulk = VREFP. L = 30 nm.", size=1.1);
// &DH @WIRE {#XHCTL:1 (-6, 20)};
// (-6.3, 20) @TEXT("DH", size=1.05, halign="end", valign="middle");
// &EN @WIRE {#XDH:2 (12, 16)};
// (11.7, 16) @TEXT("EN", size=1.05, halign="end", valign="middle");
// &ENB @WIRE {#XDH:3 (12, 13)};
// (11.7, 13) @TEXT("ENB", size=1.05, halign="end", valign="middle");
// %t10 = $SUPPLY @ATTACH &VREFP => @PLACE(25, 29);
// &VREFP @WIRE {#XDH:5 %t10:p};
// %t11 = $GROUND @ATTACH &VREFN => @PLACE(25, 7);
// &VREFN @WIRE {#XDH:6 %t11:p};
// %t12 = $GROUND @ATTACH &VSS => @PLACE(19, 7);
// &VSS @WIRE {#XDH:7 %t12:p};
// %t13 = $SUPPLY @ATTACH &DVDD => @PLACE(19, 29);
// &DVDD @WIRE {#XDH:8 %t13:p};
// &VG @WIRE {#MSH:2 (40, 7)};
// (39.7, 7) @TEXT("VG", size=1.05, halign="end", valign="middle");
// &VIN @WIRE {#MSH:3 (45, 3)};
// (45, 2.4) @TEXT("VIN", size=1.05, halign="middle", valign="top");
// &APGATE @WIRE {#MEQ1:2 (61, 7)};
// (60.7, 7) @TEXT("APGATE", size=1.05, halign="end", valign="middle");
// &VIN @WIRE {#MEQ1:3 (66, 3)};
// (66, 2.4) @TEXT("VIN", size=1.05, halign="middle", valign="top");
// &SAMP_ON @WIRE {#MSHAREH:2 (82, 7)};
// (81.7, 7) @TEXT("SAMP_ON", size=1.05, halign="end", valign="middle");
// &EQBUS @WIRE {#MSHAREH:3 (87, 3)};
// (87, 2.4) @TEXT("EQBUS", size=1.05, halign="middle", valign="top");
// &PHI_S @WIRE {#MMIDNH:2 (120, 7)};
// (119.7, 7) @TEXT("PHI_S", size=1.05, halign="end", valign="middle");
// &VIN @WIRE {#MMIDNH:3 (125, 3)};
// (125, 2.4) @TEXT("VIN", size=1.05, halign="middle", valign="top");
// &AP_OFF @WIRE {#MMIDPH:2 (142, 7)};
// (141.7, 7) @TEXT("AP_OFF", size=1.05, halign="end", valign="middle");
// &VIN @WIRE {#MMIDPH:3 (147, 3)};
// (147, 2.4) @TEXT("VIN", size=1.05, halign="middle", valign="top");
// &RL @WIRE {#XLCTL:1 (-6, -30)};
// (-6.3, -30) @TEXT("RL", size=1.05, halign="end", valign="middle");
// &EN @WIRE {#XDL:2 (12, -34)};
// (11.7, -34) @TEXT("EN", size=1.05, halign="end", valign="middle");
// &ENB @WIRE {#XDL:3 (12, -37)};
// (11.7, -37) @TEXT("ENB", size=1.05, halign="end", valign="middle");
// %t27 = $SUPPLY @ATTACH &VREFP => @PLACE(25, -21);
// &VREFP @WIRE {#XDL:5 %t27:p};
// %t28 = $GROUND @ATTACH &VREFN => @PLACE(25, -43);
// &VREFN @WIRE {#XDL:6 %t28:p};
// %t29 = $GROUND @ATTACH &VSS => @PLACE(19, -43);
// &VSS @WIRE {#XDL:7 %t29:p};
// %t30 = $SUPPLY @ATTACH &DVDD => @PLACE(19, -21);
// &DVDD @WIRE {#XDL:8 %t30:p};
// &VG @WIRE {#MSL:2 (40, -43)};
// (39.7, -43) @TEXT("VG", size=1.05, halign="end", valign="middle");
// &VIN @WIRE {#MSL:3 (45, -47)};
// (45, -47.6) @TEXT("VIN", size=1.05, halign="middle", valign="top");
// &APGATE @WIRE {#MEQ2:2 (61, -43)};
// (60.7, -43) @TEXT("APGATE", size=1.05, halign="end", valign="middle");
// &VIN @WIRE {#MEQ2:3 (66, -47)};
// (66, -47.6) @TEXT("VIN", size=1.05, halign="middle", valign="top");
// &SAMP_ON @WIRE {#MSHAREL:2 (82, -43)};
// (81.7, -43) @TEXT("SAMP_ON", size=1.05, halign="end", valign="middle");
// &EQBUS @WIRE {#MSHAREL:3 (87, -47)};
// (87, -47.6) @TEXT("EQBUS", size=1.05, halign="middle", valign="top");
// &PHI_S @WIRE {#MMIDNL:2 (120, -43)};
// (119.7, -43) @TEXT("PHI_S", size=1.05, halign="end", valign="middle");
// &VIN @WIRE {#MMIDNL:3 (125, -47)};
// (125, -47.6) @TEXT("VIN", size=1.05, halign="middle", valign="top");
// &AP_OFF @WIRE {#MMIDPL:2 (142, -43)};
// (141.7, -43) @TEXT("AP_OFF", size=1.05, halign="end", valign="middle");
// &VIN @WIRE {#MMIDPL:3 (147, -47)};
// (147, -47.6) @TEXT("VIN", size=1.05, halign="middle", valign="top");
// $JUNCTION @ATTACH %j1;
// $JUNCTION @ATTACH %j2;
// $JUNCTION @ATTACH %j3;
// $JUNCTION @ATTACH %j4;
// $JUNCTION @ATTACH %j5;
// $JUNCTION @ATTACH %j6;
// (-8, 48) @TEXT("V29 / WIP | bit 7 switches | no MOM capacitors", size=1.4, bold=true, textcolor="#17365d");
// }
ends mq_cdac_sw7
subckt mq_cdac_sw6 (DH RL EN ENB VREFP VREFN VSS DVDD BH BL)
XHCTL (DH HHIB DVDD VREFN VSS) mq_cdac_ctl_h
XLCTL (RL LHIB DVDD VREFN VSS) mq_cdac_ctl_l
XDH (HHIB EN ENB BH VREFP VREFN VSS DVDD) mq_cdac_drv6
XDL (LHIB EN ENB BL VREFP VREFN VSS DVDD) mq_cdac_drv6
// @RNL {
// {&DH &RL &EN &ENB &VREFP &VREFN &VSS &DVDD &BH &BL} @REMOVE-FROM $PORT_FILL_SET;
// &VSS @ADD-TO $GROUND_NET_SET;
// &VREFN @ADD-TO $GROUND_NET_SET;
// #XHCTL @PLACE(0, 20) => @ORIENT("R0");
// #XDH @PLACE(22, 18) => @ORIENT("R0");
// &HHIB @WIRE {#XHCTL:2 #XDH:1};
// &BH @WIRE {#XDH:4 (105, 20)};
// (105, 22) @TEXT("BH", size=1.3);
// (-8, 36) @TEXT("H reference / sampling switches", size=1.2);
// #XLCTL @PLACE(0, -30) => @ORIENT("R0");
// #XDL @PLACE(22, -32) => @ORIENT("R0");
// &LHIB @WIRE {#XLCTL:2 #XDL:1};
// &BL @WIRE {#XDL:4 (105, -30)};
// (105, -28) @TEXT("BL", size=1.3);
// (-8, -14) @TEXT("L reference / sampling switches", size=1.2);
// (-8, -56) @TEXT("Capacitors and 5% Cp are in sibling XCAP.", size=1.3);
// (-8, -60) @TEXT("N bulk = VSS; P assist / MID bulk = VREFP. L = 30 nm.", size=1.1);
// &DH @WIRE {#XHCTL:1 (-6, 20)};
// (-6.3, 20) @TEXT("DH", size=1.05, halign="end", valign="middle");
// &EN @WIRE {#XDH:2 (12, 16)};
// (11.7, 16) @TEXT("EN", size=1.05, halign="end", valign="middle");
// &ENB @WIRE {#XDH:3 (12, 13)};
// (11.7, 13) @TEXT("ENB", size=1.05, halign="end", valign="middle");
// %t4 = $SUPPLY @ATTACH &VREFP => @PLACE(25, 29);
// &VREFP @WIRE {#XDH:5 %t4:p};
// %t5 = $GROUND @ATTACH &VREFN => @PLACE(25, 7);
// &VREFN @WIRE {#XDH:6 %t5:p};
// %t6 = $GROUND @ATTACH &VSS => @PLACE(19, 7);
// &VSS @WIRE {#XDH:7 %t6:p};
// %t7 = $SUPPLY @ATTACH &DVDD => @PLACE(19, 29);
// &DVDD @WIRE {#XDH:8 %t7:p};
// &RL @WIRE {#XLCTL:1 (-6, -30)};
// (-6.3, -30) @TEXT("RL", size=1.05, halign="end", valign="middle");
// &EN @WIRE {#XDL:2 (12, -34)};
// (11.7, -34) @TEXT("EN", size=1.05, halign="end", valign="middle");
// &ENB @WIRE {#XDL:3 (12, -37)};
// (11.7, -37) @TEXT("ENB", size=1.05, halign="end", valign="middle");
// %t11 = $SUPPLY @ATTACH &VREFP => @PLACE(25, -21);
// &VREFP @WIRE {#XDL:5 %t11:p};
// %t12 = $GROUND @ATTACH &VREFN => @PLACE(25, -43);
// &VREFN @WIRE {#XDL:6 %t12:p};
// %t13 = $GROUND @ATTACH &VSS => @PLACE(19, -43);
// &VSS @WIRE {#XDL:7 %t13:p};
// %t14 = $SUPPLY @ATTACH &DVDD => @PLACE(19, -21);
// &DVDD @WIRE {#XDL:8 %t14:p};
// (-8, 48) @TEXT("V29 / WIP | bit 6 switches | no MOM capacitors", size=1.4, bold=true, textcolor="#17365d");
// }
ends mq_cdac_sw6
subckt mq_cdac_sw5 (VIN VG DH RL EN ENB VREFP VREFN VSS DVDD EQBUS APGATE SAMP_ON BH BL)
XHCTL (DH HHIB DVDD VREFN VSS) mq_cdac_ctl_h
XLCTL (RL LHIB DVDD VREFN VSS) mq_cdac_ctl_l
XDH (HHIB EN ENB BH VREFP VREFN VSS DVDD) mq_cdac_drv5
MSH (BH VG VIN VSS) nch_ulvt_mac w=2.1e-07 l=3e-08 nf=1
XDL (LHIB EN ENB BL VREFP VREFN VSS DVDD) mq_cdac_drv5
MSL (BL VG VIN VSS) nch_ulvt_mac w=2.1e-07 l=3e-08 nf=1
MEQ1 (BH APGATE VIN VREFP) pch_ulvt_mac w=2.1e-07 l=3e-08 nf=1
MEQ2 (BL APGATE VIN VREFP) pch_ulvt_mac w=2.1e-07 l=3e-08 nf=1
MSHAREH (BH SAMP_ON EQBUS VSS) nch_ulvt_mac w=2.1e-07 l=3e-08 nf=1
MSHAREL (BL SAMP_ON EQBUS VSS) nch_ulvt_mac w=2.1e-07 l=3e-08 nf=1
// @RNL {
// {&VIN &VG &DH &RL &EN &ENB &VREFP &VREFN &VSS &DVDD &EQBUS &APGATE &SAMP_ON &BH &BL} @REMOVE-FROM $PORT_FILL_SET;
// &VSS @ADD-TO $GROUND_NET_SET;
// &VREFN @ADD-TO $GROUND_NET_SET;
// #XHCTL @PLACE(0, 20) => @ORIENT("R0");
// #XDH @PLACE(22, 18) => @ORIENT("R0");
// &HHIB @WIRE {#XHCTL:2 #XDH:1};
// #MSH @PLACE(45, 7) => @ORIENT("R0");
// #MSH @SET-SYMBOL $NMOS;
// #MSH @TEXT("ULVT 0.21u", key="model", size=1.05, dx=1.5, dy=-1);
// #MSH @TEXT("MSH", key="name", size=1.1, dx=1.5, dy=1);
// %j1 = (45, 20);
// &BH @WIRE {#XDH:4 %j1};
// &BH @WIRE {%j1 #MSH:1};
// #MEQ1 @PLACE(66, 7) => @ORIENT("MX");
// #MEQ1 @SET-SYMBOL $PMOS;
// #MEQ1 @TEXT("ULVT 0.21u", key="model", size=1.05, dx=1.5, dy=-1);
// #MEQ1 @TEXT("MEQ1", key="name", size=1.1, dx=1.5, dy=1);
// %j2 = (66, 20);
// &BH @WIRE {%j1 %j2};
// &BH @WIRE {%j2 #MEQ1:1};
// #MSHAREH @PLACE(87, 7) => @ORIENT("R0");
// #MSHAREH @SET-SYMBOL $NMOS;
// #MSHAREH @TEXT("ULVT 0.21u", key="model", size=1.05, dx=1.5, dy=-1);
// #MSHAREH @TEXT("MSHAREH", key="name", size=1.1, dx=1.5, dy=1);
// %j3 = (87, 20);
// &BH @WIRE {%j2 %j3};
// &BH @WIRE {%j3 #MSHAREH:1};
// &BH @WIRE {%j3 (105, 20)};
// (105, 22) @TEXT("BH", size=1.3);
// (-8, 36) @TEXT("H reference / sampling switches", size=1.2);
// #XLCTL @PLACE(0, -30) => @ORIENT("R0");
// #XDL @PLACE(22, -32) => @ORIENT("R0");
// &LHIB @WIRE {#XLCTL:2 #XDL:1};
// #MSL @PLACE(45, -43) => @ORIENT("R0");
// #MSL @SET-SYMBOL $NMOS;
// #MSL @TEXT("ULVT 0.21u", key="model", size=1.05, dx=1.5, dy=-1);
// #MSL @TEXT("MSL", key="name", size=1.1, dx=1.5, dy=1);
// %j4 = (45, -30);
// &BL @WIRE {#XDL:4 %j4};
// &BL @WIRE {%j4 #MSL:1};
// #MEQ2 @PLACE(66, -43) => @ORIENT("MX");
// #MEQ2 @SET-SYMBOL $PMOS;
// #MEQ2 @TEXT("ULVT 0.21u", key="model", size=1.05, dx=1.5, dy=-1);
// #MEQ2 @TEXT("MEQ2", key="name", size=1.1, dx=1.5, dy=1);
// %j5 = (66, -30);
// &BL @WIRE {%j4 %j5};
// &BL @WIRE {%j5 #MEQ2:1};
// #MSHAREL @PLACE(87, -43) => @ORIENT("R0");
// #MSHAREL @SET-SYMBOL $NMOS;
// #MSHAREL @TEXT("ULVT 0.21u", key="model", size=1.05, dx=1.5, dy=-1);
// #MSHAREL @TEXT("MSHAREL", key="name", size=1.1, dx=1.5, dy=1);
// %j6 = (87, -30);
// &BL @WIRE {%j5 %j6};
// &BL @WIRE {%j6 #MSHAREL:1};
// &BL @WIRE {%j6 (105, -30)};
// (105, -28) @TEXT("BL", size=1.3);
// (-8, -14) @TEXT("L reference / sampling switches", size=1.2);
// (-8, -56) @TEXT("Capacitors and 5% Cp are in sibling XCAP.", size=1.3);
// (-8, -60) @TEXT("N bulk = VSS; P assist / MID bulk = VREFP. L = 30 nm.", size=1.1);
// &DH @WIRE {#XHCTL:1 (-6, 20)};
// (-6.3, 20) @TEXT("DH", size=1.05, halign="end", valign="middle");
// &EN @WIRE {#XDH:2 (12, 16)};
// (11.7, 16) @TEXT("EN", size=1.05, halign="end", valign="middle");
// &ENB @WIRE {#XDH:3 (12, 13)};
// (11.7, 13) @TEXT("ENB", size=1.05, halign="end", valign="middle");
// %t10 = $SUPPLY @ATTACH &VREFP => @PLACE(25, 29);
// &VREFP @WIRE {#XDH:5 %t10:p};
// %t11 = $GROUND @ATTACH &VREFN => @PLACE(25, 7);
// &VREFN @WIRE {#XDH:6 %t11:p};
// %t12 = $GROUND @ATTACH &VSS => @PLACE(19, 7);
// &VSS @WIRE {#XDH:7 %t12:p};
// %t13 = $SUPPLY @ATTACH &DVDD => @PLACE(19, 29);
// &DVDD @WIRE {#XDH:8 %t13:p};
// &VG @WIRE {#MSH:2 (40, 7)};
// (39.7, 7) @TEXT("VG", size=1.05, halign="end", valign="middle");
// &VIN @WIRE {#MSH:3 (45, 3)};
// (45, 2.4) @TEXT("VIN", size=1.05, halign="middle", valign="top");
// &APGATE @WIRE {#MEQ1:2 (61, 7)};
// (60.7, 7) @TEXT("APGATE", size=1.05, halign="end", valign="middle");
// &VIN @WIRE {#MEQ1:3 (66, 3)};
// (66, 2.4) @TEXT("VIN", size=1.05, halign="middle", valign="top");
// &SAMP_ON @WIRE {#MSHAREH:2 (82, 7)};
// (81.7, 7) @TEXT("SAMP_ON", size=1.05, halign="end", valign="middle");
// &EQBUS @WIRE {#MSHAREH:3 (87, 3)};
// (87, 2.4) @TEXT("EQBUS", size=1.05, halign="middle", valign="top");
// &RL @WIRE {#XLCTL:1 (-6, -30)};
// (-6.3, -30) @TEXT("RL", size=1.05, halign="end", valign="middle");
// &EN @WIRE {#XDL:2 (12, -34)};
// (11.7, -34) @TEXT("EN", size=1.05, halign="end", valign="middle");
// &ENB @WIRE {#XDL:3 (12, -37)};
// (11.7, -37) @TEXT("ENB", size=1.05, halign="end", valign="middle");
// %t23 = $SUPPLY @ATTACH &VREFP => @PLACE(25, -21);
// &VREFP @WIRE {#XDL:5 %t23:p};
// %t24 = $GROUND @ATTACH &VREFN => @PLACE(25, -43);
// &VREFN @WIRE {#XDL:6 %t24:p};
// %t25 = $GROUND @ATTACH &VSS => @PLACE(19, -43);
// &VSS @WIRE {#XDL:7 %t25:p};
// %t26 = $SUPPLY @ATTACH &DVDD => @PLACE(19, -21);
// &DVDD @WIRE {#XDL:8 %t26:p};
// &VG @WIRE {#MSL:2 (40, -43)};
// (39.7, -43) @TEXT("VG", size=1.05, halign="end", valign="middle");
// &VIN @WIRE {#MSL:3 (45, -47)};
// (45, -47.6) @TEXT("VIN", size=1.05, halign="middle", valign="top");
// &APGATE @WIRE {#MEQ2:2 (61, -43)};
// (60.7, -43) @TEXT("APGATE", size=1.05, halign="end", valign="middle");
// &VIN @WIRE {#MEQ2:3 (66, -47)};
// (66, -47.6) @TEXT("VIN", size=1.05, halign="middle", valign="top");
// &SAMP_ON @WIRE {#MSHAREL:2 (82, -43)};
// (81.7, -43) @TEXT("SAMP_ON", size=1.05, halign="end", valign="middle");
// &EQBUS @WIRE {#MSHAREL:3 (87, -47)};
// (87, -47.6) @TEXT("EQBUS", size=1.05, halign="middle", valign="top");
// $JUNCTION @ATTACH %j1;
// $JUNCTION @ATTACH %j2;
// $JUNCTION @ATTACH %j3;
// $JUNCTION @ATTACH %j4;
// $JUNCTION @ATTACH %j5;
// $JUNCTION @ATTACH %j6;
// (-8, 48) @TEXT("V29 / WIP | bit 5 switches | no MOM capacitors", size=1.4, bold=true, textcolor="#17365d");
// }
ends mq_cdac_sw5
subckt mq_cdac_sw4 (VIN VG DH RL EN ENB VREFP VREFN VSS DVDD EQBUS APGATE SAMP_ON BH BL)
XHCTL (DH HHIB DVDD VREFN VSS) mq_cdac_ctl_h
XLCTL (RL LHIB DVDD VREFN VSS) mq_cdac_ctl_l
XDH (HHIB EN ENB BH VREFP VREFN VSS DVDD) mq_cdac_drv4
MSH (BH VG VIN VSS) nch_ulvt_mac w=1.2e-07 l=3e-08 nf=1
XDL (LHIB EN ENB BL VREFP VREFN VSS DVDD) mq_cdac_drv4
MSL (BL VG VIN VSS) nch_ulvt_mac w=1.2e-07 l=3e-08 nf=1
MEQ1 (BH APGATE VIN VREFP) pch_ulvt_mac w=1.2e-07 l=3e-08 nf=1
MEQ2 (BL APGATE VIN VREFP) pch_ulvt_mac w=1.2e-07 l=3e-08 nf=1
MSHAREH (BH SAMP_ON EQBUS VSS) nch_ulvt_mac w=1.2e-07 l=3e-08 nf=1
MSHAREL (BL SAMP_ON EQBUS VSS) nch_ulvt_mac w=1.2e-07 l=3e-08 nf=1
// @RNL {
// {&VIN &VG &DH &RL &EN &ENB &VREFP &VREFN &VSS &DVDD &EQBUS &APGATE &SAMP_ON &BH &BL} @REMOVE-FROM $PORT_FILL_SET;
// &VSS @ADD-TO $GROUND_NET_SET;
// &VREFN @ADD-TO $GROUND_NET_SET;
// #XHCTL @PLACE(0, 20) => @ORIENT("R0");
// #XDH @PLACE(22, 18) => @ORIENT("R0");
// &HHIB @WIRE {#XHCTL:2 #XDH:1};
// #MSH @PLACE(45, 7) => @ORIENT("R0");
// #MSH @SET-SYMBOL $NMOS;
// #MSH @TEXT("ULVT 0.12u", key="model", size=1.05, dx=1.5, dy=-1);
// #MSH @TEXT("MSH", key="name", size=1.1, dx=1.5, dy=1);
// %j1 = (45, 20);
// &BH @WIRE {#XDH:4 %j1};
// &BH @WIRE {%j1 #MSH:1};
// #MEQ1 @PLACE(66, 7) => @ORIENT("MX");
// #MEQ1 @SET-SYMBOL $PMOS;
// #MEQ1 @TEXT("ULVT 0.12u", key="model", size=1.05, dx=1.5, dy=-1);
// #MEQ1 @TEXT("MEQ1", key="name", size=1.1, dx=1.5, dy=1);
// %j2 = (66, 20);
// &BH @WIRE {%j1 %j2};
// &BH @WIRE {%j2 #MEQ1:1};
// #MSHAREH @PLACE(87, 7) => @ORIENT("R0");
// #MSHAREH @SET-SYMBOL $NMOS;
// #MSHAREH @TEXT("ULVT 0.12u", key="model", size=1.05, dx=1.5, dy=-1);
// #MSHAREH @TEXT("MSHAREH", key="name", size=1.1, dx=1.5, dy=1);
// %j3 = (87, 20);
// &BH @WIRE {%j2 %j3};
// &BH @WIRE {%j3 #MSHAREH:1};
// &BH @WIRE {%j3 (105, 20)};
// (105, 22) @TEXT("BH", size=1.3);
// (-8, 36) @TEXT("H reference / sampling switches", size=1.2);
// #XLCTL @PLACE(0, -30) => @ORIENT("R0");
// #XDL @PLACE(22, -32) => @ORIENT("R0");
// &LHIB @WIRE {#XLCTL:2 #XDL:1};
// #MSL @PLACE(45, -43) => @ORIENT("R0");
// #MSL @SET-SYMBOL $NMOS;
// #MSL @TEXT("ULVT 0.12u", key="model", size=1.05, dx=1.5, dy=-1);
// #MSL @TEXT("MSL", key="name", size=1.1, dx=1.5, dy=1);
// %j4 = (45, -30);
// &BL @WIRE {#XDL:4 %j4};
// &BL @WIRE {%j4 #MSL:1};
// #MEQ2 @PLACE(66, -43) => @ORIENT("MX");
// #MEQ2 @SET-SYMBOL $PMOS;
// #MEQ2 @TEXT("ULVT 0.12u", key="model", size=1.05, dx=1.5, dy=-1);
// #MEQ2 @TEXT("MEQ2", key="name", size=1.1, dx=1.5, dy=1);
// %j5 = (66, -30);
// &BL @WIRE {%j4 %j5};
// &BL @WIRE {%j5 #MEQ2:1};
// #MSHAREL @PLACE(87, -43) => @ORIENT("R0");
// #MSHAREL @SET-SYMBOL $NMOS;
// #MSHAREL @TEXT("ULVT 0.12u", key="model", size=1.05, dx=1.5, dy=-1);
// #MSHAREL @TEXT("MSHAREL", key="name", size=1.1, dx=1.5, dy=1);
// %j6 = (87, -30);
// &BL @WIRE {%j5 %j6};
// &BL @WIRE {%j6 #MSHAREL:1};
// &BL @WIRE {%j6 (105, -30)};
// (105, -28) @TEXT("BL", size=1.3);
// (-8, -14) @TEXT("L reference / sampling switches", size=1.2);
// (-8, -56) @TEXT("Capacitors and 5% Cp are in sibling XCAP.", size=1.3);
// (-8, -60) @TEXT("N bulk = VSS; P assist / MID bulk = VREFP. L = 30 nm.", size=1.1);
// &DH @WIRE {#XHCTL:1 (-6, 20)};
// (-6.3, 20) @TEXT("DH", size=1.05, halign="end", valign="middle");
// &EN @WIRE {#XDH:2 (12, 16)};
// (11.7, 16) @TEXT("EN", size=1.05, halign="end", valign="middle");
// &ENB @WIRE {#XDH:3 (12, 13)};
// (11.7, 13) @TEXT("ENB", size=1.05, halign="end", valign="middle");
// %t10 = $SUPPLY @ATTACH &VREFP => @PLACE(25, 29);
// &VREFP @WIRE {#XDH:5 %t10:p};
// %t11 = $GROUND @ATTACH &VREFN => @PLACE(25, 7);
// &VREFN @WIRE {#XDH:6 %t11:p};
// %t12 = $GROUND @ATTACH &VSS => @PLACE(19, 7);
// &VSS @WIRE {#XDH:7 %t12:p};
// %t13 = $SUPPLY @ATTACH &DVDD => @PLACE(19, 29);
// &DVDD @WIRE {#XDH:8 %t13:p};
// &VG @WIRE {#MSH:2 (40, 7)};
// (39.7, 7) @TEXT("VG", size=1.05, halign="end", valign="middle");
// &VIN @WIRE {#MSH:3 (45, 3)};
// (45, 2.4) @TEXT("VIN", size=1.05, halign="middle", valign="top");
// &APGATE @WIRE {#MEQ1:2 (61, 7)};
// (60.7, 7) @TEXT("APGATE", size=1.05, halign="end", valign="middle");
// &VIN @WIRE {#MEQ1:3 (66, 3)};
// (66, 2.4) @TEXT("VIN", size=1.05, halign="middle", valign="top");
// &SAMP_ON @WIRE {#MSHAREH:2 (82, 7)};
// (81.7, 7) @TEXT("SAMP_ON", size=1.05, halign="end", valign="middle");
// &EQBUS @WIRE {#MSHAREH:3 (87, 3)};
// (87, 2.4) @TEXT("EQBUS", size=1.05, halign="middle", valign="top");
// &RL @WIRE {#XLCTL:1 (-6, -30)};
// (-6.3, -30) @TEXT("RL", size=1.05, halign="end", valign="middle");
// &EN @WIRE {#XDL:2 (12, -34)};
// (11.7, -34) @TEXT("EN", size=1.05, halign="end", valign="middle");
// &ENB @WIRE {#XDL:3 (12, -37)};
// (11.7, -37) @TEXT("ENB", size=1.05, halign="end", valign="middle");
// %t23 = $SUPPLY @ATTACH &VREFP => @PLACE(25, -21);
// &VREFP @WIRE {#XDL:5 %t23:p};
// %t24 = $GROUND @ATTACH &VREFN => @PLACE(25, -43);
// &VREFN @WIRE {#XDL:6 %t24:p};
// %t25 = $GROUND @ATTACH &VSS => @PLACE(19, -43);
// &VSS @WIRE {#XDL:7 %t25:p};
// %t26 = $SUPPLY @ATTACH &DVDD => @PLACE(19, -21);
// &DVDD @WIRE {#XDL:8 %t26:p};
// &VG @WIRE {#MSL:2 (40, -43)};
// (39.7, -43) @TEXT("VG", size=1.05, halign="end", valign="middle");
// &VIN @WIRE {#MSL:3 (45, -47)};
// (45, -47.6) @TEXT("VIN", size=1.05, halign="middle", valign="top");
// &APGATE @WIRE {#MEQ2:2 (61, -43)};
// (60.7, -43) @TEXT("APGATE", size=1.05, halign="end", valign="middle");
// &VIN @WIRE {#MEQ2:3 (66, -47)};
// (66, -47.6) @TEXT("VIN", size=1.05, halign="middle", valign="top");
// &SAMP_ON @WIRE {#MSHAREL:2 (82, -43)};
// (81.7, -43) @TEXT("SAMP_ON", size=1.05, halign="end", valign="middle");
// &EQBUS @WIRE {#MSHAREL:3 (87, -47)};
// (87, -47.6) @TEXT("EQBUS", size=1.05, halign="middle", valign="top");
// $JUNCTION @ATTACH %j1;
// $JUNCTION @ATTACH %j2;
// $JUNCTION @ATTACH %j3;
// $JUNCTION @ATTACH %j4;
// $JUNCTION @ATTACH %j5;
// $JUNCTION @ATTACH %j6;
// (-8, 48) @TEXT("V29 / WIP | bit 4 switches | no MOM capacitors", size=1.4, bold=true, textcolor="#17365d");
// }
ends mq_cdac_sw4
subckt mq_cdac_sw3 (VIN VG DH RL EN ENB VREFP VREFN VSS DVDD EQBUS APGATE SAMP_ON BH BL)
XHCTL (DH HHIB DVDD VREFN VSS) mq_cdac_ctl_h
XLCTL (RL LHIB DVDD VREFN VSS) mq_cdac_ctl_l
XDH (HHIB EN ENB BH VREFP VREFN VSS DVDD) mq_cdac_drv3
MSH (BH VG VIN VSS) nch_ulvt_mac w=1.2e-07 l=3e-08 nf=1
XDL (LHIB EN ENB BL VREFP VREFN VSS DVDD) mq_cdac_drv3
MSL (BL VG VIN VSS) nch_ulvt_mac w=1.2e-07 l=3e-08 nf=1
MEQ1 (BH APGATE VIN VREFP) pch_ulvt_mac w=1.2e-07 l=3e-08 nf=1
MEQ2 (BL APGATE VIN VREFP) pch_ulvt_mac w=1.2e-07 l=3e-08 nf=1
MSHAREH (BH SAMP_ON EQBUS VSS) nch_ulvt_mac w=1.2e-07 l=3e-08 nf=1
MSHAREL (BL SAMP_ON EQBUS VSS) nch_ulvt_mac w=1.2e-07 l=3e-08 nf=1
// @RNL {
// {&VIN &VG &DH &RL &EN &ENB &VREFP &VREFN &VSS &DVDD &EQBUS &APGATE &SAMP_ON &BH &BL} @REMOVE-FROM $PORT_FILL_SET;
// &VSS @ADD-TO $GROUND_NET_SET;
// &VREFN @ADD-TO $GROUND_NET_SET;
// #XHCTL @PLACE(0, 20) => @ORIENT("R0");
// #XDH @PLACE(22, 18) => @ORIENT("R0");
// &HHIB @WIRE {#XHCTL:2 #XDH:1};
// #MSH @PLACE(45, 7) => @ORIENT("R0");
// #MSH @SET-SYMBOL $NMOS;
// #MSH @TEXT("ULVT 0.12u", key="model", size=1.05, dx=1.5, dy=-1);
// #MSH @TEXT("MSH", key="name", size=1.1, dx=1.5, dy=1);
// %j1 = (45, 20);
// &BH @WIRE {#XDH:4 %j1};
// &BH @WIRE {%j1 #MSH:1};
// #MEQ1 @PLACE(66, 7) => @ORIENT("MX");
// #MEQ1 @SET-SYMBOL $PMOS;
// #MEQ1 @TEXT("ULVT 0.12u", key="model", size=1.05, dx=1.5, dy=-1);
// #MEQ1 @TEXT("MEQ1", key="name", size=1.1, dx=1.5, dy=1);
// %j2 = (66, 20);
// &BH @WIRE {%j1 %j2};
// &BH @WIRE {%j2 #MEQ1:1};
// #MSHAREH @PLACE(87, 7) => @ORIENT("R0");
// #MSHAREH @SET-SYMBOL $NMOS;
// #MSHAREH @TEXT("ULVT 0.12u", key="model", size=1.05, dx=1.5, dy=-1);
// #MSHAREH @TEXT("MSHAREH", key="name", size=1.1, dx=1.5, dy=1);
// %j3 = (87, 20);
// &BH @WIRE {%j2 %j3};
// &BH @WIRE {%j3 #MSHAREH:1};
// &BH @WIRE {%j3 (105, 20)};
// (105, 22) @TEXT("BH", size=1.3);
// (-8, 36) @TEXT("H reference / sampling switches", size=1.2);
// #XLCTL @PLACE(0, -30) => @ORIENT("R0");
// #XDL @PLACE(22, -32) => @ORIENT("R0");
// &LHIB @WIRE {#XLCTL:2 #XDL:1};
// #MSL @PLACE(45, -43) => @ORIENT("R0");
// #MSL @SET-SYMBOL $NMOS;
// #MSL @TEXT("ULVT 0.12u", key="model", size=1.05, dx=1.5, dy=-1);
// #MSL @TEXT("MSL", key="name", size=1.1, dx=1.5, dy=1);
// %j4 = (45, -30);
// &BL @WIRE {#XDL:4 %j4};
// &BL @WIRE {%j4 #MSL:1};
// #MEQ2 @PLACE(66, -43) => @ORIENT("MX");
// #MEQ2 @SET-SYMBOL $PMOS;
// #MEQ2 @TEXT("ULVT 0.12u", key="model", size=1.05, dx=1.5, dy=-1);
// #MEQ2 @TEXT("MEQ2", key="name", size=1.1, dx=1.5, dy=1);
// %j5 = (66, -30);
// &BL @WIRE {%j4 %j5};
// &BL @WIRE {%j5 #MEQ2:1};
// #MSHAREL @PLACE(87, -43) => @ORIENT("R0");
// #MSHAREL @SET-SYMBOL $NMOS;
// #MSHAREL @TEXT("ULVT 0.12u", key="model", size=1.05, dx=1.5, dy=-1);
// #MSHAREL @TEXT("MSHAREL", key="name", size=1.1, dx=1.5, dy=1);
// %j6 = (87, -30);
// &BL @WIRE {%j5 %j6};
// &BL @WIRE {%j6 #MSHAREL:1};
// &BL @WIRE {%j6 (105, -30)};
// (105, -28) @TEXT("BL", size=1.3);
// (-8, -14) @TEXT("L reference / sampling switches", size=1.2);
// (-8, -56) @TEXT("Capacitors and 5% Cp are in sibling XCAP.", size=1.3);
// (-8, -60) @TEXT("N bulk = VSS; P assist / MID bulk = VREFP. L = 30 nm.", size=1.1);
// &DH @WIRE {#XHCTL:1 (-6, 20)};
// (-6.3, 20) @TEXT("DH", size=1.05, halign="end", valign="middle");
// &EN @WIRE {#XDH:2 (12, 16)};
// (11.7, 16) @TEXT("EN", size=1.05, halign="end", valign="middle");
// &ENB @WIRE {#XDH:3 (12, 13)};
// (11.7, 13) @TEXT("ENB", size=1.05, halign="end", valign="middle");
// %t10 = $SUPPLY @ATTACH &VREFP => @PLACE(25, 29);
// &VREFP @WIRE {#XDH:5 %t10:p};
// %t11 = $GROUND @ATTACH &VREFN => @PLACE(25, 7);
// &VREFN @WIRE {#XDH:6 %t11:p};
// %t12 = $GROUND @ATTACH &VSS => @PLACE(19, 7);
// &VSS @WIRE {#XDH:7 %t12:p};
// %t13 = $SUPPLY @ATTACH &DVDD => @PLACE(19, 29);
// &DVDD @WIRE {#XDH:8 %t13:p};
// &VG @WIRE {#MSH:2 (40, 7)};
// (39.7, 7) @TEXT("VG", size=1.05, halign="end", valign="middle");
// &VIN @WIRE {#MSH:3 (45, 3)};
// (45, 2.4) @TEXT("VIN", size=1.05, halign="middle", valign="top");
// &APGATE @WIRE {#MEQ1:2 (61, 7)};
// (60.7, 7) @TEXT("APGATE", size=1.05, halign="end", valign="middle");
// &VIN @WIRE {#MEQ1:3 (66, 3)};
// (66, 2.4) @TEXT("VIN", size=1.05, halign="middle", valign="top");
// &SAMP_ON @WIRE {#MSHAREH:2 (82, 7)};
// (81.7, 7) @TEXT("SAMP_ON", size=1.05, halign="end", valign="middle");
// &EQBUS @WIRE {#MSHAREH:3 (87, 3)};
// (87, 2.4) @TEXT("EQBUS", size=1.05, halign="middle", valign="top");
// &RL @WIRE {#XLCTL:1 (-6, -30)};
// (-6.3, -30) @TEXT("RL", size=1.05, halign="end", valign="middle");
// &EN @WIRE {#XDL:2 (12, -34)};
// (11.7, -34) @TEXT("EN", size=1.05, halign="end", valign="middle");
// &ENB @WIRE {#XDL:3 (12, -37)};
// (11.7, -37) @TEXT("ENB", size=1.05, halign="end", valign="middle");
// %t23 = $SUPPLY @ATTACH &VREFP => @PLACE(25, -21);
// &VREFP @WIRE {#XDL:5 %t23:p};
// %t24 = $GROUND @ATTACH &VREFN => @PLACE(25, -43);
// &VREFN @WIRE {#XDL:6 %t24:p};
// %t25 = $GROUND @ATTACH &VSS => @PLACE(19, -43);
// &VSS @WIRE {#XDL:7 %t25:p};
// %t26 = $SUPPLY @ATTACH &DVDD => @PLACE(19, -21);
// &DVDD @WIRE {#XDL:8 %t26:p};
// &VG @WIRE {#MSL:2 (40, -43)};
// (39.7, -43) @TEXT("VG", size=1.05, halign="end", valign="middle");
// &VIN @WIRE {#MSL:3 (45, -47)};
// (45, -47.6) @TEXT("VIN", size=1.05, halign="middle", valign="top");
// &APGATE @WIRE {#MEQ2:2 (61, -43)};
// (60.7, -43) @TEXT("APGATE", size=1.05, halign="end", valign="middle");
// &VIN @WIRE {#MEQ2:3 (66, -47)};
// (66, -47.6) @TEXT("VIN", size=1.05, halign="middle", valign="top");
// &SAMP_ON @WIRE {#MSHAREL:2 (82, -43)};
// (81.7, -43) @TEXT("SAMP_ON", size=1.05, halign="end", valign="middle");
// &EQBUS @WIRE {#MSHAREL:3 (87, -47)};
// (87, -47.6) @TEXT("EQBUS", size=1.05, halign="middle", valign="top");
// $JUNCTION @ATTACH %j1;
// $JUNCTION @ATTACH %j2;
// $JUNCTION @ATTACH %j3;
// $JUNCTION @ATTACH %j4;
// $JUNCTION @ATTACH %j5;
// $JUNCTION @ATTACH %j6;
// (-8, 48) @TEXT("V29 / WIP | bit 3 switches | no MOM capacitors", size=1.4, bold=true, textcolor="#17365d");
// }
ends mq_cdac_sw3
subckt mq_cdac_sw2 (VIN VG DH RL EN ENB VREFP VREFN VSS PHI_S DVDD AP_OFF EQBUS APGATE SAMP_ON BH BL MIDH MIDL)
XHCTL (DH HHIB DVDD VREFN VSS) mq_cdac_ctl_h
XLCTL (RL LHIB DVDD VREFN VSS) mq_cdac_ctl_l
XDH (HHIB EN ENB BH VREFP VREFN VSS DVDD) mq_cdac_drv2
MSH (BH VG VIN VSS) nch_ulvt_mac w=1.2e-07 l=3e-08 nf=1
XDL (LHIB EN ENB BL VREFP VREFN VSS DVDD) mq_cdac_drv2
MSL (BL VG VIN VSS) nch_ulvt_mac w=1.2e-07 l=3e-08 nf=1
MEQ1 (BH APGATE VIN VREFP) pch_ulvt_mac w=1.2e-07 l=3e-08 nf=1
MEQ2 (BL APGATE VIN VREFP) pch_ulvt_mac w=1.2e-07 l=3e-08 nf=1
MMIDNH (MIDH PHI_S VIN VSS) nch_ulvt_mac w=1.2e-07 l=3e-08 nf=1
MMIDPH (MIDH AP_OFF VIN VREFP) pch_mac w=1.2e-07 l=3e-08 nf=1
MMIDNL (MIDL PHI_S VIN VSS) nch_ulvt_mac w=1.2e-07 l=3e-08 nf=1
MMIDPL (MIDL AP_OFF VIN VREFP) pch_mac w=1.2e-07 l=3e-08 nf=1
MSHAREH (BH SAMP_ON EQBUS VSS) nch_ulvt_mac w=1.2e-07 l=3e-08 nf=1
MSHAREL (BL SAMP_ON EQBUS VSS) nch_ulvt_mac w=1.2e-07 l=3e-08 nf=1
// @RNL {
// {&VIN &VG &DH &RL &EN &ENB &VREFP &VREFN &VSS &PHI_S &DVDD &AP_OFF &EQBUS &APGATE &SAMP_ON &BH &BL &MIDH &MIDL} @REMOVE-FROM $PORT_FILL_SET;
// &VSS @ADD-TO $GROUND_NET_SET;
// &VREFN @ADD-TO $GROUND_NET_SET;
// #XHCTL @PLACE(0, 20) => @ORIENT("R0");
// #XDH @PLACE(22, 18) => @ORIENT("R0");
// &HHIB @WIRE {#XHCTL:2 #XDH:1};
// #MSH @PLACE(45, 7) => @ORIENT("R0");
// #MSH @SET-SYMBOL $NMOS;
// #MSH @TEXT("ULVT 0.12u", key="model", size=1.05, dx=1.5, dy=-1);
// #MSH @TEXT("MSH", key="name", size=1.1, dx=1.5, dy=1);
// %j1 = (45, 20);
// &BH @WIRE {#XDH:4 %j1};
// &BH @WIRE {%j1 #MSH:1};
// #MEQ1 @PLACE(66, 7) => @ORIENT("MX");
// #MEQ1 @SET-SYMBOL $PMOS;
// #MEQ1 @TEXT("ULVT 0.12u", key="model", size=1.05, dx=1.5, dy=-1);
// #MEQ1 @TEXT("MEQ1", key="name", size=1.1, dx=1.5, dy=1);
// %j2 = (66, 20);
// &BH @WIRE {%j1 %j2};
// &BH @WIRE {%j2 #MEQ1:1};
// #MSHAREH @PLACE(87, 7) => @ORIENT("R0");
// #MSHAREH @SET-SYMBOL $NMOS;
// #MSHAREH @TEXT("ULVT 0.12u", key="model", size=1.05, dx=1.5, dy=-1);
// #MSHAREH @TEXT("MSHAREH", key="name", size=1.1, dx=1.5, dy=1);
// %j3 = (87, 20);
// &BH @WIRE {%j2 %j3};
// &BH @WIRE {%j3 #MSHAREH:1};
// &BH @WIRE {%j3 (105, 20)};
// (105, 22) @TEXT("BH", size=1.3);
// #MMIDNH @PLACE(125, 7) => @ORIENT("R0");
// #MMIDNH @SET-SYMBOL $NMOS;
// #MMIDNH @TEXT("ULVT 0.12u", key="model", size=1.05, dx=1.5, dy=-1);
// #MMIDNH @TEXT("MMIDNH", key="name", size=1.1, dx=1.5, dy=1);
// #MMIDPH @PLACE(147, 7) => @ORIENT("MX");
// #MMIDPH @SET-SYMBOL $PMOS;
// #MMIDPH @TEXT("SVT 0.12u", key="model", size=1.05, dx=1.5, dy=-1);
// #MMIDPH @TEXT("MMIDPH", key="name", size=1.1, dx=1.5, dy=1);
// &MIDH @WIRE {#MMIDNH:1 (125, 20) (147, 20) #MMIDPH:1};
// (128, 22) @TEXT("MIDH", size=1.2);
// (-8, 36) @TEXT("H reference / sampling switches", size=1.2);
// #XLCTL @PLACE(0, -30) => @ORIENT("R0");
// #XDL @PLACE(22, -32) => @ORIENT("R0");
// &LHIB @WIRE {#XLCTL:2 #XDL:1};
// #MSL @PLACE(45, -43) => @ORIENT("R0");
// #MSL @SET-SYMBOL $NMOS;
// #MSL @TEXT("ULVT 0.12u", key="model", size=1.05, dx=1.5, dy=-1);
// #MSL @TEXT("MSL", key="name", size=1.1, dx=1.5, dy=1);
// %j4 = (45, -30);
// &BL @WIRE {#XDL:4 %j4};
// &BL @WIRE {%j4 #MSL:1};
// #MEQ2 @PLACE(66, -43) => @ORIENT("MX");
// #MEQ2 @SET-SYMBOL $PMOS;
// #MEQ2 @TEXT("ULVT 0.12u", key="model", size=1.05, dx=1.5, dy=-1);
// #MEQ2 @TEXT("MEQ2", key="name", size=1.1, dx=1.5, dy=1);
// %j5 = (66, -30);
// &BL @WIRE {%j4 %j5};
// &BL @WIRE {%j5 #MEQ2:1};
// #MSHAREL @PLACE(87, -43) => @ORIENT("R0");
// #MSHAREL @SET-SYMBOL $NMOS;
// #MSHAREL @TEXT("ULVT 0.12u", key="model", size=1.05, dx=1.5, dy=-1);
// #MSHAREL @TEXT("MSHAREL", key="name", size=1.1, dx=1.5, dy=1);
// %j6 = (87, -30);
// &BL @WIRE {%j5 %j6};
// &BL @WIRE {%j6 #MSHAREL:1};
// &BL @WIRE {%j6 (105, -30)};
// (105, -28) @TEXT("BL", size=1.3);
// #MMIDNL @PLACE(125, -43) => @ORIENT("R0");
// #MMIDNL @SET-SYMBOL $NMOS;
// #MMIDNL @TEXT("ULVT 0.12u", key="model", size=1.05, dx=1.5, dy=-1);
// #MMIDNL @TEXT("MMIDNL", key="name", size=1.1, dx=1.5, dy=1);
// #MMIDPL @PLACE(147, -43) => @ORIENT("MX");
// #MMIDPL @SET-SYMBOL $PMOS;
// #MMIDPL @TEXT("SVT 0.12u", key="model", size=1.05, dx=1.5, dy=-1);
// #MMIDPL @TEXT("MMIDPL", key="name", size=1.1, dx=1.5, dy=1);
// &MIDL @WIRE {#MMIDNL:1 (125, -30) (147, -30) #MMIDPL:1};
// (128, -28) @TEXT("MIDL", size=1.2);
// (-8, -14) @TEXT("L reference / sampling switches", size=1.2);
// (-8, -56) @TEXT("Capacitors and 5% Cp are in sibling XCAP.", size=1.3);
// (-8, -60) @TEXT("N bulk = VSS; P assist / MID bulk = VREFP. L = 30 nm.", size=1.1);
// &DH @WIRE {#XHCTL:1 (-6, 20)};
// (-6.3, 20) @TEXT("DH", size=1.05, halign="end", valign="middle");
// &EN @WIRE {#XDH:2 (12, 16)};
// (11.7, 16) @TEXT("EN", size=1.05, halign="end", valign="middle");
// &ENB @WIRE {#XDH:3 (12, 13)};
// (11.7, 13) @TEXT("ENB", size=1.05, halign="end", valign="middle");
// %t10 = $SUPPLY @ATTACH &VREFP => @PLACE(25, 29);
// &VREFP @WIRE {#XDH:5 %t10:p};
// %t11 = $GROUND @ATTACH &VREFN => @PLACE(25, 7);
// &VREFN @WIRE {#XDH:6 %t11:p};
// %t12 = $GROUND @ATTACH &VSS => @PLACE(19, 7);
// &VSS @WIRE {#XDH:7 %t12:p};
// %t13 = $SUPPLY @ATTACH &DVDD => @PLACE(19, 29);
// &DVDD @WIRE {#XDH:8 %t13:p};
// &VG @WIRE {#MSH:2 (40, 7)};
// (39.7, 7) @TEXT("VG", size=1.05, halign="end", valign="middle");
// &VIN @WIRE {#MSH:3 (45, 3)};
// (45, 2.4) @TEXT("VIN", size=1.05, halign="middle", valign="top");
// &APGATE @WIRE {#MEQ1:2 (61, 7)};
// (60.7, 7) @TEXT("APGATE", size=1.05, halign="end", valign="middle");
// &VIN @WIRE {#MEQ1:3 (66, 3)};
// (66, 2.4) @TEXT("VIN", size=1.05, halign="middle", valign="top");
// &SAMP_ON @WIRE {#MSHAREH:2 (82, 7)};
// (81.7, 7) @TEXT("SAMP_ON", size=1.05, halign="end", valign="middle");
// &EQBUS @WIRE {#MSHAREH:3 (87, 3)};
// (87, 2.4) @TEXT("EQBUS", size=1.05, halign="middle", valign="top");
// &PHI_S @WIRE {#MMIDNH:2 (120, 7)};
// (119.7, 7) @TEXT("PHI_S", size=1.05, halign="end", valign="middle");
// &VIN @WIRE {#MMIDNH:3 (125, 3)};
// (125, 2.4) @TEXT("VIN", size=1.05, halign="middle", valign="top");
// &AP_OFF @WIRE {#MMIDPH:2 (142, 7)};
// (141.7, 7) @TEXT("AP_OFF", size=1.05, halign="end", valign="middle");
// &VIN @WIRE {#MMIDPH:3 (147, 3)};
// (147, 2.4) @TEXT("VIN", size=1.05, halign="middle", valign="top");
// &RL @WIRE {#XLCTL:1 (-6, -30)};
// (-6.3, -30) @TEXT("RL", size=1.05, halign="end", valign="middle");
// &EN @WIRE {#XDL:2 (12, -34)};
// (11.7, -34) @TEXT("EN", size=1.05, halign="end", valign="middle");
// &ENB @WIRE {#XDL:3 (12, -37)};
// (11.7, -37) @TEXT("ENB", size=1.05, halign="end", valign="middle");
// %t27 = $SUPPLY @ATTACH &VREFP => @PLACE(25, -21);
// &VREFP @WIRE {#XDL:5 %t27:p};
// %t28 = $GROUND @ATTACH &VREFN => @PLACE(25, -43);
// &VREFN @WIRE {#XDL:6 %t28:p};
// %t29 = $GROUND @ATTACH &VSS => @PLACE(19, -43);
// &VSS @WIRE {#XDL:7 %t29:p};
// %t30 = $SUPPLY @ATTACH &DVDD => @PLACE(19, -21);
// &DVDD @WIRE {#XDL:8 %t30:p};
// &VG @WIRE {#MSL:2 (40, -43)};
// (39.7, -43) @TEXT("VG", size=1.05, halign="end", valign="middle");
// &VIN @WIRE {#MSL:3 (45, -47)};
// (45, -47.6) @TEXT("VIN", size=1.05, halign="middle", valign="top");
// &APGATE @WIRE {#MEQ2:2 (61, -43)};
// (60.7, -43) @TEXT("APGATE", size=1.05, halign="end", valign="middle");
// &VIN @WIRE {#MEQ2:3 (66, -47)};
// (66, -47.6) @TEXT("VIN", size=1.05, halign="middle", valign="top");
// &SAMP_ON @WIRE {#MSHAREL:2 (82, -43)};
// (81.7, -43) @TEXT("SAMP_ON", size=1.05, halign="end", valign="middle");
// &EQBUS @WIRE {#MSHAREL:3 (87, -47)};
// (87, -47.6) @TEXT("EQBUS", size=1.05, halign="middle", valign="top");
// &PHI_S @WIRE {#MMIDNL:2 (120, -43)};
// (119.7, -43) @TEXT("PHI_S", size=1.05, halign="end", valign="middle");
// &VIN @WIRE {#MMIDNL:3 (125, -47)};
// (125, -47.6) @TEXT("VIN", size=1.05, halign="middle", valign="top");
// &AP_OFF @WIRE {#MMIDPL:2 (142, -43)};
// (141.7, -43) @TEXT("AP_OFF", size=1.05, halign="end", valign="middle");
// &VIN @WIRE {#MMIDPL:3 (147, -47)};
// (147, -47.6) @TEXT("VIN", size=1.05, halign="middle", valign="top");
// $JUNCTION @ATTACH %j1;
// $JUNCTION @ATTACH %j2;
// $JUNCTION @ATTACH %j3;
// $JUNCTION @ATTACH %j4;
// $JUNCTION @ATTACH %j5;
// $JUNCTION @ATTACH %j6;
// (-8, 48) @TEXT("V29 / WIP | bit 2 switches | no MOM capacitors", size=1.4, bold=true, textcolor="#17365d");
// }
ends mq_cdac_sw2
subckt mq_cdac_sw1 (VIN VG DH RL EN ENB VREFP VREFN VSS DVDD EQBUS APGATE SAMP_ON BH BL)
XHCTL (DH HHIB DVDD VREFN VSS) mq_cdac_ctl_h
XLCTL (RL LHIB DVDD VREFN VSS) mq_cdac_ctl_l
XDH (HHIB EN ENB BH VREFP VREFN VSS DVDD) mq_cdac_drv1
MSH (BH VG VIN VSS) nch_ulvt_mac w=1.2e-07 l=3e-08 nf=1
XDL (LHIB EN ENB BL VREFP VREFN VSS DVDD) mq_cdac_drv1
MSL (BL VG VIN VSS) nch_ulvt_mac w=1.2e-07 l=3e-08 nf=1
MEQ1 (BH APGATE VIN VREFP) pch_ulvt_mac w=1.2e-07 l=3e-08 nf=1
MEQ2 (BL APGATE VIN VREFP) pch_ulvt_mac w=1.2e-07 l=3e-08 nf=1
MSHAREH (BH SAMP_ON EQBUS VSS) nch_ulvt_mac w=1.2e-07 l=3e-08 nf=1
MSHAREL (BL SAMP_ON EQBUS VSS) nch_ulvt_mac w=1.2e-07 l=3e-08 nf=1
// @RNL {
// {&VIN &VG &DH &RL &EN &ENB &VREFP &VREFN &VSS &DVDD &EQBUS &APGATE &SAMP_ON &BH &BL} @REMOVE-FROM $PORT_FILL_SET;
// &VSS @ADD-TO $GROUND_NET_SET;
// &VREFN @ADD-TO $GROUND_NET_SET;
// #XHCTL @PLACE(0, 20) => @ORIENT("R0");
// #XDH @PLACE(22, 18) => @ORIENT("R0");
// &HHIB @WIRE {#XHCTL:2 #XDH:1};
// #MSH @PLACE(45, 7) => @ORIENT("R0");
// #MSH @SET-SYMBOL $NMOS;
// #MSH @TEXT("ULVT 0.12u", key="model", size=1.05, dx=1.5, dy=-1);
// #MSH @TEXT("MSH", key="name", size=1.1, dx=1.5, dy=1);
// %j1 = (45, 20);
// &BH @WIRE {#XDH:4 %j1};
// &BH @WIRE {%j1 #MSH:1};
// #MEQ1 @PLACE(66, 7) => @ORIENT("MX");
// #MEQ1 @SET-SYMBOL $PMOS;
// #MEQ1 @TEXT("ULVT 0.12u", key="model", size=1.05, dx=1.5, dy=-1);
// #MEQ1 @TEXT("MEQ1", key="name", size=1.1, dx=1.5, dy=1);
// %j2 = (66, 20);
// &BH @WIRE {%j1 %j2};
// &BH @WIRE {%j2 #MEQ1:1};
// #MSHAREH @PLACE(87, 7) => @ORIENT("R0");
// #MSHAREH @SET-SYMBOL $NMOS;
// #MSHAREH @TEXT("ULVT 0.12u", key="model", size=1.05, dx=1.5, dy=-1);
// #MSHAREH @TEXT("MSHAREH", key="name", size=1.1, dx=1.5, dy=1);
// %j3 = (87, 20);
// &BH @WIRE {%j2 %j3};
// &BH @WIRE {%j3 #MSHAREH:1};
// &BH @WIRE {%j3 (105, 20)};
// (105, 22) @TEXT("BH", size=1.3);
// (-8, 36) @TEXT("H reference / sampling switches", size=1.2);
// #XLCTL @PLACE(0, -30) => @ORIENT("R0");
// #XDL @PLACE(22, -32) => @ORIENT("R0");
// &LHIB @WIRE {#XLCTL:2 #XDL:1};
// #MSL @PLACE(45, -43) => @ORIENT("R0");
// #MSL @SET-SYMBOL $NMOS;
// #MSL @TEXT("ULVT 0.12u", key="model", size=1.05, dx=1.5, dy=-1);
// #MSL @TEXT("MSL", key="name", size=1.1, dx=1.5, dy=1);
// %j4 = (45, -30);
// &BL @WIRE {#XDL:4 %j4};
// &BL @WIRE {%j4 #MSL:1};
// #MEQ2 @PLACE(66, -43) => @ORIENT("MX");
// #MEQ2 @SET-SYMBOL $PMOS;
// #MEQ2 @TEXT("ULVT 0.12u", key="model", size=1.05, dx=1.5, dy=-1);
// #MEQ2 @TEXT("MEQ2", key="name", size=1.1, dx=1.5, dy=1);
// %j5 = (66, -30);
// &BL @WIRE {%j4 %j5};
// &BL @WIRE {%j5 #MEQ2:1};
// #MSHAREL @PLACE(87, -43) => @ORIENT("R0");
// #MSHAREL @SET-SYMBOL $NMOS;
// #MSHAREL @TEXT("ULVT 0.12u", key="model", size=1.05, dx=1.5, dy=-1);
// #MSHAREL @TEXT("MSHAREL", key="name", size=1.1, dx=1.5, dy=1);
// %j6 = (87, -30);
// &BL @WIRE {%j5 %j6};
// &BL @WIRE {%j6 #MSHAREL:1};
// &BL @WIRE {%j6 (105, -30)};
// (105, -28) @TEXT("BL", size=1.3);
// (-8, -14) @TEXT("L reference / sampling switches", size=1.2);
// (-8, -56) @TEXT("Capacitors and 5% Cp are in sibling XCAP.", size=1.3);
// (-8, -60) @TEXT("N bulk = VSS; P assist / MID bulk = VREFP. L = 30 nm.", size=1.1);
// &DH @WIRE {#XHCTL:1 (-6, 20)};
// (-6.3, 20) @TEXT("DH", size=1.05, halign="end", valign="middle");
// &EN @WIRE {#XDH:2 (12, 16)};
// (11.7, 16) @TEXT("EN", size=1.05, halign="end", valign="middle");
// &ENB @WIRE {#XDH:3 (12, 13)};
// (11.7, 13) @TEXT("ENB", size=1.05, halign="end", valign="middle");
// %t10 = $SUPPLY @ATTACH &VREFP => @PLACE(25, 29);
// &VREFP @WIRE {#XDH:5 %t10:p};
// %t11 = $GROUND @ATTACH &VREFN => @PLACE(25, 7);
// &VREFN @WIRE {#XDH:6 %t11:p};
// %t12 = $GROUND @ATTACH &VSS => @PLACE(19, 7);
// &VSS @WIRE {#XDH:7 %t12:p};
// %t13 = $SUPPLY @ATTACH &DVDD => @PLACE(19, 29);
// &DVDD @WIRE {#XDH:8 %t13:p};
// &VG @WIRE {#MSH:2 (40, 7)};
// (39.7, 7) @TEXT("VG", size=1.05, halign="end", valign="middle");
// &VIN @WIRE {#MSH:3 (45, 3)};
// (45, 2.4) @TEXT("VIN", size=1.05, halign="middle", valign="top");
// &APGATE @WIRE {#MEQ1:2 (61, 7)};
// (60.7, 7) @TEXT("APGATE", size=1.05, halign="end", valign="middle");
// &VIN @WIRE {#MEQ1:3 (66, 3)};
// (66, 2.4) @TEXT("VIN", size=1.05, halign="middle", valign="top");
// &SAMP_ON @WIRE {#MSHAREH:2 (82, 7)};
// (81.7, 7) @TEXT("SAMP_ON", size=1.05, halign="end", valign="middle");
// &EQBUS @WIRE {#MSHAREH:3 (87, 3)};
// (87, 2.4) @TEXT("EQBUS", size=1.05, halign="middle", valign="top");
// &RL @WIRE {#XLCTL:1 (-6, -30)};
// (-6.3, -30) @TEXT("RL", size=1.05, halign="end", valign="middle");
// &EN @WIRE {#XDL:2 (12, -34)};
// (11.7, -34) @TEXT("EN", size=1.05, halign="end", valign="middle");
// &ENB @WIRE {#XDL:3 (12, -37)};
// (11.7, -37) @TEXT("ENB", size=1.05, halign="end", valign="middle");
// %t23 = $SUPPLY @ATTACH &VREFP => @PLACE(25, -21);
// &VREFP @WIRE {#XDL:5 %t23:p};
// %t24 = $GROUND @ATTACH &VREFN => @PLACE(25, -43);
// &VREFN @WIRE {#XDL:6 %t24:p};
// %t25 = $GROUND @ATTACH &VSS => @PLACE(19, -43);
// &VSS @WIRE {#XDL:7 %t25:p};
// %t26 = $SUPPLY @ATTACH &DVDD => @PLACE(19, -21);
// &DVDD @WIRE {#XDL:8 %t26:p};
// &VG @WIRE {#MSL:2 (40, -43)};
// (39.7, -43) @TEXT("VG", size=1.05, halign="end", valign="middle");
// &VIN @WIRE {#MSL:3 (45, -47)};
// (45, -47.6) @TEXT("VIN", size=1.05, halign="middle", valign="top");
// &APGATE @WIRE {#MEQ2:2 (61, -43)};
// (60.7, -43) @TEXT("APGATE", size=1.05, halign="end", valign="middle");
// &VIN @WIRE {#MEQ2:3 (66, -47)};
// (66, -47.6) @TEXT("VIN", size=1.05, halign="middle", valign="top");
// &SAMP_ON @WIRE {#MSHAREL:2 (82, -43)};
// (81.7, -43) @TEXT("SAMP_ON", size=1.05, halign="end", valign="middle");
// &EQBUS @WIRE {#MSHAREL:3 (87, -47)};
// (87, -47.6) @TEXT("EQBUS", size=1.05, halign="middle", valign="top");
// $JUNCTION @ATTACH %j1;
// $JUNCTION @ATTACH %j2;
// $JUNCTION @ATTACH %j3;
// $JUNCTION @ATTACH %j4;
// $JUNCTION @ATTACH %j5;
// $JUNCTION @ATTACH %j6;
// (-8, 48) @TEXT("V29 / WIP | bit 1 switches | no MOM capacitors", size=1.4, bold=true, textcolor="#17365d");
// }
ends mq_cdac_sw1
subckt mq_cdac_sw0 (VIN VG DH RL EN ENB VREFP VREFN VSS PHI_S DVDD AP_OFF EQBUS APGATE SAMP_ON BH BL MIDH MIDL)
XHCTL (DH HHIB DVDD VREFN VSS) mq_cdac_ctl_h
XLCTL (RL LHIB DVDD VREFN VSS) mq_cdac_ctl_l
XDH (HHIB EN ENB BH VREFP VREFN VSS DVDD) mq_cdac_drv0
MSH (BH VG VIN VSS) nch_ulvt_mac w=1.2e-07 l=3e-08 nf=1
XDL (LHIB EN ENB BL VREFP VREFN VSS DVDD) mq_cdac_drv0
MSL (BL VG VIN VSS) nch_ulvt_mac w=1.2e-07 l=3e-08 nf=1
MEQ1 (BH APGATE VIN VREFP) pch_ulvt_mac w=1.2e-07 l=3e-08 nf=1
MEQ2 (BL APGATE VIN VREFP) pch_ulvt_mac w=1.2e-07 l=3e-08 nf=1
MMIDNH (MIDH PHI_S VIN VSS) nch_ulvt_mac w=1.2e-07 l=3e-08 nf=1
MMIDPH (MIDH AP_OFF VIN VREFP) pch_mac w=1.2e-07 l=3e-08 nf=1
MMIDNL (MIDL PHI_S VIN VSS) nch_ulvt_mac w=1.2e-07 l=3e-08 nf=1
MMIDPL (MIDL AP_OFF VIN VREFP) pch_mac w=1.2e-07 l=3e-08 nf=1
MSHAREH (BH SAMP_ON EQBUS VSS) nch_ulvt_mac w=1.2e-07 l=3e-08 nf=1
MSHAREL (BL SAMP_ON EQBUS VSS) nch_ulvt_mac w=1.2e-07 l=3e-08 nf=1
// @RNL {
// {&VIN &VG &DH &RL &EN &ENB &VREFP &VREFN &VSS &PHI_S &DVDD &AP_OFF &EQBUS &APGATE &SAMP_ON &BH &BL &MIDH &MIDL} @REMOVE-FROM $PORT_FILL_SET;
// &VSS @ADD-TO $GROUND_NET_SET;
// &VREFN @ADD-TO $GROUND_NET_SET;
// #XHCTL @PLACE(0, 20) => @ORIENT("R0");
// #XDH @PLACE(22, 18) => @ORIENT("R0");
// &HHIB @WIRE {#XHCTL:2 #XDH:1};
// #MSH @PLACE(45, 7) => @ORIENT("R0");
// #MSH @SET-SYMBOL $NMOS;
// #MSH @TEXT("ULVT 0.12u", key="model", size=1.05, dx=1.5, dy=-1);
// #MSH @TEXT("MSH", key="name", size=1.1, dx=1.5, dy=1);
// %j1 = (45, 20);
// &BH @WIRE {#XDH:4 %j1};
// &BH @WIRE {%j1 #MSH:1};
// #MEQ1 @PLACE(66, 7) => @ORIENT("MX");
// #MEQ1 @SET-SYMBOL $PMOS;
// #MEQ1 @TEXT("ULVT 0.12u", key="model", size=1.05, dx=1.5, dy=-1);
// #MEQ1 @TEXT("MEQ1", key="name", size=1.1, dx=1.5, dy=1);
// %j2 = (66, 20);
// &BH @WIRE {%j1 %j2};
// &BH @WIRE {%j2 #MEQ1:1};
// #MSHAREH @PLACE(87, 7) => @ORIENT("R0");
// #MSHAREH @SET-SYMBOL $NMOS;
// #MSHAREH @TEXT("ULVT 0.12u", key="model", size=1.05, dx=1.5, dy=-1);
// #MSHAREH @TEXT("MSHAREH", key="name", size=1.1, dx=1.5, dy=1);
// %j3 = (87, 20);
// &BH @WIRE {%j2 %j3};
// &BH @WIRE {%j3 #MSHAREH:1};
// &BH @WIRE {%j3 (105, 20)};
// (105, 22) @TEXT("BH", size=1.3);
// #MMIDNH @PLACE(125, 7) => @ORIENT("R0");
// #MMIDNH @SET-SYMBOL $NMOS;
// #MMIDNH @TEXT("ULVT 0.12u", key="model", size=1.05, dx=1.5, dy=-1);
// #MMIDNH @TEXT("MMIDNH", key="name", size=1.1, dx=1.5, dy=1);
// #MMIDPH @PLACE(147, 7) => @ORIENT("MX");
// #MMIDPH @SET-SYMBOL $PMOS;
// #MMIDPH @TEXT("SVT 0.12u", key="model", size=1.05, dx=1.5, dy=-1);
// #MMIDPH @TEXT("MMIDPH", key="name", size=1.1, dx=1.5, dy=1);
// &MIDH @WIRE {#MMIDNH:1 (125, 20) (147, 20) #MMIDPH:1};
// (128, 22) @TEXT("MIDH", size=1.2);
// (-8, 36) @TEXT("H reference / sampling switches", size=1.2);
// #XLCTL @PLACE(0, -30) => @ORIENT("R0");
// #XDL @PLACE(22, -32) => @ORIENT("R0");
// &LHIB @WIRE {#XLCTL:2 #XDL:1};
// #MSL @PLACE(45, -43) => @ORIENT("R0");
// #MSL @SET-SYMBOL $NMOS;
// #MSL @TEXT("ULVT 0.12u", key="model", size=1.05, dx=1.5, dy=-1);
// #MSL @TEXT("MSL", key="name", size=1.1, dx=1.5, dy=1);
// %j4 = (45, -30);
// &BL @WIRE {#XDL:4 %j4};
// &BL @WIRE {%j4 #MSL:1};
// #MEQ2 @PLACE(66, -43) => @ORIENT("MX");
// #MEQ2 @SET-SYMBOL $PMOS;
// #MEQ2 @TEXT("ULVT 0.12u", key="model", size=1.05, dx=1.5, dy=-1);
// #MEQ2 @TEXT("MEQ2", key="name", size=1.1, dx=1.5, dy=1);
// %j5 = (66, -30);
// &BL @WIRE {%j4 %j5};
// &BL @WIRE {%j5 #MEQ2:1};
// #MSHAREL @PLACE(87, -43) => @ORIENT("R0");
// #MSHAREL @SET-SYMBOL $NMOS;
// #MSHAREL @TEXT("ULVT 0.12u", key="model", size=1.05, dx=1.5, dy=-1);
// #MSHAREL @TEXT("MSHAREL", key="name", size=1.1, dx=1.5, dy=1);
// %j6 = (87, -30);
// &BL @WIRE {%j5 %j6};
// &BL @WIRE {%j6 #MSHAREL:1};
// &BL @WIRE {%j6 (105, -30)};
// (105, -28) @TEXT("BL", size=1.3);
// #MMIDNL @PLACE(125, -43) => @ORIENT("R0");
// #MMIDNL @SET-SYMBOL $NMOS;
// #MMIDNL @TEXT("ULVT 0.12u", key="model", size=1.05, dx=1.5, dy=-1);
// #MMIDNL @TEXT("MMIDNL", key="name", size=1.1, dx=1.5, dy=1);
// #MMIDPL @PLACE(147, -43) => @ORIENT("MX");
// #MMIDPL @SET-SYMBOL $PMOS;
// #MMIDPL @TEXT("SVT 0.12u", key="model", size=1.05, dx=1.5, dy=-1);
// #MMIDPL @TEXT("MMIDPL", key="name", size=1.1, dx=1.5, dy=1);
// &MIDL @WIRE {#MMIDNL:1 (125, -30) (147, -30) #MMIDPL:1};
// (128, -28) @TEXT("MIDL", size=1.2);
// (-8, -14) @TEXT("L reference / sampling switches", size=1.2);
// (-8, -56) @TEXT("Capacitors and 5% Cp are in sibling XCAP.", size=1.3);
// (-8, -60) @TEXT("N bulk = VSS; P assist / MID bulk = VREFP. L = 30 nm.", size=1.1);
// &DH @WIRE {#XHCTL:1 (-6, 20)};
// (-6.3, 20) @TEXT("DH", size=1.05, halign="end", valign="middle");
// &EN @WIRE {#XDH:2 (12, 16)};
// (11.7, 16) @TEXT("EN", size=1.05, halign="end", valign="middle");
// &ENB @WIRE {#XDH:3 (12, 13)};
// (11.7, 13) @TEXT("ENB", size=1.05, halign="end", valign="middle");
// %t10 = $SUPPLY @ATTACH &VREFP => @PLACE(25, 29);
// &VREFP @WIRE {#XDH:5 %t10:p};
// %t11 = $GROUND @ATTACH &VREFN => @PLACE(25, 7);
// &VREFN @WIRE {#XDH:6 %t11:p};
// %t12 = $GROUND @ATTACH &VSS => @PLACE(19, 7);
// &VSS @WIRE {#XDH:7 %t12:p};
// %t13 = $SUPPLY @ATTACH &DVDD => @PLACE(19, 29);
// &DVDD @WIRE {#XDH:8 %t13:p};
// &VG @WIRE {#MSH:2 (40, 7)};
// (39.7, 7) @TEXT("VG", size=1.05, halign="end", valign="middle");
// &VIN @WIRE {#MSH:3 (45, 3)};
// (45, 2.4) @TEXT("VIN", size=1.05, halign="middle", valign="top");
// &APGATE @WIRE {#MEQ1:2 (61, 7)};
// (60.7, 7) @TEXT("APGATE", size=1.05, halign="end", valign="middle");
// &VIN @WIRE {#MEQ1:3 (66, 3)};
// (66, 2.4) @TEXT("VIN", size=1.05, halign="middle", valign="top");
// &SAMP_ON @WIRE {#MSHAREH:2 (82, 7)};
// (81.7, 7) @TEXT("SAMP_ON", size=1.05, halign="end", valign="middle");
// &EQBUS @WIRE {#MSHAREH:3 (87, 3)};
// (87, 2.4) @TEXT("EQBUS", size=1.05, halign="middle", valign="top");
// &PHI_S @WIRE {#MMIDNH:2 (120, 7)};
// (119.7, 7) @TEXT("PHI_S", size=1.05, halign="end", valign="middle");
// &VIN @WIRE {#MMIDNH:3 (125, 3)};
// (125, 2.4) @TEXT("VIN", size=1.05, halign="middle", valign="top");
// &AP_OFF @WIRE {#MMIDPH:2 (142, 7)};
// (141.7, 7) @TEXT("AP_OFF", size=1.05, halign="end", valign="middle");
// &VIN @WIRE {#MMIDPH:3 (147, 3)};
// (147, 2.4) @TEXT("VIN", size=1.05, halign="middle", valign="top");
// &RL @WIRE {#XLCTL:1 (-6, -30)};
// (-6.3, -30) @TEXT("RL", size=1.05, halign="end", valign="middle");
// &EN @WIRE {#XDL:2 (12, -34)};
// (11.7, -34) @TEXT("EN", size=1.05, halign="end", valign="middle");
// &ENB @WIRE {#XDL:3 (12, -37)};
// (11.7, -37) @TEXT("ENB", size=1.05, halign="end", valign="middle");
// %t27 = $SUPPLY @ATTACH &VREFP => @PLACE(25, -21);
// &VREFP @WIRE {#XDL:5 %t27:p};
// %t28 = $GROUND @ATTACH &VREFN => @PLACE(25, -43);
// &VREFN @WIRE {#XDL:6 %t28:p};
// %t29 = $GROUND @ATTACH &VSS => @PLACE(19, -43);
// &VSS @WIRE {#XDL:7 %t29:p};
// %t30 = $SUPPLY @ATTACH &DVDD => @PLACE(19, -21);
// &DVDD @WIRE {#XDL:8 %t30:p};
// &VG @WIRE {#MSL:2 (40, -43)};
// (39.7, -43) @TEXT("VG", size=1.05, halign="end", valign="middle");
// &VIN @WIRE {#MSL:3 (45, -47)};
// (45, -47.6) @TEXT("VIN", size=1.05, halign="middle", valign="top");
// &APGATE @WIRE {#MEQ2:2 (61, -43)};
// (60.7, -43) @TEXT("APGATE", size=1.05, halign="end", valign="middle");
// &VIN @WIRE {#MEQ2:3 (66, -47)};
// (66, -47.6) @TEXT("VIN", size=1.05, halign="middle", valign="top");
// &SAMP_ON @WIRE {#MSHAREL:2 (82, -43)};
// (81.7, -43) @TEXT("SAMP_ON", size=1.05, halign="end", valign="middle");
// &EQBUS @WIRE {#MSHAREL:3 (87, -47)};
// (87, -47.6) @TEXT("EQBUS", size=1.05, halign="middle", valign="top");
// &PHI_S @WIRE {#MMIDNL:2 (120, -43)};
// (119.7, -43) @TEXT("PHI_S", size=1.05, halign="end", valign="middle");
// &VIN @WIRE {#MMIDNL:3 (125, -47)};
// (125, -47.6) @TEXT("VIN", size=1.05, halign="middle", valign="top");
// &AP_OFF @WIRE {#MMIDPL:2 (142, -43)};
// (141.7, -43) @TEXT("AP_OFF", size=1.05, halign="end", valign="middle");
// &VIN @WIRE {#MMIDPL:3 (147, -47)};
// (147, -47.6) @TEXT("VIN", size=1.05, halign="middle", valign="top");
// $JUNCTION @ATTACH %j1;
// $JUNCTION @ATTACH %j2;
// $JUNCTION @ATTACH %j3;
// $JUNCTION @ATTACH %j4;
// $JUNCTION @ATTACH %j5;
// $JUNCTION @ATTACH %j6;
// (-8, 48) @TEXT("V29 / WIP | bit 0 switches | no MOM capacitors", size=1.4, bold=true, textcolor="#17365d");
// }
ends mq_cdac_sw0
subckt mq_cdac_cap_array (TOP BPH12 BPL12 BPH11 BPL11 BPH10 BPL10 BPH9 BPL9 BPH8 BPL8 BPH7 BPL7 BPH6 BPL6 BPH5 BPL5 BPH4 BPL4 BPH3 BPL3 BPH2 BPL2 BPH1 BPL1 BPH0 BPL0 MIDH7 MIDL7 MIDH2 MIDL2 MIDH0 MIDL0 VSS)
B12_CH (TOP BPH12) cfmom_2t w=5e-08 s=2.4e-07 nr=6 lr=1.69e-06 stm=2 spm=4 multi=490
B12_CPH (BPH12 VSS) capacitor c=2.45561050e-14
B12_CL (TOP BPL12) cfmom_2t w=5e-08 s=2.4e-07 nr=6 lr=1.69e-06 stm=2 spm=4 multi=490
B12_CPL (BPL12 VSS) capacitor c=2.45561050e-14
B11_CH (TOP BPH11) cfmom_2t w=5e-08 s=2.4e-07 nr=6 lr=1.69e-06 stm=2 spm=4 multi=280
B11_CPH (BPH11 VSS) capacitor c=1.40320600e-14
B11_CL (TOP BPL11) cfmom_2t w=5e-08 s=2.4e-07 nr=6 lr=1.69e-06 stm=2 spm=4 multi=280
B11_CPL (BPL11 VSS) capacitor c=1.40320600e-14
B10_CH (TOP BPH10) cfmom_2t w=5e-08 s=2.4e-07 nr=6 lr=1.69e-06 stm=2 spm=4 multi=159
B10_CPH (BPH10 VSS) capacitor c=7.9682055e-15
B10_CL (TOP BPL10) cfmom_2t w=5e-08 s=2.4e-07 nr=6 lr=1.69e-06 stm=2 spm=4 multi=159
B10_CPL (BPL10 VSS) capacitor c=7.9682055e-15
B9_CH (TOP BPH9) cfmom_2t w=5e-08 s=2.4e-07 nr=6 lr=1.69e-06 stm=2 spm=4 multi=90
B9_CPH (BPH9 VSS) capacitor c=4.5103050e-15
B9_CL (TOP BPL9) cfmom_2t w=5e-08 s=2.4e-07 nr=6 lr=1.69e-06 stm=2 spm=4 multi=90
B9_CPL (BPL9 VSS) capacitor c=4.5103050e-15
B8_CH (TOP BPH8) cfmom_2t w=5e-08 s=2.4e-07 nr=6 lr=1.69e-06 stm=2 spm=4 multi=51
B8_CPH (BPH8 VSS) capacitor c=2.5558395e-15
B8_CL (TOP BPL8) cfmom_2t w=5e-08 s=2.4e-07 nr=6 lr=1.69e-06 stm=2 spm=4 multi=51
B8_CPL (BPL8 VSS) capacitor c=2.5558395e-15
B7_CH (TOP BPH7) cfmom_2t w=5e-08 s=2.4e-07 nr=6 lr=1.69e-06 stm=2 spm=4 multi=28
B7_CPH (BPH7 VSS) capacitor c=1.4032060e-15
B7_CHA (TOP MIDH7) cfmom_2t w=5e-08 s=2.4e-07 nr=6 lr=1.69e-06 stm=2 spm=4 multi=1
B7_CPHA (MIDH7 VSS) capacitor c=5.01145e-17
B7_CHB (MIDH7 BPH7) cfmom_2t w=5e-08 s=2.4e-07 nr=6 lr=1.69e-06 stm=2 spm=4 multi=1
B7_CPHB (BPH7 VSS) capacitor c=5.01145e-17
B7_CL (TOP BPL7) cfmom_2t w=5e-08 s=2.4e-07 nr=6 lr=1.69e-06 stm=2 spm=4 multi=28
B7_CPL (BPL7 VSS) capacitor c=1.4032060e-15
B7_CLA (TOP MIDL7) cfmom_2t w=5e-08 s=2.4e-07 nr=6 lr=1.69e-06 stm=2 spm=4 multi=1
B7_CPLA (MIDL7 VSS) capacitor c=5.01145e-17
B7_CLB (MIDL7 BPL7) cfmom_2t w=5e-08 s=2.4e-07 nr=6 lr=1.69e-06 stm=2 spm=4 multi=1
B7_CPLB (BPL7 VSS) capacitor c=5.01145e-17
B6_CH (TOP BPH6) cfmom_2t w=5e-08 s=2.4e-07 nr=6 lr=1.69e-06 stm=2 spm=4 multi=16
B6_CPH (BPH6 VSS) capacitor c=8.018320e-16
B6_CL (TOP BPL6) cfmom_2t w=5e-08 s=2.4e-07 nr=6 lr=1.69e-06 stm=2 spm=4 multi=16
B6_CPL (BPL6 VSS) capacitor c=8.018320e-16
B5_CH (TOP BPH5) cfmom_2t w=5e-08 s=2.4e-07 nr=6 lr=1.69e-06 stm=2 spm=4 multi=9
B5_CPH (BPH5 VSS) capacitor c=4.510305e-16
B5_CL (TOP BPL5) cfmom_2t w=5e-08 s=2.4e-07 nr=6 lr=1.69e-06 stm=2 spm=4 multi=9
B5_CPL (BPL5 VSS) capacitor c=4.510305e-16
B4_CH (TOP BPH4) cfmom_2t w=5e-08 s=2.4e-07 nr=6 lr=1.69e-06 stm=2 spm=4 multi=5
B4_CPH (BPH4 VSS) capacitor c=2.505725e-16
B4_CL (TOP BPL4) cfmom_2t w=5e-08 s=2.4e-07 nr=6 lr=1.69e-06 stm=2 spm=4 multi=5
B4_CPL (BPL4 VSS) capacitor c=2.505725e-16
B3_CH (TOP BPH3) cfmom_2t w=5e-08 s=2.4e-07 nr=6 lr=1.69e-06 stm=2 spm=4 multi=3
B3_CPH (BPH3 VSS) capacitor c=1.503435e-16
B3_CL (TOP BPL3) cfmom_2t w=5e-08 s=2.4e-07 nr=6 lr=1.69e-06 stm=2 spm=4 multi=3
B3_CPL (BPL3 VSS) capacitor c=1.503435e-16
B2_CH (TOP BPH2) cfmom_2t w=5e-08 s=2.4e-07 nr=6 lr=1.69e-06 stm=2 spm=4 multi=1
B2_CPH (BPH2 VSS) capacitor c=5.01145e-17
B2_CHA (TOP MIDH2) cfmom_2t w=5e-08 s=2.4e-07 nr=6 lr=1.69e-06 stm=2 spm=4 multi=1
B2_CPHA (MIDH2 VSS) capacitor c=5.01145e-17
B2_CHB (MIDH2 BPH2) cfmom_2t w=5e-08 s=2.4e-07 nr=6 lr=1.69e-06 stm=2 spm=4 multi=1
B2_CPHB (BPH2 VSS) capacitor c=5.01145e-17
B2_CL (TOP BPL2) cfmom_2t w=5e-08 s=2.4e-07 nr=6 lr=1.69e-06 stm=2 spm=4 multi=1
B2_CPL (BPL2 VSS) capacitor c=5.01145e-17
B2_CLA (TOP MIDL2) cfmom_2t w=5e-08 s=2.4e-07 nr=6 lr=1.69e-06 stm=2 spm=4 multi=1
B2_CPLA (MIDL2 VSS) capacitor c=5.01145e-17
B2_CLB (MIDL2 BPL2) cfmom_2t w=5e-08 s=2.4e-07 nr=6 lr=1.69e-06 stm=2 spm=4 multi=1
B2_CPLB (BPL2 VSS) capacitor c=5.01145e-17
B1_CH (TOP BPH1) cfmom_2t w=5e-08 s=2.4e-07 nr=6 lr=1.69e-06 stm=2 spm=4 multi=1
B1_CPH (BPH1 VSS) capacitor c=5.01145e-17
B1_CL (TOP BPL1) cfmom_2t w=5e-08 s=2.4e-07 nr=6 lr=1.69e-06 stm=2 spm=4 multi=1
B1_CPL (BPL1 VSS) capacitor c=5.01145e-17
B0_CHA (TOP MIDH0) cfmom_2t w=5e-08 s=2.4e-07 nr=6 lr=1.69e-06 stm=2 spm=4 multi=1
B0_CPHA (MIDH0 VSS) capacitor c=5.01145e-17
B0_CHB (MIDH0 BPH0) cfmom_2t w=5e-08 s=2.4e-07 nr=6 lr=1.69e-06 stm=2 spm=4 multi=1
B0_CPHB (BPH0 VSS) capacitor c=5.01145e-17
B0_CLA (TOP MIDL0) cfmom_2t w=5e-08 s=2.4e-07 nr=6 lr=1.69e-06 stm=2 spm=4 multi=1
B0_CPLA (MIDL0 VSS) capacitor c=5.01145e-17
B0_CLB (MIDL0 BPL0) cfmom_2t w=5e-08 s=2.4e-07 nr=6 lr=1.69e-06 stm=2 spm=4 multi=1
B0_CPLB (BPL0 VSS) capacitor c=5.01145e-17
// @RNL {
// {&TOP &BPH12 &BPL12 &BPH11 &BPL11 &BPH10 &BPL10 &BPH9 &BPL9 &BPH8 &BPL8 &BPH7 &BPL7 &BPH6 &BPL6 &BPH5 &BPL5 &BPH4 &BPL4 &BPH3 &BPL3 &BPH2 &BPL2 &BPH1 &BPL1 &BPH0 &BPL0 &MIDH7 &MIDL7 &MIDH2 &MIDL2 &MIDH0 &MIDL0 &VSS} @REMOVE-FROM $PORT_FILL_SET;
// &VSS @ADD-TO $GROUND_NET_SET;
// (-4, 20) @TEXT("weight 12 = 980 Cu", size=2.0);
// %j1 = (10, -9);
// #B12_CH @PLACE(10, 3) => @ORIENT("R0");
// #B12_CH @TEXT("", key="value");
// #B12_CH @TEXT("", key="name");
// (12, 4) @TEXT("B12_CH", size=2.0);
// (12, 2) @TEXT("490 Cu", size=2.0);
// &BPH12 @WIRE {#B12_CH:2 %j1};
// #B12_CPH @PLACE(36, -14) => @ORIENT("R0");
// #B12_CPH @TEXT("", key="value");
// #B12_CPH @TEXT("", key="name");
// (38, -13) @TEXT("B12_CPH", size=2.0);
// (38, -15) @TEXT("24.56 fF / 5%", size=2.0);
// &BPH12 @WIRE {%j1 (36, -9) #B12_CPH:1};
// &BPH12 @WIRE {%j1 (-2, -9)};
// (-3, -7) @TEXT("BPH12", size=2.0);
// %j2 = (10, -59);
// #B12_CL @PLACE(10, -47) => @ORIENT("R0");
// #B12_CL @TEXT("", key="value");
// #B12_CL @TEXT("", key="name");
// (12, -46) @TEXT("B12_CL", size=2.0);
// (12, -48) @TEXT("490 Cu", size=2.0);
// &BPL12 @WIRE {#B12_CL:2 %j2};
// #B12_CPL @PLACE(36, -64) => @ORIENT("R0");
// #B12_CPL @TEXT("", key="value");
// #B12_CPL @TEXT("", key="name");
// (38, -63) @TEXT("B12_CPL", size=2.0);
// (38, -65) @TEXT("24.56 fF / 5%", size=2.0);
// &BPL12 @WIRE {%j2 (36, -59) #B12_CPL:1};
// &BPL12 @WIRE {%j2 (-2, -59)};
// (-3, -57) @TEXT("BPL12", size=2.0);
// (116, 20) @TEXT("weight 11 = 560 Cu", size=2.0);
// %j3 = (130, -9);
// #B11_CH @PLACE(130, 3) => @ORIENT("R0");
// #B11_CH @TEXT("", key="value");
// #B11_CH @TEXT("", key="name");
// (132, 4) @TEXT("B11_CH", size=2.0);
// (132, 2) @TEXT("280 Cu", size=2.0);
// &BPH11 @WIRE {#B11_CH:2 %j3};
// #B11_CPH @PLACE(156, -14) => @ORIENT("R0");
// #B11_CPH @TEXT("", key="value");
// #B11_CPH @TEXT("", key="name");
// (158, -13) @TEXT("B11_CPH", size=2.0);
// (158, -15) @TEXT("14.03 fF / 5%", size=2.0);
// &BPH11 @WIRE {%j3 (156, -9) #B11_CPH:1};
// &BPH11 @WIRE {%j3 (118, -9)};
// (117, -7) @TEXT("BPH11", size=2.0);
// %j4 = (130, -59);
// #B11_CL @PLACE(130, -47) => @ORIENT("R0");
// #B11_CL @TEXT("", key="value");
// #B11_CL @TEXT("", key="name");
// (132, -46) @TEXT("B11_CL", size=2.0);
// (132, -48) @TEXT("280 Cu", size=2.0);
// &BPL11 @WIRE {#B11_CL:2 %j4};
// #B11_CPL @PLACE(156, -64) => @ORIENT("R0");
// #B11_CPL @TEXT("", key="value");
// #B11_CPL @TEXT("", key="name");
// (158, -63) @TEXT("B11_CPL", size=2.0);
// (158, -65) @TEXT("14.03 fF / 5%", size=2.0);
// &BPL11 @WIRE {%j4 (156, -59) #B11_CPL:1};
// &BPL11 @WIRE {%j4 (118, -59)};
// (117, -57) @TEXT("BPL11", size=2.0);
// (236, 20) @TEXT("weight 10 = 318 Cu", size=2.0);
// %j5 = (250, -9);
// #B10_CH @PLACE(250, 3) => @ORIENT("R0");
// #B10_CH @TEXT("", key="value");
// #B10_CH @TEXT("", key="name");
// (252, 4) @TEXT("B10_CH", size=2.0);
// (252, 2) @TEXT("159 Cu", size=2.0);
// &BPH10 @WIRE {#B10_CH:2 %j5};
// #B10_CPH @PLACE(276, -14) => @ORIENT("R0");
// #B10_CPH @TEXT("", key="value");
// #B10_CPH @TEXT("", key="name");
// (278, -13) @TEXT("B10_CPH", size=2.0);
// (278, -15) @TEXT("7.968 fF / 5%", size=2.0);
// &BPH10 @WIRE {%j5 (276, -9) #B10_CPH:1};
// &BPH10 @WIRE {%j5 (238, -9)};
// (237, -7) @TEXT("BPH10", size=2.0);
// %j6 = (250, -59);
// #B10_CL @PLACE(250, -47) => @ORIENT("R0");
// #B10_CL @TEXT("", key="value");
// #B10_CL @TEXT("", key="name");
// (252, -46) @TEXT("B10_CL", size=2.0);
// (252, -48) @TEXT("159 Cu", size=2.0);
// &BPL10 @WIRE {#B10_CL:2 %j6};
// #B10_CPL @PLACE(276, -64) => @ORIENT("R0");
// #B10_CPL @TEXT("", key="value");
// #B10_CPL @TEXT("", key="name");
// (278, -63) @TEXT("B10_CPL", size=2.0);
// (278, -65) @TEXT("7.968 fF / 5%", size=2.0);
// &BPL10 @WIRE {%j6 (276, -59) #B10_CPL:1};
// &BPL10 @WIRE {%j6 (238, -59)};
// (237, -57) @TEXT("BPL10", size=2.0);
// (356, 20) @TEXT("weight 9 = 180 Cu", size=2.0);
// %j7 = (370, -9);
// #B9_CH @PLACE(370, 3) => @ORIENT("R0");
// #B9_CH @TEXT("", key="value");
// #B9_CH @TEXT("", key="name");
// (372, 4) @TEXT("B9_CH", size=2.0);
// (372, 2) @TEXT("90 Cu", size=2.0);
// &BPH9 @WIRE {#B9_CH:2 %j7};
// #B9_CPH @PLACE(396, -14) => @ORIENT("R0");
// #B9_CPH @TEXT("", key="value");
// #B9_CPH @TEXT("", key="name");
// (398, -13) @TEXT("B9_CPH", size=2.0);
// (398, -15) @TEXT("4.51 fF / 5%", size=2.0);
// &BPH9 @WIRE {%j7 (396, -9) #B9_CPH:1};
// &BPH9 @WIRE {%j7 (358, -9)};
// (357, -7) @TEXT("BPH9", size=2.0);
// %j8 = (370, -59);
// #B9_CL @PLACE(370, -47) => @ORIENT("R0");
// #B9_CL @TEXT("", key="value");
// #B9_CL @TEXT("", key="name");
// (372, -46) @TEXT("B9_CL", size=2.0);
// (372, -48) @TEXT("90 Cu", size=2.0);
// &BPL9 @WIRE {#B9_CL:2 %j8};
// #B9_CPL @PLACE(396, -64) => @ORIENT("R0");
// #B9_CPL @TEXT("", key="value");
// #B9_CPL @TEXT("", key="name");
// (398, -63) @TEXT("B9_CPL", size=2.0);
// (398, -65) @TEXT("4.51 fF / 5%", size=2.0);
// &BPL9 @WIRE {%j8 (396, -59) #B9_CPL:1};
// &BPL9 @WIRE {%j8 (358, -59)};
// (357, -57) @TEXT("BPL9", size=2.0);
// (-4, -91) @TEXT("weight 8 = 102 Cu", size=2.0);
// %j9 = (10, -120);
// #B8_CH @PLACE(10, -108) => @ORIENT("R0");
// #B8_CH @TEXT("", key="value");
// #B8_CH @TEXT("", key="name");
// (12, -107) @TEXT("B8_CH", size=2.0);
// (12, -109) @TEXT("51 Cu", size=2.0);
// &BPH8 @WIRE {#B8_CH:2 %j9};
// #B8_CPH @PLACE(36, -125) => @ORIENT("R0");
// #B8_CPH @TEXT("", key="value");
// #B8_CPH @TEXT("", key="name");
// (38, -124) @TEXT("B8_CPH", size=2.0);
// (38, -126) @TEXT("2.556 fF / 5%", size=2.0);
// &BPH8 @WIRE {%j9 (36, -120) #B8_CPH:1};
// &BPH8 @WIRE {%j9 (-2, -120)};
// (-3, -118) @TEXT("BPH8", size=2.0);
// %j10 = (10, -170);
// #B8_CL @PLACE(10, -158) => @ORIENT("R0");
// #B8_CL @TEXT("", key="value");
// #B8_CL @TEXT("", key="name");
// (12, -157) @TEXT("B8_CL", size=2.0);
// (12, -159) @TEXT("51 Cu", size=2.0);
// &BPL8 @WIRE {#B8_CL:2 %j10};
// #B8_CPL @PLACE(36, -175) => @ORIENT("R0");
// #B8_CPL @TEXT("", key="value");
// #B8_CPL @TEXT("", key="name");
// (38, -174) @TEXT("B8_CPL", size=2.0);
// (38, -176) @TEXT("2.556 fF / 5%", size=2.0);
// &BPL8 @WIRE {%j10 (36, -170) #B8_CPL:1};
// &BPL8 @WIRE {%j10 (-2, -170)};
// (-3, -168) @TEXT("BPL8", size=2.0);
// (116, -91) @TEXT("weight 7 = 57 Cu", size=2.0);
// %j11 = (130, -120);
// #B7_CH @PLACE(130, -108) => @ORIENT("R0");
// #B7_CH @TEXT("", key="value");
// #B7_CH @TEXT("", key="name");
// (132, -107) @TEXT("B7_CH", size=2.0);
// (132, -109) @TEXT("28 Cu", size=2.0);
// &BPH7 @WIRE {#B7_CH:2 %j11};
// #B7_CPH @PLACE(156, -125) => @ORIENT("R0");
// #B7_CPH @TEXT("", key="value");
// #B7_CPH @TEXT("", key="name");
// (158, -124) @TEXT("B7_CPH", size=2.0);
// (158, -126) @TEXT("1.403 fF / 5%", size=2.0);
// &BPH7 @WIRE {%j11 (156, -120) #B7_CPH:1};
// #B7_CHA @PLACE(185, -101) => @ORIENT("R0");
// #B7_CHA @TEXT("", key="value");
// #B7_CHA @TEXT("", key="name");
// (187, -100) @TEXT("B7_CHA", size=2.0);
// (187, -102) @TEXT("1 Cu", size=2.0);
// #B7_CHB @PLACE(185, -115) => @ORIENT("R0");
// #B7_CHB @TEXT("", key="value");
// #B7_CHB @TEXT("", key="name");
// (187, -114) @TEXT("B7_CHB", size=2.0);
// (187, -116) @TEXT("1 Cu", size=2.0);
// %j12 = (185, -108);
// &MIDH7 @WIRE {#B7_CHA:2 %j12 #B7_CHB:1};
// (200, -107) @TEXT("MIDH7", size=2.0);
// %j13 = (185, -120);
// &BPH7 @WIRE {#B7_CHB:2 %j13 %j11};
// #B7_CPHA @PLACE(212, -113) => @ORIENT("R0");
// #B7_CPHA @TEXT("", key="value");
// #B7_CPHA @TEXT("", key="name");
// (214, -112) @TEXT("B7_CPHA", size=2.0);
// (214, -114) @TEXT("0.05011 fF / 5%", size=2.0);
// #B7_CPHB @PLACE(185, -129) => @ORIENT("R0");
// #B7_CPHB @TEXT("", key="value");
// #B7_CPHB @TEXT("", key="name");
// (187, -128) @TEXT("B7_CPHB", size=2.0);
// (187, -130) @TEXT("0.05011 fF / 5%", size=2.0);
// &MIDH7 @WIRE {%j12 (212, -108) #B7_CPHA:1};
// &BPH7 @WIRE {%j13 #B7_CPHB:1};
// &BPH7 @WIRE {%j11 (118, -120)};
// (117, -118) @TEXT("BPH7", size=2.0);
// %j14 = (130, -170);
// #B7_CL @PLACE(130, -158) => @ORIENT("R0");
// #B7_CL @TEXT("", key="value");
// #B7_CL @TEXT("", key="name");
// (132, -157) @TEXT("B7_CL", size=2.0);
// (132, -159) @TEXT("28 Cu", size=2.0);
// &BPL7 @WIRE {#B7_CL:2 %j14};
// #B7_CPL @PLACE(156, -175) => @ORIENT("R0");
// #B7_CPL @TEXT("", key="value");
// #B7_CPL @TEXT("", key="name");
// (158, -174) @TEXT("B7_CPL", size=2.0);
// (158, -176) @TEXT("1.403 fF / 5%", size=2.0);
// &BPL7 @WIRE {%j14 (156, -170) #B7_CPL:1};
// #B7_CLA @PLACE(185, -151) => @ORIENT("R0");
// #B7_CLA @TEXT("", key="value");
// #B7_CLA @TEXT("", key="name");
// (187, -150) @TEXT("B7_CLA", size=2.0);
// (187, -152) @TEXT("1 Cu", size=2.0);
// #B7_CLB @PLACE(185, -165) => @ORIENT("R0");
// #B7_CLB @TEXT("", key="value");
// #B7_CLB @TEXT("", key="name");
// (187, -164) @TEXT("B7_CLB", size=2.0);
// (187, -166) @TEXT("1 Cu", size=2.0);
// %j15 = (185, -158);
// &MIDL7 @WIRE {#B7_CLA:2 %j15 #B7_CLB:1};
// (200, -157) @TEXT("MIDL7", size=2.0);
// %j16 = (185, -170);
// &BPL7 @WIRE {#B7_CLB:2 %j16 %j14};
// #B7_CPLA @PLACE(212, -163) => @ORIENT("R0");
// #B7_CPLA @TEXT("", key="value");
// #B7_CPLA @TEXT("", key="name");
// (214, -162) @TEXT("B7_CPLA", size=2.0);
// (214, -164) @TEXT("0.05011 fF / 5%", size=2.0);
// #B7_CPLB @PLACE(185, -179) => @ORIENT("R0");
// #B7_CPLB @TEXT("", key="value");
// #B7_CPLB @TEXT("", key="name");
// (187, -178) @TEXT("B7_CPLB", size=2.0);
// (187, -180) @TEXT("0.05011 fF / 5%", size=2.0);
// &MIDL7 @WIRE {%j15 (212, -158) #B7_CPLA:1};
// &BPL7 @WIRE {%j16 #B7_CPLB:1};
// &BPL7 @WIRE {%j14 (118, -170)};
// (117, -168) @TEXT("BPL7", size=2.0);
// (236, -91) @TEXT("weight 6 = 32 Cu", size=2.0);
// %j17 = (250, -120);
// #B6_CH @PLACE(250, -108) => @ORIENT("R0");
// #B6_CH @TEXT("", key="value");
// #B6_CH @TEXT("", key="name");
// (252, -107) @TEXT("B6_CH", size=2.0);
// (252, -109) @TEXT("16 Cu", size=2.0);
// &BPH6 @WIRE {#B6_CH:2 %j17};
// #B6_CPH @PLACE(276, -125) => @ORIENT("R0");
// #B6_CPH @TEXT("", key="value");
// #B6_CPH @TEXT("", key="name");
// (278, -124) @TEXT("B6_CPH", size=2.0);
// (278, -126) @TEXT("0.8018 fF / 5%", size=2.0);
// &BPH6 @WIRE {%j17 (276, -120) #B6_CPH:1};
// &BPH6 @WIRE {%j17 (238, -120)};
// (237, -118) @TEXT("BPH6", size=2.0);
// %j18 = (250, -170);
// #B6_CL @PLACE(250, -158) => @ORIENT("R0");
// #B6_CL @TEXT("", key="value");
// #B6_CL @TEXT("", key="name");
// (252, -157) @TEXT("B6_CL", size=2.0);
// (252, -159) @TEXT("16 Cu", size=2.0);
// &BPL6 @WIRE {#B6_CL:2 %j18};
// #B6_CPL @PLACE(276, -175) => @ORIENT("R0");
// #B6_CPL @TEXT("", key="value");
// #B6_CPL @TEXT("", key="name");
// (278, -174) @TEXT("B6_CPL", size=2.0);
// (278, -176) @TEXT("0.8018 fF / 5%", size=2.0);
// &BPL6 @WIRE {%j18 (276, -170) #B6_CPL:1};
// &BPL6 @WIRE {%j18 (238, -170)};
// (237, -168) @TEXT("BPL6", size=2.0);
// (356, -91) @TEXT("weight 5 = 18 Cu", size=2.0);
// %j19 = (370, -120);
// #B5_CH @PLACE(370, -108) => @ORIENT("R0");
// #B5_CH @TEXT("", key="value");
// #B5_CH @TEXT("", key="name");
// (372, -107) @TEXT("B5_CH", size=2.0);
// (372, -109) @TEXT("9 Cu", size=2.0);
// &BPH5 @WIRE {#B5_CH:2 %j19};
// #B5_CPH @PLACE(396, -125) => @ORIENT("R0");
// #B5_CPH @TEXT("", key="value");
// #B5_CPH @TEXT("", key="name");
// (398, -124) @TEXT("B5_CPH", size=2.0);
// (398, -126) @TEXT("0.451 fF / 5%", size=2.0);
// &BPH5 @WIRE {%j19 (396, -120) #B5_CPH:1};
// &BPH5 @WIRE {%j19 (358, -120)};
// (357, -118) @TEXT("BPH5", size=2.0);
// %j20 = (370, -170);
// #B5_CL @PLACE(370, -158) => @ORIENT("R0");
// #B5_CL @TEXT("", key="value");
// #B5_CL @TEXT("", key="name");
// (372, -157) @TEXT("B5_CL", size=2.0);
// (372, -159) @TEXT("9 Cu", size=2.0);
// &BPL5 @WIRE {#B5_CL:2 %j20};
// #B5_CPL @PLACE(396, -175) => @ORIENT("R0");
// #B5_CPL @TEXT("", key="value");
// #B5_CPL @TEXT("", key="name");
// (398, -174) @TEXT("B5_CPL", size=2.0);
// (398, -176) @TEXT("0.451 fF / 5%", size=2.0);
// &BPL5 @WIRE {%j20 (396, -170) #B5_CPL:1};
// &BPL5 @WIRE {%j20 (358, -170)};
// (357, -168) @TEXT("BPL5", size=2.0);
// (-4, -202) @TEXT("weight 4 = 10 Cu", size=2.0);
// %j21 = (10, -231);
// #B4_CH @PLACE(10, -219) => @ORIENT("R0");
// #B4_CH @TEXT("", key="value");
// #B4_CH @TEXT("", key="name");
// (12, -218) @TEXT("B4_CH", size=2.0);
// (12, -220) @TEXT("5 Cu", size=2.0);
// &BPH4 @WIRE {#B4_CH:2 %j21};
// #B4_CPH @PLACE(36, -236) => @ORIENT("R0");
// #B4_CPH @TEXT("", key="value");
// #B4_CPH @TEXT("", key="name");
// (38, -235) @TEXT("B4_CPH", size=2.0);
// (38, -237) @TEXT("0.2506 fF / 5%", size=2.0);
// &BPH4 @WIRE {%j21 (36, -231) #B4_CPH:1};
// &BPH4 @WIRE {%j21 (-2, -231)};
// (-3, -229) @TEXT("BPH4", size=2.0);
// %j22 = (10, -281);
// #B4_CL @PLACE(10, -269) => @ORIENT("R0");
// #B4_CL @TEXT("", key="value");
// #B4_CL @TEXT("", key="name");
// (12, -268) @TEXT("B4_CL", size=2.0);
// (12, -270) @TEXT("5 Cu", size=2.0);
// &BPL4 @WIRE {#B4_CL:2 %j22};
// #B4_CPL @PLACE(36, -286) => @ORIENT("R0");
// #B4_CPL @TEXT("", key="value");
// #B4_CPL @TEXT("", key="name");
// (38, -285) @TEXT("B4_CPL", size=2.0);
// (38, -287) @TEXT("0.2506 fF / 5%", size=2.0);
// &BPL4 @WIRE {%j22 (36, -281) #B4_CPL:1};
// &BPL4 @WIRE {%j22 (-2, -281)};
// (-3, -279) @TEXT("BPL4", size=2.0);
// (116, -202) @TEXT("weight 3 = 6 Cu", size=2.0);
// %j23 = (130, -231);
// #B3_CH @PLACE(130, -219) => @ORIENT("R0");
// #B3_CH @TEXT("", key="value");
// #B3_CH @TEXT("", key="name");
// (132, -218) @TEXT("B3_CH", size=2.0);
// (132, -220) @TEXT("3 Cu", size=2.0);
// &BPH3 @WIRE {#B3_CH:2 %j23};
// #B3_CPH @PLACE(156, -236) => @ORIENT("R0");
// #B3_CPH @TEXT("", key="value");
// #B3_CPH @TEXT("", key="name");
// (158, -235) @TEXT("B3_CPH", size=2.0);
// (158, -237) @TEXT("0.1503 fF / 5%", size=2.0);
// &BPH3 @WIRE {%j23 (156, -231) #B3_CPH:1};
// &BPH3 @WIRE {%j23 (118, -231)};
// (117, -229) @TEXT("BPH3", size=2.0);
// %j24 = (130, -281);
// #B3_CL @PLACE(130, -269) => @ORIENT("R0");
// #B3_CL @TEXT("", key="value");
// #B3_CL @TEXT("", key="name");
// (132, -268) @TEXT("B3_CL", size=2.0);
// (132, -270) @TEXT("3 Cu", size=2.0);
// &BPL3 @WIRE {#B3_CL:2 %j24};
// #B3_CPL @PLACE(156, -286) => @ORIENT("R0");
// #B3_CPL @TEXT("", key="value");
// #B3_CPL @TEXT("", key="name");
// (158, -285) @TEXT("B3_CPL", size=2.0);
// (158, -287) @TEXT("0.1503 fF / 5%", size=2.0);
// &BPL3 @WIRE {%j24 (156, -281) #B3_CPL:1};
// &BPL3 @WIRE {%j24 (118, -281)};
// (117, -279) @TEXT("BPL3", size=2.0);
// (236, -202) @TEXT("weight 2 = 3 Cu", size=2.0);
// %j25 = (250, -231);
// #B2_CH @PLACE(250, -219) => @ORIENT("R0");
// #B2_CH @TEXT("", key="value");
// #B2_CH @TEXT("", key="name");
// (252, -218) @TEXT("B2_CH", size=2.0);
// (252, -220) @TEXT("1 Cu", size=2.0);
// &BPH2 @WIRE {#B2_CH:2 %j25};
// #B2_CPH @PLACE(276, -236) => @ORIENT("R0");
// #B2_CPH @TEXT("", key="value");
// #B2_CPH @TEXT("", key="name");
// (278, -235) @TEXT("B2_CPH", size=2.0);
// (278, -237) @TEXT("0.05011 fF / 5%", size=2.0);
// &BPH2 @WIRE {%j25 (276, -231) #B2_CPH:1};
// #B2_CHA @PLACE(305, -212) => @ORIENT("R0");
// #B2_CHA @TEXT("", key="value");
// #B2_CHA @TEXT("", key="name");
// (307, -211) @TEXT("B2_CHA", size=2.0);
// (307, -213) @TEXT("1 Cu", size=2.0);
// #B2_CHB @PLACE(305, -226) => @ORIENT("R0");
// #B2_CHB @TEXT("", key="value");
// #B2_CHB @TEXT("", key="name");
// (307, -225) @TEXT("B2_CHB", size=2.0);
// (307, -227) @TEXT("1 Cu", size=2.0);
// %j26 = (305, -219);
// &MIDH2 @WIRE {#B2_CHA:2 %j26 #B2_CHB:1};
// (320, -218) @TEXT("MIDH2", size=2.0);
// %j27 = (305, -231);
// &BPH2 @WIRE {#B2_CHB:2 %j27 %j25};
// #B2_CPHA @PLACE(332, -224) => @ORIENT("R0");
// #B2_CPHA @TEXT("", key="value");
// #B2_CPHA @TEXT("", key="name");
// (334, -223) @TEXT("B2_CPHA", size=2.0);
// (334, -225) @TEXT("0.05011 fF / 5%", size=2.0);
// #B2_CPHB @PLACE(305, -240) => @ORIENT("R0");
// #B2_CPHB @TEXT("", key="value");
// #B2_CPHB @TEXT("", key="name");
// (307, -239) @TEXT("B2_CPHB", size=2.0);
// (307, -241) @TEXT("0.05011 fF / 5%", size=2.0);
// &MIDH2 @WIRE {%j26 (332, -219) #B2_CPHA:1};
// &BPH2 @WIRE {%j27 #B2_CPHB:1};
// &BPH2 @WIRE {%j25 (238, -231)};
// (237, -229) @TEXT("BPH2", size=2.0);
// %j28 = (250, -281);
// #B2_CL @PLACE(250, -269) => @ORIENT("R0");
// #B2_CL @TEXT("", key="value");
// #B2_CL @TEXT("", key="name");
// (252, -268) @TEXT("B2_CL", size=2.0);
// (252, -270) @TEXT("1 Cu", size=2.0);
// &BPL2 @WIRE {#B2_CL:2 %j28};
// #B2_CPL @PLACE(276, -286) => @ORIENT("R0");
// #B2_CPL @TEXT("", key="value");
// #B2_CPL @TEXT("", key="name");
// (278, -285) @TEXT("B2_CPL", size=2.0);
// (278, -287) @TEXT("0.05011 fF / 5%", size=2.0);
// &BPL2 @WIRE {%j28 (276, -281) #B2_CPL:1};
// #B2_CLA @PLACE(305, -262) => @ORIENT("R0");
// #B2_CLA @TEXT("", key="value");
// #B2_CLA @TEXT("", key="name");
// (307, -261) @TEXT("B2_CLA", size=2.0);
// (307, -263) @TEXT("1 Cu", size=2.0);
// #B2_CLB @PLACE(305, -276) => @ORIENT("R0");
// #B2_CLB @TEXT("", key="value");
// #B2_CLB @TEXT("", key="name");
// (307, -275) @TEXT("B2_CLB", size=2.0);
// (307, -277) @TEXT("1 Cu", size=2.0);
// %j29 = (305, -269);
// &MIDL2 @WIRE {#B2_CLA:2 %j29 #B2_CLB:1};
// (320, -268) @TEXT("MIDL2", size=2.0);
// %j30 = (305, -281);
// &BPL2 @WIRE {#B2_CLB:2 %j30 %j28};
// #B2_CPLA @PLACE(332, -274) => @ORIENT("R0");
// #B2_CPLA @TEXT("", key="value");
// #B2_CPLA @TEXT("", key="name");
// (334, -273) @TEXT("B2_CPLA", size=2.0);
// (334, -275) @TEXT("0.05011 fF / 5%", size=2.0);
// #B2_CPLB @PLACE(305, -290) => @ORIENT("R0");
// #B2_CPLB @TEXT("", key="value");
// #B2_CPLB @TEXT("", key="name");
// (307, -289) @TEXT("B2_CPLB", size=2.0);
// (307, -291) @TEXT("0.05011 fF / 5%", size=2.0);
// &MIDL2 @WIRE {%j29 (332, -269) #B2_CPLA:1};
// &BPL2 @WIRE {%j30 #B2_CPLB:1};
// &BPL2 @WIRE {%j28 (238, -281)};
// (237, -279) @TEXT("BPL2", size=2.0);
// (356, -202) @TEXT("weight 1 = 2 Cu", size=2.0);
// %j31 = (370, -231);
// #B1_CH @PLACE(370, -219) => @ORIENT("R0");
// #B1_CH @TEXT("", key="value");
// #B1_CH @TEXT("", key="name");
// (372, -218) @TEXT("B1_CH", size=2.0);
// (372, -220) @TEXT("1 Cu", size=2.0);
// &BPH1 @WIRE {#B1_CH:2 %j31};
// #B1_CPH @PLACE(396, -236) => @ORIENT("R0");
// #B1_CPH @TEXT("", key="value");
// #B1_CPH @TEXT("", key="name");
// (398, -235) @TEXT("B1_CPH", size=2.0);
// (398, -237) @TEXT("0.05011 fF / 5%", size=2.0);
// &BPH1 @WIRE {%j31 (396, -231) #B1_CPH:1};
// &BPH1 @WIRE {%j31 (358, -231)};
// (357, -229) @TEXT("BPH1", size=2.0);
// %j32 = (370, -281);
// #B1_CL @PLACE(370, -269) => @ORIENT("R0");
// #B1_CL @TEXT("", key="value");
// #B1_CL @TEXT("", key="name");
// (372, -268) @TEXT("B1_CL", size=2.0);
// (372, -270) @TEXT("1 Cu", size=2.0);
// &BPL1 @WIRE {#B1_CL:2 %j32};
// #B1_CPL @PLACE(396, -286) => @ORIENT("R0");
// #B1_CPL @TEXT("", key="value");
// #B1_CPL @TEXT("", key="name");
// (398, -285) @TEXT("B1_CPL", size=2.0);
// (398, -287) @TEXT("0.05011 fF / 5%", size=2.0);
// &BPL1 @WIRE {%j32 (396, -281) #B1_CPL:1};
// &BPL1 @WIRE {%j32 (358, -281)};
// (357, -279) @TEXT("BPL1", size=2.0);
// (-4, -313) @TEXT("weight 0 = 1 Cu", size=2.0);
// %j33 = (10, -342);
// #B0_CHA @PLACE(65, -323) => @ORIENT("R0");
// #B0_CHA @TEXT("", key="value");
// #B0_CHA @TEXT("", key="name");
// (67, -322) @TEXT("B0_CHA", size=2.0);
// (67, -324) @TEXT("1 Cu", size=2.0);
// #B0_CHB @PLACE(65, -337) => @ORIENT("R0");
// #B0_CHB @TEXT("", key="value");
// #B0_CHB @TEXT("", key="name");
// (67, -336) @TEXT("B0_CHB", size=2.0);
// (67, -338) @TEXT("1 Cu", size=2.0);
// %j34 = (65, -330);
// &MIDH0 @WIRE {#B0_CHA:2 %j34 #B0_CHB:1};
// (80, -329) @TEXT("MIDH0", size=2.0);
// %j35 = (65, -342);
// &BPH0 @WIRE {#B0_CHB:2 %j35 %j33};
// #B0_CPHA @PLACE(92, -335) => @ORIENT("R0");
// #B0_CPHA @TEXT("", key="value");
// #B0_CPHA @TEXT("", key="name");
// (94, -334) @TEXT("B0_CPHA", size=2.0);
// (94, -336) @TEXT("0.05011 fF / 5%", size=2.0);
// #B0_CPHB @PLACE(65, -351) => @ORIENT("R0");
// #B0_CPHB @TEXT("", key="value");
// #B0_CPHB @TEXT("", key="name");
// (67, -350) @TEXT("B0_CPHB", size=2.0);
// (67, -352) @TEXT("0.05011 fF / 5%", size=2.0);
// &MIDH0 @WIRE {%j34 (92, -330) #B0_CPHA:1};
// &BPH0 @WIRE {%j35 #B0_CPHB:1};
// &BPH0 @WIRE {%j33 (-2, -342)};
// (-3, -340) @TEXT("BPH0", size=2.0);
// %j36 = (10, -392);
// #B0_CLA @PLACE(65, -373) => @ORIENT("R0");
// #B0_CLA @TEXT("", key="value");
// #B0_CLA @TEXT("", key="name");
// (67, -372) @TEXT("B0_CLA", size=2.0);
// (67, -374) @TEXT("1 Cu", size=2.0);
// #B0_CLB @PLACE(65, -387) => @ORIENT("R0");
// #B0_CLB @TEXT("", key="value");
// #B0_CLB @TEXT("", key="name");
// (67, -386) @TEXT("B0_CLB", size=2.0);
// (67, -388) @TEXT("1 Cu", size=2.0);
// %j37 = (65, -380);
// &MIDL0 @WIRE {#B0_CLA:2 %j37 #B0_CLB:1};
// (80, -379) @TEXT("MIDL0", size=2.0);
// %j38 = (65, -392);
// &BPL0 @WIRE {#B0_CLB:2 %j38 %j36};
// #B0_CPLA @PLACE(92, -385) => @ORIENT("R0");
// #B0_CPLA @TEXT("", key="value");
// #B0_CPLA @TEXT("", key="name");
// (94, -384) @TEXT("B0_CPLA", size=2.0);
// (94, -386) @TEXT("0.05011 fF / 5%", size=2.0);
// #B0_CPLB @PLACE(65, -401) => @ORIENT("R0");
// #B0_CPLB @TEXT("", key="value");
// #B0_CPLB @TEXT("", key="name");
// (67, -400) @TEXT("B0_CPLB", size=2.0);
// (67, -402) @TEXT("0.05011 fF / 5%", size=2.0);
// &MIDL0 @WIRE {%j37 (92, -380) #B0_CPLA:1};
// &BPL0 @WIRE {%j38 #B0_CPLB:1};
// &BPL0 @WIRE {%j36 (-2, -392)};
// (-3, -390) @TEXT("BPL0", size=2.0);
// (123, -351) @TEXT("Cu = 1.00229 fF; Cp = 5% per physical MOM.", size=2.0);
// (123, -357) @TEXT("j7 / j2 / j0: series-unit MID pins go to XSW sampling gates.", size=2.0);
// &TOP @WIRE {#B12_CH:1 (10, 7)};
// (10, 7.4) @TEXT("TOP", size=2.0, halign="middle", valign="bottom");
// %t40 = $GROUND @ATTACH &VSS => @PLACE(36, -18);
// &VSS @WIRE {#B12_CPH:2 %t40:p};
// &TOP @WIRE {#B12_CL:1 (10, -43)};
// (10, -42.6) @TEXT("TOP", size=2.0, halign="middle", valign="bottom");
// %t42 = $GROUND @ATTACH &VSS => @PLACE(36, -68);
// &VSS @WIRE {#B12_CPL:2 %t42:p};
// &TOP @WIRE {#B11_CH:1 (130, 7)};
// (130, 7.4) @TEXT("TOP", size=2.0, halign="middle", valign="bottom");
// %t44 = $GROUND @ATTACH &VSS => @PLACE(156, -18);
// &VSS @WIRE {#B11_CPH:2 %t44:p};
// &TOP @WIRE {#B11_CL:1 (130, -43)};
// (130, -42.6) @TEXT("TOP", size=2.0, halign="middle", valign="bottom");
// %t46 = $GROUND @ATTACH &VSS => @PLACE(156, -68);
// &VSS @WIRE {#B11_CPL:2 %t46:p};
// &TOP @WIRE {#B10_CH:1 (250, 7)};
// (250, 7.4) @TEXT("TOP", size=2.0, halign="middle", valign="bottom");
// %t48 = $GROUND @ATTACH &VSS => @PLACE(276, -18);
// &VSS @WIRE {#B10_CPH:2 %t48:p};
// &TOP @WIRE {#B10_CL:1 (250, -43)};
// (250, -42.6) @TEXT("TOP", size=2.0, halign="middle", valign="bottom");
// %t50 = $GROUND @ATTACH &VSS => @PLACE(276, -68);
// &VSS @WIRE {#B10_CPL:2 %t50:p};
// &TOP @WIRE {#B9_CH:1 (370, 7)};
// (370, 7.4) @TEXT("TOP", size=2.0, halign="middle", valign="bottom");
// %t52 = $GROUND @ATTACH &VSS => @PLACE(396, -18);
// &VSS @WIRE {#B9_CPH:2 %t52:p};
// &TOP @WIRE {#B9_CL:1 (370, -43)};
// (370, -42.6) @TEXT("TOP", size=2.0, halign="middle", valign="bottom");
// %t54 = $GROUND @ATTACH &VSS => @PLACE(396, -68);
// &VSS @WIRE {#B9_CPL:2 %t54:p};
// &TOP @WIRE {#B8_CH:1 (10, -104)};
// (10, -103.6) @TEXT("TOP", size=2.0, halign="middle", valign="bottom");
// %t56 = $GROUND @ATTACH &VSS => @PLACE(36, -129);
// &VSS @WIRE {#B8_CPH:2 %t56:p};
// &TOP @WIRE {#B8_CL:1 (10, -154)};
// (10, -153.6) @TEXT("TOP", size=2.0, halign="middle", valign="bottom");
// %t58 = $GROUND @ATTACH &VSS => @PLACE(36, -179);
// &VSS @WIRE {#B8_CPL:2 %t58:p};
// &TOP @WIRE {#B7_CH:1 (130, -104)};
// (130, -103.6) @TEXT("TOP", size=2.0, halign="middle", valign="bottom");
// %t60 = $GROUND @ATTACH &VSS => @PLACE(156, -129);
// &VSS @WIRE {#B7_CPH:2 %t60:p};
// &TOP @WIRE {#B7_CHA:1 (185, -97)};
// (185, -96.6) @TEXT("TOP", size=2.0, halign="middle", valign="bottom");
// %t62 = $GROUND @ATTACH &VSS => @PLACE(212, -117);
// &VSS @WIRE {#B7_CPHA:2 %t62:p};
// %t63 = $GROUND @ATTACH &VSS => @PLACE(185, -133);
// &VSS @WIRE {#B7_CPHB:2 %t63:p};
// &TOP @WIRE {#B7_CL:1 (130, -154)};
// (130, -153.6) @TEXT("TOP", size=2.0, halign="middle", valign="bottom");
// %t65 = $GROUND @ATTACH &VSS => @PLACE(156, -179);
// &VSS @WIRE {#B7_CPL:2 %t65:p};
// &TOP @WIRE {#B7_CLA:1 (185, -147)};
// (185, -146.6) @TEXT("TOP", size=2.0, halign="middle", valign="bottom");
// %t67 = $GROUND @ATTACH &VSS => @PLACE(212, -167);
// &VSS @WIRE {#B7_CPLA:2 %t67:p};
// %t68 = $GROUND @ATTACH &VSS => @PLACE(185, -183);
// &VSS @WIRE {#B7_CPLB:2 %t68:p};
// &TOP @WIRE {#B6_CH:1 (250, -104)};
// (250, -103.6) @TEXT("TOP", size=2.0, halign="middle", valign="bottom");
// %t70 = $GROUND @ATTACH &VSS => @PLACE(276, -129);
// &VSS @WIRE {#B6_CPH:2 %t70:p};
// &TOP @WIRE {#B6_CL:1 (250, -154)};
// (250, -153.6) @TEXT("TOP", size=2.0, halign="middle", valign="bottom");
// %t72 = $GROUND @ATTACH &VSS => @PLACE(276, -179);
// &VSS @WIRE {#B6_CPL:2 %t72:p};
// &TOP @WIRE {#B5_CH:1 (370, -104)};
// (370, -103.6) @TEXT("TOP", size=2.0, halign="middle", valign="bottom");
// %t74 = $GROUND @ATTACH &VSS => @PLACE(396, -129);
// &VSS @WIRE {#B5_CPH:2 %t74:p};
// &TOP @WIRE {#B5_CL:1 (370, -154)};
// (370, -153.6) @TEXT("TOP", size=2.0, halign="middle", valign="bottom");
// %t76 = $GROUND @ATTACH &VSS => @PLACE(396, -179);
// &VSS @WIRE {#B5_CPL:2 %t76:p};
// &TOP @WIRE {#B4_CH:1 (10, -215)};
// (10, -214.6) @TEXT("TOP", size=2.0, halign="middle", valign="bottom");
// %t78 = $GROUND @ATTACH &VSS => @PLACE(36, -240);
// &VSS @WIRE {#B4_CPH:2 %t78:p};
// &TOP @WIRE {#B4_CL:1 (10, -265)};
// (10, -264.6) @TEXT("TOP", size=2.0, halign="middle", valign="bottom");
// %t80 = $GROUND @ATTACH &VSS => @PLACE(36, -290);
// &VSS @WIRE {#B4_CPL:2 %t80:p};
// &TOP @WIRE {#B3_CH:1 (130, -215)};
// (130, -214.6) @TEXT("TOP", size=2.0, halign="middle", valign="bottom");
// %t82 = $GROUND @ATTACH &VSS => @PLACE(156, -240);
// &VSS @WIRE {#B3_CPH:2 %t82:p};
// &TOP @WIRE {#B3_CL:1 (130, -265)};
// (130, -264.6) @TEXT("TOP", size=2.0, halign="middle", valign="bottom");
// %t84 = $GROUND @ATTACH &VSS => @PLACE(156, -290);
// &VSS @WIRE {#B3_CPL:2 %t84:p};
// &TOP @WIRE {#B2_CH:1 (250, -215)};
// (250, -214.6) @TEXT("TOP", size=2.0, halign="middle", valign="bottom");
// %t86 = $GROUND @ATTACH &VSS => @PLACE(276, -240);
// &VSS @WIRE {#B2_CPH:2 %t86:p};
// &TOP @WIRE {#B2_CHA:1 (305, -208)};
// (305, -207.6) @TEXT("TOP", size=2.0, halign="middle", valign="bottom");
// %t88 = $GROUND @ATTACH &VSS => @PLACE(332, -228);
// &VSS @WIRE {#B2_CPHA:2 %t88:p};
// %t89 = $GROUND @ATTACH &VSS => @PLACE(305, -244);
// &VSS @WIRE {#B2_CPHB:2 %t89:p};
// &TOP @WIRE {#B2_CL:1 (250, -265)};
// (250, -264.6) @TEXT("TOP", size=2.0, halign="middle", valign="bottom");
// %t91 = $GROUND @ATTACH &VSS => @PLACE(276, -290);
// &VSS @WIRE {#B2_CPL:2 %t91:p};
// &TOP @WIRE {#B2_CLA:1 (305, -258)};
// (305, -257.6) @TEXT("TOP", size=2.0, halign="middle", valign="bottom");
// %t93 = $GROUND @ATTACH &VSS => @PLACE(332, -278);
// &VSS @WIRE {#B2_CPLA:2 %t93:p};
// %t94 = $GROUND @ATTACH &VSS => @PLACE(305, -294);
// &VSS @WIRE {#B2_CPLB:2 %t94:p};
// &TOP @WIRE {#B1_CH:1 (370, -215)};
// (370, -214.6) @TEXT("TOP", size=2.0, halign="middle", valign="bottom");
// %t96 = $GROUND @ATTACH &VSS => @PLACE(396, -240);
// &VSS @WIRE {#B1_CPH:2 %t96:p};
// &TOP @WIRE {#B1_CL:1 (370, -265)};
// (370, -264.6) @TEXT("TOP", size=2.0, halign="middle", valign="bottom");
// %t98 = $GROUND @ATTACH &VSS => @PLACE(396, -290);
// &VSS @WIRE {#B1_CPL:2 %t98:p};
// &TOP @WIRE {#B0_CHA:1 (65, -319)};
// (65, -318.6) @TEXT("TOP", size=2.0, halign="middle", valign="bottom");
// %t100 = $GROUND @ATTACH &VSS => @PLACE(92, -339);
// &VSS @WIRE {#B0_CPHA:2 %t100:p};
// %t101 = $GROUND @ATTACH &VSS => @PLACE(65, -355);
// &VSS @WIRE {#B0_CPHB:2 %t101:p};
// &TOP @WIRE {#B0_CLA:1 (65, -369)};
// (65, -368.6) @TEXT("TOP", size=2.0, halign="middle", valign="bottom");
// %t103 = $GROUND @ATTACH &VSS => @PLACE(92, -389);
// &VSS @WIRE {#B0_CPLA:2 %t103:p};
// %t104 = $GROUND @ATTACH &VSS => @PLACE(65, -405);
// &VSS @WIRE {#B0_CPLB:2 %t104:p};
// $JUNCTION @ATTACH %j1;
// $JUNCTION @ATTACH %j2;
// $JUNCTION @ATTACH %j3;
// $JUNCTION @ATTACH %j4;
// $JUNCTION @ATTACH %j5;
// $JUNCTION @ATTACH %j6;
// $JUNCTION @ATTACH %j7;
// $JUNCTION @ATTACH %j8;
// $JUNCTION @ATTACH %j9;
// $JUNCTION @ATTACH %j10;
// $JUNCTION @ATTACH %j11;
// $JUNCTION @ATTACH %j12;
// $JUNCTION @ATTACH %j13;
// $JUNCTION @ATTACH %j14;
// $JUNCTION @ATTACH %j15;
// $JUNCTION @ATTACH %j16;
// $JUNCTION @ATTACH %j17;
// $JUNCTION @ATTACH %j18;
// $JUNCTION @ATTACH %j19;
// $JUNCTION @ATTACH %j20;
// $JUNCTION @ATTACH %j21;
// $JUNCTION @ATTACH %j22;
// $JUNCTION @ATTACH %j23;
// $JUNCTION @ATTACH %j24;
// $JUNCTION @ATTACH %j25;
// $JUNCTION @ATTACH %j26;
// $JUNCTION @ATTACH %j27;
// $JUNCTION @ATTACH %j28;
// $JUNCTION @ATTACH %j29;
// $JUNCTION @ATTACH %j30;
// $JUNCTION @ATTACH %j31;
// $JUNCTION @ATTACH %j32;
// $JUNCTION @ATTACH %j34;
// $JUNCTION @ATTACH %j35;
// $JUNCTION @ATTACH %j37;
// $JUNCTION @ATTACH %j38;
// (-4, 32) @TEXT("V29 / WIP | pure capacitor array | no switching devices", size=2.0, bold=true, textcolor="#17365d");
// }
ends mq_cdac_cap_array
subckt mq_cdac_switch_array (VIN VG VREFP VREFN PHI_S PHI_SB CONV DH12 DH11 DH10 DH9 DH8 DH7 DH6 DH5 DH4 DH3 DH2 DH1 DH0 RL12 RL11 RL10 RL9 RL8 RL7 RL6 RL5 RL4 RL3 RL2 RL1 RL0 DVDD VSS BPH12 BPL12 BPH11 BPL11 BPH10 BPL10 BPH9 BPL9 BPH8 BPL8 BPH7 BPL7 BPH6 BPL6 BPH5 BPL5 BPH4 BPL4 BPH3 BPL3 BPH2 BPL2 BPH1 BPL1 BPH0 BPL0 MIDH7 MIDL7 MIDH2 MIDL2 MIDH0 MIDL0)
XEN (CONV EN ENB DVDD VREFN VSS) mq_cdac_enable
MSHBN (SAMP_ON PHI_SB VREFN VSS) nch_ulvt_mac w=8e-06 l=3e-08 nf=4
MSHBP (SAMP_ON PHI_SB DVDD DVDD) pch_ulvt_mac w=1.6e-05 l=3e-08 nf=8
C_SAMPLOAD (VSS SAMP_ON) cfmom_2t w=5e-08 s=2.4e-07 nr=6 lr=1.69e-06 stm=2 spm=4 multi=50
CP_SAMPLOAD (SAMP_ON VSS) capacitor c=2.505725e-15
XAPULSE (PHI_S PHI_SB APGATE DVDD VREFN VSS VREFP) mq_cdac_assist_pulse
XSW12 (VIN VG DH12 RL12 EN ENB VREFP VREFN VSS DVDD EQBUS APGATE SAMP_ON BPH12 BPL12) mq_cdac_sw12
XSW11 (VIN VG DH11 RL11 EN ENB VREFP VREFN VSS DVDD EQBUS APGATE SAMP_ON BPH11 BPL11) mq_cdac_sw11
XSW10 (VIN VG DH10 RL10 EN ENB VREFP VREFN VSS DVDD EQBUS APGATE SAMP_ON BPH10 BPL10) mq_cdac_sw10
XSW9 (DH9 RL9 DVDD VREFN VREFP VREFN VSS DVDD BPH9 BPL9) mq_cdac_sw9
XSW8 (VIN VG DH8 RL8 EN ENB VREFP VREFN VSS DVDD EQBUS APGATE SAMP_ON BPH8 BPL8) mq_cdac_sw8
XSW7 (VIN VG DH7 RL7 EN ENB VREFP VREFN VSS PHI_S DVDD APGATE EQBUS APGATE SAMP_ON BPH7 BPL7 MIDH7 MIDL7) mq_cdac_sw7
XSW6 (DH6 RL6 DVDD VREFN VREFP VREFN VSS DVDD BPH6 BPL6) mq_cdac_sw6
XSW5 (VIN VG DH5 RL5 EN ENB VREFP VREFN VSS DVDD EQBUS APGATE SAMP_ON BPH5 BPL5) mq_cdac_sw5
XSW4 (VIN VG DH4 RL4 EN ENB VREFP VREFN VSS DVDD EQBUS APGATE SAMP_ON BPH4 BPL4) mq_cdac_sw4
XSW3 (VIN VG DH3 RL3 EN ENB VREFP VREFN VSS DVDD EQBUS APGATE SAMP_ON BPH3 BPL3) mq_cdac_sw3
XSW2 (VIN VG DH2 RL2 EN ENB VREFP VREFN VSS PHI_S DVDD APGATE EQBUS APGATE SAMP_ON BPH2 BPL2 MIDH2 MIDL2) mq_cdac_sw2
XSW1 (VIN VG DH1 RL1 EN ENB VREFP VREFN VSS DVDD EQBUS APGATE SAMP_ON BPH1 BPL1) mq_cdac_sw1
XSW0 (VIN VG DH0 RL0 EN ENB VREFP VREFN VSS PHI_S DVDD APGATE EQBUS APGATE SAMP_ON BPH0 BPL0 MIDH0 MIDL0) mq_cdac_sw0
// @RNL {
// {&VIN &VG &VREFP &VREFN &PHI_S &PHI_SB &CONV &DH12 &DH11 &DH10 &DH9 &DH8 &DH7 &DH6 &DH5 &DH4 &DH3 &DH2 &DH1 &DH0 &RL12 &RL11 &RL10 &RL9 &RL8 &RL7 &RL6 &RL5 &RL4 &RL3 &RL2 &RL1 &RL0 &DVDD &VSS &BPH12 &BPL12 &BPH11 &BPL11 &BPH10 &BPL10 &BPH9 &BPL9 &BPH8 &BPL8 &BPH7 &BPL7 &BPH6 &BPL6 &BPH5 &BPL5 &BPH4 &BPL4 &BPH3 &BPL3 &BPH2 &BPL2 &BPH1 &BPL1 &BPH0 &BPL0 &MIDH7 &MIDL7 &MIDH2 &MIDL2 &MIDH0 &MIDL0} @REMOVE-FROM $PORT_FILL_SET;
// &VSS @ADD-TO $GROUND_NET_SET;
// &VREFN @ADD-TO $GROUND_NET_SET;
// #XSW12 @PLACE(0, 0) => @ORIENT("R0");
// #XSW11 @PLACE(74, 0) => @ORIENT("R0");
// #XSW10 @PLACE(148, 0) => @ORIENT("R0");
// #XSW9 @PLACE(222, 0) => @ORIENT("R0");
// #XSW8 @PLACE(0, -65) => @ORIENT("R0");
// #XSW7 @PLACE(74, -65) => @ORIENT("R0");
// #XSW6 @PLACE(148, -65) => @ORIENT("R0");
// #XSW5 @PLACE(222, -65) => @ORIENT("R0");
// #XSW4 @PLACE(0, -130) => @ORIENT("R0");
// #XSW3 @PLACE(74, -130) => @ORIENT("R0");
// #XSW2 @PLACE(148, -130) => @ORIENT("R0");
// #XSW1 @PLACE(222, -130) => @ORIENT("R0");
// #XSW0 @PLACE(0, -195) => @ORIENT("R0");
// #XEN @PLACE(75, -195) => @ORIENT("R0");
// #XAPULSE @PLACE(145, -195) => @ORIENT("R0");
// (45, -166) @TEXT("Shared enable / sampling assist", size=1.7);
// #MSHBN @PLACE(224, -188) => @ORIENT("R0");
// #MSHBN @SET-SYMBOL $NMOS;
// #MSHBN @TEXT("ULVT 8u", key="model", size=1.7, dx=1.5, dy=-1);
// #MSHBN @TEXT("MSHBN", key="name", size=1.7, dx=1.5, dy=1);
// #MSHBP @PLACE(248, -188) => @ORIENT("MX");
// #MSHBP @SET-SYMBOL $PMOS;
// #MSHBP @TEXT("ULVT 16u", key="model", size=1.7, dx=1.5, dy=-1);
// #MSHBP @TEXT("MSHBP", key="name", size=1.7, dx=1.5, dy=1);
// #C_SAMPLOAD @PLACE(224, -216) => @ORIENT("MX");
// #C_SAMPLOAD @TEXT("", key="value");
// #C_SAMPLOAD @TEXT("", key="name");
// (226, -215) @TEXT("C_SAMPLOAD", size=1.7);
// (226, -217) @TEXT("50 Cu", size=1.7);
// #CP_SAMPLOAD @PLACE(248, -216) => @ORIENT("R0");
// #CP_SAMPLOAD @TEXT("", key="value");
// #CP_SAMPLOAD @TEXT("", key="name");
// (250, -215) @TEXT("CP_SAMPLOAD", size=1.7);
// (250, -217) @TEXT("2.506 fF / 5%", size=1.7);
// &SAMP_ON @WIRE {#MSHBN:1 (224, -180) (248, -180) #MSHBP:1};
// (224, -176) @TEXT("SAMP_ON control load", size=1.7);
// (45, -225) @TEXT("All bottom and midpoint switches reside in this module.", size=1.7);
// (45, -229) @TEXT("j9 / j6: EN = DVDD, ENB = VREFN; no sampling switch.", size=1.7);
// &VIN @WIRE {#XSW12:1 (-20, 14)};
// (-20.3, 14) @TEXT("VIN", size=1.7, halign="end", valign="middle");
// &VG @WIRE {#XSW12:2 (-20, 11)};
// (-20.3, 11) @TEXT("VG", size=1.7, halign="end", valign="middle");
// &DH12 @WIRE {#XSW12:3 (-20, 8)};
// (-20.3, 8) @TEXT("DH12", size=1.7, halign="end", valign="middle");
// &RL12 @WIRE {#XSW12:4 (-20, 5)};
// (-20.3, 5) @TEXT("RL12", size=1.7, halign="end", valign="middle");
// &EN @WIRE {#XSW12:5 (-20, 2)};
// (-20.3, 2) @TEXT("EN", size=1.7, halign="end", valign="middle");
// &ENB @WIRE {#XSW12:6 (-20, -1)};
// (-20.3, -1) @TEXT("ENB", size=1.7, halign="end", valign="middle");
// &EQBUS @WIRE {#XSW12:11 (-20, -4)};
// (-20.3, -4) @TEXT("EQBUS", size=1.7, halign="end", valign="middle");
// &APGATE @WIRE {#XSW12:12 (-20, -7)};
// (-20.3, -7) @TEXT("APGATE", size=1.7, halign="end", valign="middle");
// &SAMP_ON @WIRE {#XSW12:13 (-20, -10)};
// (-20.3, -10) @TEXT("SAMP_ON", size=1.7, halign="end", valign="middle");
// &BPH12 @WIRE {#XSW12:14 (20, 8)};
// (20.3, 8) @TEXT("BPH12", size=1.7, halign="start", valign="middle");
// &BPL12 @WIRE {#XSW12:15 (20, -8)};
// (20.3, -8) @TEXT("BPL12", size=1.7, halign="start", valign="middle");
// %t12 = $SUPPLY @ATTACH &DVDD => @PLACE(-6, 23);
// &DVDD @WIRE {#XSW12:10 %t12:p};
// %t13 = $SUPPLY @ATTACH &VREFP => @PLACE(6, 23);
// &VREFP @WIRE {#XSW12:7 %t13:p};
// %t14 = $GROUND @ATTACH &VREFN => @PLACE(-6, -23);
// &VREFN @WIRE {#XSW12:8 %t14:p};
// %t15 = $GROUND @ATTACH &VSS => @PLACE(6, -23);
// &VSS @WIRE {#XSW12:9 %t15:p};
// &VIN @WIRE {#XSW11:1 (54, 14)};
// (53.7, 14) @TEXT("VIN", size=1.7, halign="end", valign="middle");
// &VG @WIRE {#XSW11:2 (54, 11)};
// (53.7, 11) @TEXT("VG", size=1.7, halign="end", valign="middle");
// &DH11 @WIRE {#XSW11:3 (54, 8)};
// (53.7, 8) @TEXT("DH11", size=1.7, halign="end", valign="middle");
// &RL11 @WIRE {#XSW11:4 (54, 5)};
// (53.7, 5) @TEXT("RL11", size=1.7, halign="end", valign="middle");
// &EN @WIRE {#XSW11:5 (54, 2)};
// (53.7, 2) @TEXT("EN", size=1.7, halign="end", valign="middle");
// &ENB @WIRE {#XSW11:6 (54, -1)};
// (53.7, -1) @TEXT("ENB", size=1.7, halign="end", valign="middle");
// &EQBUS @WIRE {#XSW11:11 (54, -4)};
// (53.7, -4) @TEXT("EQBUS", size=1.7, halign="end", valign="middle");
// &APGATE @WIRE {#XSW11:12 (54, -7)};
// (53.7, -7) @TEXT("APGATE", size=1.7, halign="end", valign="middle");
// &SAMP_ON @WIRE {#XSW11:13 (54, -10)};
// (53.7, -10) @TEXT("SAMP_ON", size=1.7, halign="end", valign="middle");
// &BPH11 @WIRE {#XSW11:14 (94, 8)};
// (94.3, 8) @TEXT("BPH11", size=1.7, halign="start", valign="middle");
// &BPL11 @WIRE {#XSW11:15 (94, -8)};
// (94.3, -8) @TEXT("BPL11", size=1.7, halign="start", valign="middle");
// %t27 = $SUPPLY @ATTACH &DVDD => @PLACE(68, 23);
// &DVDD @WIRE {#XSW11:10 %t27:p};
// %t28 = $SUPPLY @ATTACH &VREFP => @PLACE(80, 23);
// &VREFP @WIRE {#XSW11:7 %t28:p};
// %t29 = $GROUND @ATTACH &VREFN => @PLACE(68, -23);
// &VREFN @WIRE {#XSW11:8 %t29:p};
// %t30 = $GROUND @ATTACH &VSS => @PLACE(80, -23);
// &VSS @WIRE {#XSW11:9 %t30:p};
// &VIN @WIRE {#XSW10:1 (128, 14)};
// (127.7, 14) @TEXT("VIN", size=1.7, halign="end", valign="middle");
// &VG @WIRE {#XSW10:2 (128, 11)};
// (127.7, 11) @TEXT("VG", size=1.7, halign="end", valign="middle");
// &DH10 @WIRE {#XSW10:3 (128, 8)};
// (127.7, 8) @TEXT("DH10", size=1.7, halign="end", valign="middle");
// &RL10 @WIRE {#XSW10:4 (128, 5)};
// (127.7, 5) @TEXT("RL10", size=1.7, halign="end", valign="middle");
// &EN @WIRE {#XSW10:5 (128, 2)};
// (127.7, 2) @TEXT("EN", size=1.7, halign="end", valign="middle");
// &ENB @WIRE {#XSW10:6 (128, -1)};
// (127.7, -1) @TEXT("ENB", size=1.7, halign="end", valign="middle");
// &EQBUS @WIRE {#XSW10:11 (128, -4)};
// (127.7, -4) @TEXT("EQBUS", size=1.7, halign="end", valign="middle");
// &APGATE @WIRE {#XSW10:12 (128, -7)};
// (127.7, -7) @TEXT("APGATE", size=1.7, halign="end", valign="middle");
// &SAMP_ON @WIRE {#XSW10:13 (128, -10)};
// (127.7, -10) @TEXT("SAMP_ON", size=1.7, halign="end", valign="middle");
// &BPH10 @WIRE {#XSW10:14 (168, 8)};
// (168.3, 8) @TEXT("BPH10", size=1.7, halign="start", valign="middle");
// &BPL10 @WIRE {#XSW10:15 (168, -8)};
// (168.3, -8) @TEXT("BPL10", size=1.7, halign="start", valign="middle");
// %t42 = $SUPPLY @ATTACH &DVDD => @PLACE(142, 23);
// &DVDD @WIRE {#XSW10:10 %t42:p};
// %t43 = $SUPPLY @ATTACH &VREFP => @PLACE(154, 23);
// &VREFP @WIRE {#XSW10:7 %t43:p};
// %t44 = $GROUND @ATTACH &VREFN => @PLACE(142, -23);
// &VREFN @WIRE {#XSW10:8 %t44:p};
// %t45 = $GROUND @ATTACH &VSS => @PLACE(154, -23);
// &VSS @WIRE {#XSW10:9 %t45:p};
// &DH9 @WIRE {#XSW9:1 (202, 14)};
// (201.7, 14) @TEXT("DH9", size=1.7, halign="end", valign="middle");
// &RL9 @WIRE {#XSW9:2 (202, 11)};
// (201.7, 11) @TEXT("RL9", size=1.7, halign="end", valign="middle");
// %t48 = $SUPPLY @ATTACH &DVDD => @PLACE(204, 10);
// &DVDD @WIRE {#XSW9:3 %t48:p};
// %t49 = $GROUND @ATTACH &VREFN => @PLACE(204, 3);
// &VREFN @WIRE {#XSW9:4 %t49:p};
// &BPH9 @WIRE {#XSW9:9 (242, 8)};
// (242.3, 8) @TEXT("BPH9", size=1.7, halign="start", valign="middle");
// &BPL9 @WIRE {#XSW9:10 (242, -8)};
// (242.3, -8) @TEXT("BPL9", size=1.7, halign="start", valign="middle");
// %t52 = $SUPPLY @ATTACH &DVDD => @PLACE(216, 23);
// &DVDD @WIRE {#XSW9:8 %t52:p};
// %t53 = $SUPPLY @ATTACH &VREFP => @PLACE(228, 23);
// &VREFP @WIRE {#XSW9:5 %t53:p};
// %t54 = $GROUND @ATTACH &VREFN => @PLACE(216, -23);
// &VREFN @WIRE {#XSW9:6 %t54:p};
// %t55 = $GROUND @ATTACH &VSS => @PLACE(228, -23);
// &VSS @WIRE {#XSW9:7 %t55:p};
// &VIN @WIRE {#XSW8:1 (-20, -51)};
// (-20.3, -51) @TEXT("VIN", size=1.7, halign="end", valign="middle");
// &VG @WIRE {#XSW8:2 (-20, -54)};
// (-20.3, -54) @TEXT("VG", size=1.7, halign="end", valign="middle");
// &DH8 @WIRE {#XSW8:3 (-20, -57)};
// (-20.3, -57) @TEXT("DH8", size=1.7, halign="end", valign="middle");
// &RL8 @WIRE {#XSW8:4 (-20, -60)};
// (-20.3, -60) @TEXT("RL8", size=1.7, halign="end", valign="middle");
// &EN @WIRE {#XSW8:5 (-20, -63)};
// (-20.3, -63) @TEXT("EN", size=1.7, halign="end", valign="middle");
// &ENB @WIRE {#XSW8:6 (-20, -66)};
// (-20.3, -66) @TEXT("ENB", size=1.7, halign="end", valign="middle");
// &EQBUS @WIRE {#XSW8:11 (-20, -69)};
// (-20.3, -69) @TEXT("EQBUS", size=1.7, halign="end", valign="middle");
// &APGATE @WIRE {#XSW8:12 (-20, -72)};
// (-20.3, -72) @TEXT("APGATE", size=1.7, halign="end", valign="middle");
// &SAMP_ON @WIRE {#XSW8:13 (-20, -75)};
// (-20.3, -75) @TEXT("SAMP_ON", size=1.7, halign="end", valign="middle");
// &BPH8 @WIRE {#XSW8:14 (20, -57)};
// (20.3, -57) @TEXT("BPH8", size=1.7, halign="start", valign="middle");
// &BPL8 @WIRE {#XSW8:15 (20, -73)};
// (20.3, -73) @TEXT("BPL8", size=1.7, halign="start", valign="middle");
// %t67 = $SUPPLY @ATTACH &DVDD => @PLACE(-6, -42);
// &DVDD @WIRE {#XSW8:10 %t67:p};
// %t68 = $SUPPLY @ATTACH &VREFP => @PLACE(6, -42);
// &VREFP @WIRE {#XSW8:7 %t68:p};
// %t69 = $GROUND @ATTACH &VREFN => @PLACE(-6, -88);
// &VREFN @WIRE {#XSW8:8 %t69:p};
// %t70 = $GROUND @ATTACH &VSS => @PLACE(6, -88);
// &VSS @WIRE {#XSW8:9 %t70:p};
// &VIN @WIRE {#XSW7:1 (54, -51)};
// (53.7, -51) @TEXT("VIN", size=1.7, halign="end", valign="middle");
// &VG @WIRE {#XSW7:2 (54, -54)};
// (53.7, -54) @TEXT("VG", size=1.7, halign="end", valign="middle");
// &DH7 @WIRE {#XSW7:3 (54, -57)};
// (53.7, -57) @TEXT("DH7", size=1.7, halign="end", valign="middle");
// &RL7 @WIRE {#XSW7:4 (54, -60)};
// (53.7, -60) @TEXT("RL7", size=1.7, halign="end", valign="middle");
// &EN @WIRE {#XSW7:5 (54, -63)};
// (53.7, -63) @TEXT("EN", size=1.7, halign="end", valign="middle");
// &ENB @WIRE {#XSW7:6 (54, -66)};
// (53.7, -66) @TEXT("ENB", size=1.7, halign="end", valign="middle");
// &PHI_S @WIRE {#XSW7:10 (54, -69)};
// (53.7, -69) @TEXT("PHI_S", size=1.7, halign="end", valign="middle");
// &APGATE @WIRE {#XSW7:12 (54, -72)};
// (53.7, -72) @TEXT("APGATE", size=1.7, halign="end", valign="middle");
// &EQBUS @WIRE {#XSW7:13 (54, -75)};
// (53.7, -75) @TEXT("EQBUS", size=1.7, halign="end", valign="middle");
// &APGATE @WIRE {#XSW7:14 (54, -78)};
// (53.7, -78) @TEXT("APGATE", size=1.7, halign="end", valign="middle");
// &SAMP_ON @WIRE {#XSW7:15 (54, -81)};
// (53.7, -81) @TEXT("SAMP_ON", size=1.7, halign="end", valign="middle");
// &BPH7 @WIRE {#XSW7:16 (94, -57)};
// (94.3, -57) @TEXT("BPH7", size=1.7, halign="start", valign="middle");
// &BPL7 @WIRE {#XSW7:17 (94, -73)};
// (94.3, -73) @TEXT("BPL7", size=1.7, halign="start", valign="middle");
// &MIDH7 @WIRE {#XSW7:18 (94, -62)};
// (94.3, -62) @TEXT("MIDH7", size=1.7, halign="start", valign="middle");
// &MIDL7 @WIRE {#XSW7:19 (94, -68)};
// (94.3, -68) @TEXT("MIDL7", size=1.7, halign="start", valign="middle");
// %t86 = $SUPPLY @ATTACH &DVDD => @PLACE(68, -42);
// &DVDD @WIRE {#XSW7:11 %t86:p};
// %t87 = $SUPPLY @ATTACH &VREFP => @PLACE(80, -42);
// &VREFP @WIRE {#XSW7:7 %t87:p};
// %t88 = $GROUND @ATTACH &VREFN => @PLACE(68, -88);
// &VREFN @WIRE {#XSW7:8 %t88:p};
// %t89 = $GROUND @ATTACH &VSS => @PLACE(80, -88);
// &VSS @WIRE {#XSW7:9 %t89:p};
// &DH6 @WIRE {#XSW6:1 (128, -51)};
// (127.7, -51) @TEXT("DH6", size=1.7, halign="end", valign="middle");
// &RL6 @WIRE {#XSW6:2 (128, -54)};
// (127.7, -54) @TEXT("RL6", size=1.7, halign="end", valign="middle");
// %t92 = $SUPPLY @ATTACH &DVDD => @PLACE(130, -55);
// &DVDD @WIRE {#XSW6:3 %t92:p};
// %t93 = $GROUND @ATTACH &VREFN => @PLACE(130, -62);
// &VREFN @WIRE {#XSW6:4 %t93:p};
// &BPH6 @WIRE {#XSW6:9 (168, -57)};
// (168.3, -57) @TEXT("BPH6", size=1.7, halign="start", valign="middle");
// &BPL6 @WIRE {#XSW6:10 (168, -73)};
// (168.3, -73) @TEXT("BPL6", size=1.7, halign="start", valign="middle");
// %t96 = $SUPPLY @ATTACH &DVDD => @PLACE(142, -42);
// &DVDD @WIRE {#XSW6:8 %t96:p};
// %t97 = $SUPPLY @ATTACH &VREFP => @PLACE(154, -42);
// &VREFP @WIRE {#XSW6:5 %t97:p};
// %t98 = $GROUND @ATTACH &VREFN => @PLACE(142, -88);
// &VREFN @WIRE {#XSW6:6 %t98:p};
// %t99 = $GROUND @ATTACH &VSS => @PLACE(154, -88);
// &VSS @WIRE {#XSW6:7 %t99:p};
// &VIN @WIRE {#XSW5:1 (202, -51)};
// (201.7, -51) @TEXT("VIN", size=1.7, halign="end", valign="middle");
// &VG @WIRE {#XSW5:2 (202, -54)};
// (201.7, -54) @TEXT("VG", size=1.7, halign="end", valign="middle");
// &DH5 @WIRE {#XSW5:3 (202, -57)};
// (201.7, -57) @TEXT("DH5", size=1.7, halign="end", valign="middle");
// &RL5 @WIRE {#XSW5:4 (202, -60)};
// (201.7, -60) @TEXT("RL5", size=1.7, halign="end", valign="middle");
// &EN @WIRE {#XSW5:5 (202, -63)};
// (201.7, -63) @TEXT("EN", size=1.7, halign="end", valign="middle");
// &ENB @WIRE {#XSW5:6 (202, -66)};
// (201.7, -66) @TEXT("ENB", size=1.7, halign="end", valign="middle");
// &EQBUS @WIRE {#XSW5:11 (202, -69)};
// (201.7, -69) @TEXT("EQBUS", size=1.7, halign="end", valign="middle");
// &APGATE @WIRE {#XSW5:12 (202, -72)};
// (201.7, -72) @TEXT("APGATE", size=1.7, halign="end", valign="middle");
// &SAMP_ON @WIRE {#XSW5:13 (202, -75)};
// (201.7, -75) @TEXT("SAMP_ON", size=1.7, halign="end", valign="middle");
// &BPH5 @WIRE {#XSW5:14 (242, -57)};
// (242.3, -57) @TEXT("BPH5", size=1.7, halign="start", valign="middle");
// &BPL5 @WIRE {#XSW5:15 (242, -73)};
// (242.3, -73) @TEXT("BPL5", size=1.7, halign="start", valign="middle");
// %t111 = $SUPPLY @ATTACH &DVDD => @PLACE(216, -42);
// &DVDD @WIRE {#XSW5:10 %t111:p};
// %t112 = $SUPPLY @ATTACH &VREFP => @PLACE(228, -42);
// &VREFP @WIRE {#XSW5:7 %t112:p};
// %t113 = $GROUND @ATTACH &VREFN => @PLACE(216, -88);
// &VREFN @WIRE {#XSW5:8 %t113:p};
// %t114 = $GROUND @ATTACH &VSS => @PLACE(228, -88);
// &VSS @WIRE {#XSW5:9 %t114:p};
// &VIN @WIRE {#XSW4:1 (-20, -116)};
// (-20.3, -116) @TEXT("VIN", size=1.7, halign="end", valign="middle");
// &VG @WIRE {#XSW4:2 (-20, -119)};
// (-20.3, -119) @TEXT("VG", size=1.7, halign="end", valign="middle");
// &DH4 @WIRE {#XSW4:3 (-20, -122)};
// (-20.3, -122) @TEXT("DH4", size=1.7, halign="end", valign="middle");
// &RL4 @WIRE {#XSW4:4 (-20, -125)};
// (-20.3, -125) @TEXT("RL4", size=1.7, halign="end", valign="middle");
// &EN @WIRE {#XSW4:5 (-20, -128)};
// (-20.3, -128) @TEXT("EN", size=1.7, halign="end", valign="middle");
// &ENB @WIRE {#XSW4:6 (-20, -131)};
// (-20.3, -131) @TEXT("ENB", size=1.7, halign="end", valign="middle");
// &EQBUS @WIRE {#XSW4:11 (-20, -134)};
// (-20.3, -134) @TEXT("EQBUS", size=1.7, halign="end", valign="middle");
// &APGATE @WIRE {#XSW4:12 (-20, -137)};
// (-20.3, -137) @TEXT("APGATE", size=1.7, halign="end", valign="middle");
// &SAMP_ON @WIRE {#XSW4:13 (-20, -140)};
// (-20.3, -140) @TEXT("SAMP_ON", size=1.7, halign="end", valign="middle");
// &BPH4 @WIRE {#XSW4:14 (20, -122)};
// (20.3, -122) @TEXT("BPH4", size=1.7, halign="start", valign="middle");
// &BPL4 @WIRE {#XSW4:15 (20, -138)};
// (20.3, -138) @TEXT("BPL4", size=1.7, halign="start", valign="middle");
// %t126 = $SUPPLY @ATTACH &DVDD => @PLACE(-6, -107);
// &DVDD @WIRE {#XSW4:10 %t126:p};
// %t127 = $SUPPLY @ATTACH &VREFP => @PLACE(6, -107);
// &VREFP @WIRE {#XSW4:7 %t127:p};
// %t128 = $GROUND @ATTACH &VREFN => @PLACE(-6, -153);
// &VREFN @WIRE {#XSW4:8 %t128:p};
// %t129 = $GROUND @ATTACH &VSS => @PLACE(6, -153);
// &VSS @WIRE {#XSW4:9 %t129:p};
// &VIN @WIRE {#XSW3:1 (54, -116)};
// (53.7, -116) @TEXT("VIN", size=1.7, halign="end", valign="middle");
// &VG @WIRE {#XSW3:2 (54, -119)};
// (53.7, -119) @TEXT("VG", size=1.7, halign="end", valign="middle");
// &DH3 @WIRE {#XSW3:3 (54, -122)};
// (53.7, -122) @TEXT("DH3", size=1.7, halign="end", valign="middle");
// &RL3 @WIRE {#XSW3:4 (54, -125)};
// (53.7, -125) @TEXT("RL3", size=1.7, halign="end", valign="middle");
// &EN @WIRE {#XSW3:5 (54, -128)};
// (53.7, -128) @TEXT("EN", size=1.7, halign="end", valign="middle");
// &ENB @WIRE {#XSW3:6 (54, -131)};
// (53.7, -131) @TEXT("ENB", size=1.7, halign="end", valign="middle");
// &EQBUS @WIRE {#XSW3:11 (54, -134)};
// (53.7, -134) @TEXT("EQBUS", size=1.7, halign="end", valign="middle");
// &APGATE @WIRE {#XSW3:12 (54, -137)};
// (53.7, -137) @TEXT("APGATE", size=1.7, halign="end", valign="middle");
// &SAMP_ON @WIRE {#XSW3:13 (54, -140)};
// (53.7, -140) @TEXT("SAMP_ON", size=1.7, halign="end", valign="middle");
// &BPH3 @WIRE {#XSW3:14 (94, -122)};
// (94.3, -122) @TEXT("BPH3", size=1.7, halign="start", valign="middle");
// &BPL3 @WIRE {#XSW3:15 (94, -138)};
// (94.3, -138) @TEXT("BPL3", size=1.7, halign="start", valign="middle");
// %t141 = $SUPPLY @ATTACH &DVDD => @PLACE(68, -107);
// &DVDD @WIRE {#XSW3:10 %t141:p};
// %t142 = $SUPPLY @ATTACH &VREFP => @PLACE(80, -107);
// &VREFP @WIRE {#XSW3:7 %t142:p};
// %t143 = $GROUND @ATTACH &VREFN => @PLACE(68, -153);
// &VREFN @WIRE {#XSW3:8 %t143:p};
// %t144 = $GROUND @ATTACH &VSS => @PLACE(80, -153);
// &VSS @WIRE {#XSW3:9 %t144:p};
// &VIN @WIRE {#XSW2:1 (128, -116)};
// (127.7, -116) @TEXT("VIN", size=1.7, halign="end", valign="middle");
// &VG @WIRE {#XSW2:2 (128, -119)};
// (127.7, -119) @TEXT("VG", size=1.7, halign="end", valign="middle");
// &DH2 @WIRE {#XSW2:3 (128, -122)};
// (127.7, -122) @TEXT("DH2", size=1.7, halign="end", valign="middle");
// &RL2 @WIRE {#XSW2:4 (128, -125)};
// (127.7, -125) @TEXT("RL2", size=1.7, halign="end", valign="middle");
// &EN @WIRE {#XSW2:5 (128, -128)};
// (127.7, -128) @TEXT("EN", size=1.7, halign="end", valign="middle");
// &ENB @WIRE {#XSW2:6 (128, -131)};
// (127.7, -131) @TEXT("ENB", size=1.7, halign="end", valign="middle");
// &PHI_S @WIRE {#XSW2:10 (128, -134)};
// (127.7, -134) @TEXT("PHI_S", size=1.7, halign="end", valign="middle");
// &APGATE @WIRE {#XSW2:12 (128, -137)};
// (127.7, -137) @TEXT("APGATE", size=1.7, halign="end", valign="middle");
// &EQBUS @WIRE {#XSW2:13 (128, -140)};
// (127.7, -140) @TEXT("EQBUS", size=1.7, halign="end", valign="middle");
// &APGATE @WIRE {#XSW2:14 (128, -143)};
// (127.7, -143) @TEXT("APGATE", size=1.7, halign="end", valign="middle");
// &SAMP_ON @WIRE {#XSW2:15 (128, -146)};
// (127.7, -146) @TEXT("SAMP_ON", size=1.7, halign="end", valign="middle");
// &BPH2 @WIRE {#XSW2:16 (168, -122)};
// (168.3, -122) @TEXT("BPH2", size=1.7, halign="start", valign="middle");
// &BPL2 @WIRE {#XSW2:17 (168, -138)};
// (168.3, -138) @TEXT("BPL2", size=1.7, halign="start", valign="middle");
// &MIDH2 @WIRE {#XSW2:18 (168, -127)};
// (168.3, -127) @TEXT("MIDH2", size=1.7, halign="start", valign="middle");
// &MIDL2 @WIRE {#XSW2:19 (168, -133)};
// (168.3, -133) @TEXT("MIDL2", size=1.7, halign="start", valign="middle");
// %t160 = $SUPPLY @ATTACH &DVDD => @PLACE(142, -107);
// &DVDD @WIRE {#XSW2:11 %t160:p};
// %t161 = $SUPPLY @ATTACH &VREFP => @PLACE(154, -107);
// &VREFP @WIRE {#XSW2:7 %t161:p};
// %t162 = $GROUND @ATTACH &VREFN => @PLACE(142, -153);
// &VREFN @WIRE {#XSW2:8 %t162:p};
// %t163 = $GROUND @ATTACH &VSS => @PLACE(154, -153);
// &VSS @WIRE {#XSW2:9 %t163:p};
// &VIN @WIRE {#XSW1:1 (202, -116)};
// (201.7, -116) @TEXT("VIN", size=1.7, halign="end", valign="middle");
// &VG @WIRE {#XSW1:2 (202, -119)};
// (201.7, -119) @TEXT("VG", size=1.7, halign="end", valign="middle");
// &DH1 @WIRE {#XSW1:3 (202, -122)};
// (201.7, -122) @TEXT("DH1", size=1.7, halign="end", valign="middle");
// &RL1 @WIRE {#XSW1:4 (202, -125)};
// (201.7, -125) @TEXT("RL1", size=1.7, halign="end", valign="middle");
// &EN @WIRE {#XSW1:5 (202, -128)};
// (201.7, -128) @TEXT("EN", size=1.7, halign="end", valign="middle");
// &ENB @WIRE {#XSW1:6 (202, -131)};
// (201.7, -131) @TEXT("ENB", size=1.7, halign="end", valign="middle");
// &EQBUS @WIRE {#XSW1:11 (202, -134)};
// (201.7, -134) @TEXT("EQBUS", size=1.7, halign="end", valign="middle");
// &APGATE @WIRE {#XSW1:12 (202, -137)};
// (201.7, -137) @TEXT("APGATE", size=1.7, halign="end", valign="middle");
// &SAMP_ON @WIRE {#XSW1:13 (202, -140)};
// (201.7, -140) @TEXT("SAMP_ON", size=1.7, halign="end", valign="middle");
// &BPH1 @WIRE {#XSW1:14 (242, -122)};
// (242.3, -122) @TEXT("BPH1", size=1.7, halign="start", valign="middle");
// &BPL1 @WIRE {#XSW1:15 (242, -138)};
// (242.3, -138) @TEXT("BPL1", size=1.7, halign="start", valign="middle");
// %t175 = $SUPPLY @ATTACH &DVDD => @PLACE(216, -107);
// &DVDD @WIRE {#XSW1:10 %t175:p};
// %t176 = $SUPPLY @ATTACH &VREFP => @PLACE(228, -107);
// &VREFP @WIRE {#XSW1:7 %t176:p};
// %t177 = $GROUND @ATTACH &VREFN => @PLACE(216, -153);
// &VREFN @WIRE {#XSW1:8 %t177:p};
// %t178 = $GROUND @ATTACH &VSS => @PLACE(228, -153);
// &VSS @WIRE {#XSW1:9 %t178:p};
// &VIN @WIRE {#XSW0:1 (-20, -181)};
// (-20.3, -181) @TEXT("VIN", size=1.7, halign="end", valign="middle");
// &VG @WIRE {#XSW0:2 (-20, -184)};
// (-20.3, -184) @TEXT("VG", size=1.7, halign="end", valign="middle");
// &DH0 @WIRE {#XSW0:3 (-20, -187)};
// (-20.3, -187) @TEXT("DH0", size=1.7, halign="end", valign="middle");
// &RL0 @WIRE {#XSW0:4 (-20, -190)};
// (-20.3, -190) @TEXT("RL0", size=1.7, halign="end", valign="middle");
// &EN @WIRE {#XSW0:5 (-20, -193)};
// (-20.3, -193) @TEXT("EN", size=1.7, halign="end", valign="middle");
// &ENB @WIRE {#XSW0:6 (-20, -196)};
// (-20.3, -196) @TEXT("ENB", size=1.7, halign="end", valign="middle");
// &PHI_S @WIRE {#XSW0:10 (-20, -199)};
// (-20.3, -199) @TEXT("PHI_S", size=1.7, halign="end", valign="middle");
// &APGATE @WIRE {#XSW0:12 (-20, -202)};
// (-20.3, -202) @TEXT("APGATE", size=1.7, halign="end", valign="middle");
// &EQBUS @WIRE {#XSW0:13 (-20, -205)};
// (-20.3, -205) @TEXT("EQBUS", size=1.7, halign="end", valign="middle");
// &APGATE @WIRE {#XSW0:14 (-20, -208)};
// (-20.3, -208) @TEXT("APGATE", size=1.7, halign="end", valign="middle");
// &SAMP_ON @WIRE {#XSW0:15 (-20, -211)};
// (-20.3, -211) @TEXT("SAMP_ON", size=1.7, halign="end", valign="middle");
// &BPH0 @WIRE {#XSW0:16 (20, -187)};
// (20.3, -187) @TEXT("BPH0", size=1.7, halign="start", valign="middle");
// &BPL0 @WIRE {#XSW0:17 (20, -203)};
// (20.3, -203) @TEXT("BPL0", size=1.7, halign="start", valign="middle");
// &MIDH0 @WIRE {#XSW0:18 (20, -192)};
// (20.3, -192) @TEXT("MIDH0", size=1.7, halign="start", valign="middle");
// &MIDL0 @WIRE {#XSW0:19 (20, -198)};
// (20.3, -198) @TEXT("MIDL0", size=1.7, halign="start", valign="middle");
// %t194 = $SUPPLY @ATTACH &DVDD => @PLACE(-6, -172);
// &DVDD @WIRE {#XSW0:11 %t194:p};
// %t195 = $SUPPLY @ATTACH &VREFP => @PLACE(6, -172);
// &VREFP @WIRE {#XSW0:7 %t195:p};
// %t196 = $GROUND @ATTACH &VREFN => @PLACE(-6, -218);
// &VREFN @WIRE {#XSW0:8 %t196:p};
// %t197 = $GROUND @ATTACH &VSS => @PLACE(6, -218);
// &VSS @WIRE {#XSW0:9 %t197:p};
// &CONV @WIRE {#XEN:1 (63, -195)};
// (62.7, -195) @TEXT("CONV", size=1.7, halign="end", valign="middle");
// &EN @WIRE {#XEN:2 (89, -192)};
// (89.3, -192) @TEXT("EN", size=1.7, halign="start", valign="middle");
// &ENB @WIRE {#XEN:3 (89, -198)};
// (89.3, -198) @TEXT("ENB", size=1.7, halign="start", valign="middle");
// %t201 = $SUPPLY @ATTACH &DVDD => @PLACE(70, -182);
// &DVDD @WIRE {#XEN:4 %t201:p};
// %t202 = $GROUND @ATTACH &VREFN => @PLACE(70, -208);
// &VREFN @WIRE {#XEN:5 %t202:p};
// %t203 = $GROUND @ATTACH &VSS => @PLACE(80, -208);
// &VSS @WIRE {#XEN:6 %t203:p};
// &PHI_S @WIRE {#XAPULSE:1 (131, -191)};
// (130.7, -191) @TEXT("PHI_S", size=1.7, halign="end", valign="middle");
// &PHI_SB @WIRE {#XAPULSE:2 (131, -199)};
// (130.7, -199) @TEXT("PHI_SB", size=1.7, halign="end", valign="middle");
// &APGATE @WIRE {#XAPULSE:3 (159, -195)};
// (159.3, -195) @TEXT("APGATE", size=1.7, halign="start", valign="middle");
// %t207 = $SUPPLY @ATTACH &DVDD => @PLACE(140, -182);
// &DVDD @WIRE {#XAPULSE:4 %t207:p};
// %t208 = $SUPPLY @ATTACH &VREFP => @PLACE(150, -182);
// &VREFP @WIRE {#XAPULSE:7 %t208:p};
// %t209 = $GROUND @ATTACH &VREFN => @PLACE(140, -208);
// &VREFN @WIRE {#XAPULSE:5 %t209:p};
// %t210 = $GROUND @ATTACH &VSS => @PLACE(150, -208);
// &VSS @WIRE {#XAPULSE:6 %t210:p};
// &PHI_SB @WIRE {#MSHBN:2 (219, -188)};
// (218.7, -188) @TEXT("PHI_SB", size=1.7, halign="end", valign="middle");
// %t212 = $GROUND @ATTACH &VREFN => @PLACE(224, -192);
// &VREFN @WIRE {#MSHBN:3 %t212:p};
// &PHI_SB @WIRE {#MSHBP:2 (243, -188)};
// (242.7, -188) @TEXT("PHI_SB", size=1.7, halign="end", valign="middle");
// %t214 = $SUPPLY @ATTACH &DVDD => @PLACE(248, -188);
// &DVDD @WIRE {#MSHBP:3 %t214:p};
// %t215 = $GROUND @ATTACH &VSS => @PLACE(224, -220);
// &VSS @WIRE {#C_SAMPLOAD:1 %t215:p};
// &SAMP_ON @WIRE {#C_SAMPLOAD:2 (224, -212)};
// (224, -211.6) @TEXT("SAMP_ON", size=1.7, halign="middle", valign="bottom");
// &SAMP_ON @WIRE {#CP_SAMPLOAD:1 (248, -212)};
// (248, -211.6) @TEXT("SAMP_ON", size=1.7, halign="middle", valign="bottom");
// %t218 = $GROUND @ATTACH &VSS => @PLACE(248, -220);
// &VSS @WIRE {#CP_SAMPLOAD:2 %t218:p};
// (-24, 34) @TEXT("V29 / WIP | switch array | per-bit reference and sampling control", size=1.7, bold=true, textcolor="#17365d");
// }
ends mq_cdac_switch_array

subckt mq_cdac_reset_booster (CLKB BST DVDD VB VSS)
MPINV (CBOT CLKB DVDD DVDD) pch_ulvt_mac w=1.6e-07 l=6e-08 nf=1
MNINV (CBOT CLKB VSS VSS) nch_ulvt_mac w=1.2e-06 l=3e-08 nf=1
M1 (BST DVDD CBOT VSS) nch_ulvt_mac w=9.6e-07 l=3e-08 nf=1
M2 (BST VB VCB VCB) pch_ulvt_mac w=2.4e-07 l=4e-08 nf=1
M3 (VB BST VCB VCB) pch_ulvt_mac w=2.4e-07 l=3e-08 nf=1
CBOOST (VCB CBOT) cfmom_2t w=5e-08 s=2.4e-07 nr=6 lr=1.69e-06 stm=2 spm=4 multi=40
CP_BOOST (CBOT VSS) capacitor c=2.00458e-15
// @RNL {
// {&CLKB &BST &DVDD &VB &VSS} @REMOVE-FROM $PORT_FILL_SET;
// #MPINV @SET-SYMBOL $PMOS_4TERM => @PLACE(0,12);
// #MNINV @SET-SYMBOL $NMOS_4TERM => @PLACE(0,-12);
// #M1 @SET-SYMBOL $NMOS_4TERM => @PLACE(32,0) => @ORIENT("R270");
// #M2 @SET-SYMBOL $PMOS_4TERM => @PLACE(32,14) => @ORIENT("R90");
// #M3 @SET-SYMBOL $PMOS_4TERM => @PLACE(14,28) => @ORIENT("R180");
// #CBOOST @PLACE(14,12);
// #CP_BOOST @PLACE(14,-12);
// %clki = (-10,0);
// &CLKB @WIRE {(-19,0) %clki (-10,12) #MPINV:g};
// &CLKB @WIRE {%clki (-10,-12) #MNINV:g};
// $JUNCTION @ATTACH %clki;
// (-19.5,0) @TEXT("CLKB", size=1, halign="end", valign="middle");
// %inv = (0,0);
// %cbot = (14,0);
// &CBOT @WIRE {#MPINV:d %inv #MNINV:d};
// &CBOT @WIRE {%inv %cbot #M1:s};
// &CBOT @WIRE {#CBOOST:2 %cbot #CP_BOOST:1};
// $JUNCTION @ATTACH %inv;
// $JUNCTION @ATTACH %cbot;
// %vcb = (14,20);
// &VCB @WIRE {#CBOOST:1 %vcb #M3:s};
// &VCB @WIRE {#CBOOST:1 #M2:s};
// &VCB @WIRE {#M2:b (32,20) %vcb (9,20) (9,28) #M3:b};
// $JUNCTION @ATTACH %vcb;
// %bsthi = (44,14);
// %bstlo = (44,0);
// &BST @WIRE {#M3:g (44,28) %bsthi %bstlo (53,0)};
// &BST @WIRE {#M2:d %bsthi};
// &BST @WIRE {#M1:d %bstlo};
// $JUNCTION @ATTACH %bsthi;
// $JUNCTION @ATTACH %bstlo;
// (53.5,0) @TEXT("BST", size=1, valign="middle");
// %vddinv = (0,20);
// $SUPPLY @ATTACH &DVDD => @PLACE(0,24) => %vddp;
// &DVDD @WIRE {#MPINV:s %vddinv %vddp:p};
// &DVDD @WIRE {#MPINV:b (4,12) (4,20) %vddinv};
// $JUNCTION @ATTACH %vddinv;
// $SUPPLY @ATTACH #M1:g;
// $SUPPLY @ATTACH #M2:g;
// $SUPPLY @ATTACH &VB => @PLACE(14,35) => %bias;
// &VB @WIRE {#M3:d %bias:p};
// $GROUND @ATTACH #MNINV:s;
// $GROUND @ATTACH #MNINV:b;
// $GROUND @ATTACH #M1:b;
// $GROUND @ATTACH #CP_BOOST:2;
// (-19,40) @TEXT("Fig. 11(c) reset booster", size=1.3, bold=true);
// (-19,-22) @TEXT("The inverter PMOS limits the rise. M1 provides a separate discharge path.", size=0.9);
// (-19,-26) @TEXT("M2 and M3 use the boosted well node VCB. CB includes the 5% bottom-plate estimate.", size=0.9);
// }
ends mq_cdac_reset_booster
