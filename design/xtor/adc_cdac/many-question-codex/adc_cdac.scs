// CDAC: physical unit MOM banks, MOS switches, and user-specified parasitic estimates.
// @RNL(type="header") {
//   @VERSION("0.3");
//   @USE-PACKAGE(name="adc28", version="0.1", path="../../../rnl/adc28.rnl");
// }
// @RNL {
//   # @SELECT-INSTANCE(model="mq_cdac_ctl_l") => @SET-SYMBOL $INVERTER;
//   # @SELECT-INSTANCE(model="mq_cdac_ctl_h") => @SET-SYMBOL $BUFFER;
//   $DRAW_mq_cdac_enable = @DEFINE-SYMBOL {
//     @LINE {(-10, 0) (-6, 0)};
//     @LINE {(-6, 2) (-2, 0) (-6, -2) (-6, 2)};
//     (-1.3,0) @CIRCLE(radius=0.7);
//     @LINE {(-0.6, 0) (2, 0) (2, -3) (12, -3)};
//     @LINE {(2, 0) (2, 3) (4, 3)};
//     @LINE {(4, 5) (8, 3) (4, 1) (4, 5)};
//     (8.7,3) @CIRCLE(radius=0.7);
//     @LINE {(9.4, 3) (12, 3)};
//     (0, -6) @TEXT("EN + complement", size=1.05, halign="middle");
//     @LINE {(-5, 11) (-5, 9)};
//     @LINE {(-5, -11) (-5, -9)};
//     @LINE {(5, -11) (5, -9)};
//     (-10, 0) @PIN(terminal=1, direction="left");
//     (12, 3) @PIN(terminal=2, direction="right");
//     (12, -3) @PIN(terminal=3, direction="right");
//     (-5, 11) @PIN(terminal=4, direction="up");
//     (-5, -11) @PIN(terminal=5, direction="down");
//     (5, -11) @PIN(terminal=6, direction="down");
//     ? @TEXT("${name}", key="name", size=0.9, bold=true) => @PLACE(-7, 11);
//   };
//   # @SELECT-INSTANCE(model="mq_cdac_enable") => @SET-SYMBOL $DRAW_mq_cdac_enable;
//   $DRAW_mq_cdac_drv12 = @DEFINE-SYMBOL {
//     @LINE {(-4, 6) (5, 2) (-4, -2) (-4, 6)};
//     (5.7,2) @CIRCLE(radius=0.7);
//     @LINE {(6.4, 2) (9, 2)};
//     (0, 1) @TEXT("REF", size=1.05, halign="middle");
//     (0, -6.8) @TEXT("EN / high-Z", size=1.05, halign="middle");
//     (-8, 2) @PIN(terminal=1, direction="left");
//     @LINE {(-8, 2) (-5, 2)};
//     (-4.8, 2) @TEXT("HIB", size=1.05, halign="start", valign="middle");
//     (-8, -2) @PIN(terminal=2, direction="left");
//     @LINE {(-8, -2) (-5, -2)};
//     (-4.8, -2) @TEXT("EN", size=1.05, halign="start", valign="middle");
//     (-8, -5) @PIN(terminal=3, direction="left");
//     @LINE {(-8, -5) (-5, -5)};
//     (-4.8, -5) @TEXT("ENB", size=1.05, halign="start", valign="middle");
//     (9, 2) @PIN(terminal=4, direction="right");
//     (9, 1) @TEXT("BP", size=1.05, halign="middle");
//     (3, 9) @PIN(terminal=5, direction="up");
//     (3, 8) @TEXT("VREFP", size=1.05, halign="middle");
//     (3, -9) @PIN(terminal=6, direction="down");
//     (3, -8) @TEXT("VREFN", size=1.05, halign="middle");
//     (-3, -9) @PIN(terminal=7, direction="down");
//     (-3, -8) @TEXT("VSS", size=1.05, halign="middle");
//     (-3, 9) @PIN(terminal=8, direction="up");
//     (-3, 8) @TEXT("DVDD", size=1.05, halign="middle");
//     ? @TEXT("${name}", key="name", size=0.9, bold=true) => @PLACE(-7, 11);
//   };
//   # @SELECT-INSTANCE(model="mq_cdac_drv12") => @SET-SYMBOL $DRAW_mq_cdac_drv12;
//   $DRAW_mq_cdac_bit12 = @DEFINE-SYMBOL {
//     @LINE(linestyle="dashed", linecolor="#a0aec0") {(-14,-13) (14,-13) (14,13) (-14,13) (-14,-13)};
//     @LINE {(-1, 4) (3, 4)};
//     @LINE {(3, 2.6) (3, 5.4)};
//     @LINE {(4, 2.6) (4, 5.4)};
//     @LINE {(4, 4) (10, 4)};
//     @LINE {(-1, 4) (-3, 4)};
//     @LINE {(-3, 4) (-5, 2.3)};
//     @LINE {(-6, 2) (-8, 2)};
//     @LINE {(-1, -3) (3, -3)};
//     @LINE {(3, -4.4) (3, -1.6)};
//     @LINE {(4, -4.4) (4, -1.6)};
//     @LINE {(4, -3) (10, -3)};
//     @LINE {(-1, -3) (-3, -3)};
//     @LINE {(-3, -3) (-5, -4.7)};
//     @LINE {(-6, -5) (-8, -5)};
//     @LINE {(10, -3) (10, 4)};
//     @LINE {(10, 0) (17, 0)};
//     (3, 9) @TEXT("w12 = 980", size=1.8, bold=true, halign="middle");
//     (3, -9) @TEXT("2 x 490 Cu", size=1.2, halign="middle");
//     (3, -11) @TEXT("sample + reference", size=1.05, halign="middle");
//     (-17, 10) @PIN(terminal=1, direction="left");
//     @LINE {(-17, 10) (-14, 10)};
//     (-13.7, 10) @TEXT("VIN", size=1.05, halign="start", valign="middle");
//     (-17, 8) @PIN(terminal=2, direction="left");
//     @LINE {(-17, 8) (-14, 8)};
//     (-13.7, 8) @TEXT("VG", size=1.05, halign="start", valign="middle");
//     (-17, 6) @PIN(terminal=3, direction="left");
//     @LINE {(-17, 6) (-14, 6)};
//     (-13.7, 6) @TEXT("DH", size=1.05, halign="start", valign="middle");
//     (-17, 4) @PIN(terminal=4, direction="left");
//     @LINE {(-17, 4) (-14, 4)};
//     (-13.7, 4) @TEXT("RL", size=1.05, halign="start", valign="middle");
//     (-17, 2) @PIN(terminal=5, direction="left");
//     @LINE {(-17, 2) (-14, 2)};
//     (-13.7, 2) @TEXT("EN", size=1.05, halign="start", valign="middle");
//     (-17, 0) @PIN(terminal=6, direction="left");
//     @LINE {(-17, 0) (-14, 0)};
//     (-13.7, 0) @TEXT("ENB", size=1.05, halign="start", valign="middle");
//     (-17, -2) @PIN(terminal=12, direction="left");
//     @LINE {(-17, -2) (-14, -2)};
//     (-13.7, -2) @TEXT("EQBUS", size=1.05, halign="start", valign="middle");
//     (-17, -4) @PIN(terminal=13, direction="left");
//     @LINE {(-17, -4) (-14, -4)};
//     (-13.7, -4) @TEXT("APGATE", size=1.05, halign="start", valign="middle");
//     (17, 0) @PIN(terminal=7, direction="right");
//     (-5, 15) @PIN(terminal=8, direction="up");
//     @LINE {(-5, 15) (-5, 13)};
//     (5, 15) @PIN(terminal=11, direction="up");
//     @LINE {(5, 15) (5, 13)};
//     (-5, -15) @PIN(terminal=9, direction="down");
//     @LINE {(-5, -15) (-5, -13)};
//     (5, -15) @PIN(terminal=10, direction="down");
//     @LINE {(5, -15) (5, -13)};
//     ? @TEXT("${name}", key="name", size=0.9, bold=true) => @PLACE(-7, 17);
//   };
//   # @SELECT-INSTANCE(model="mq_cdac_bit12") => @SET-SYMBOL $DRAW_mq_cdac_bit12;
//   $DRAW_mq_cdac_drv11 = @DEFINE-SYMBOL {
//     @LINE {(-4, 6) (5, 2) (-4, -2) (-4, 6)};
//     (5.7,2) @CIRCLE(radius=0.7);
//     @LINE {(6.4, 2) (9, 2)};
//     (0, 1) @TEXT("REF", size=1.05, halign="middle");
//     (0, -6.8) @TEXT("EN / high-Z", size=1.05, halign="middle");
//     (-8, 2) @PIN(terminal=1, direction="left");
//     @LINE {(-8, 2) (-5, 2)};
//     (-4.8, 2) @TEXT("HIB", size=1.05, halign="start", valign="middle");
//     (-8, -2) @PIN(terminal=2, direction="left");
//     @LINE {(-8, -2) (-5, -2)};
//     (-4.8, -2) @TEXT("EN", size=1.05, halign="start", valign="middle");
//     (-8, -5) @PIN(terminal=3, direction="left");
//     @LINE {(-8, -5) (-5, -5)};
//     (-4.8, -5) @TEXT("ENB", size=1.05, halign="start", valign="middle");
//     (9, 2) @PIN(terminal=4, direction="right");
//     (9, 1) @TEXT("BP", size=1.05, halign="middle");
//     (3, 9) @PIN(terminal=5, direction="up");
//     (3, 8) @TEXT("VREFP", size=1.05, halign="middle");
//     (3, -9) @PIN(terminal=6, direction="down");
//     (3, -8) @TEXT("VREFN", size=1.05, halign="middle");
//     (-3, -9) @PIN(terminal=7, direction="down");
//     (-3, -8) @TEXT("VSS", size=1.05, halign="middle");
//     (-3, 9) @PIN(terminal=8, direction="up");
//     (-3, 8) @TEXT("DVDD", size=1.05, halign="middle");
//     ? @TEXT("${name}", key="name", size=0.9, bold=true) => @PLACE(-7, 11);
//   };
//   # @SELECT-INSTANCE(model="mq_cdac_drv11") => @SET-SYMBOL $DRAW_mq_cdac_drv11;
//   $DRAW_mq_cdac_bit11 = @DEFINE-SYMBOL {
//     @LINE(linestyle="dashed", linecolor="#a0aec0") {(-14,-13) (14,-13) (14,13) (-14,13) (-14,-13)};
//     @LINE {(-1, 4) (3, 4)};
//     @LINE {(3, 2.6) (3, 5.4)};
//     @LINE {(4, 2.6) (4, 5.4)};
//     @LINE {(4, 4) (10, 4)};
//     @LINE {(-1, 4) (-3, 4)};
//     @LINE {(-3, 4) (-5, 2.3)};
//     @LINE {(-6, 2) (-8, 2)};
//     @LINE {(-1, -3) (3, -3)};
//     @LINE {(3, -4.4) (3, -1.6)};
//     @LINE {(4, -4.4) (4, -1.6)};
//     @LINE {(4, -3) (10, -3)};
//     @LINE {(-1, -3) (-3, -3)};
//     @LINE {(-3, -3) (-5, -4.7)};
//     @LINE {(-6, -5) (-8, -5)};
//     @LINE {(10, -3) (10, 4)};
//     @LINE {(10, 0) (17, 0)};
//     (3, 9) @TEXT("w11 = 560", size=1.8, bold=true, halign="middle");
//     (3, -9) @TEXT("2 x 280 Cu", size=1.2, halign="middle");
//     (3, -11) @TEXT("sample + reference", size=1.05, halign="middle");
//     (-17, 10) @PIN(terminal=1, direction="left");
//     @LINE {(-17, 10) (-14, 10)};
//     (-13.7, 10) @TEXT("VIN", size=1.05, halign="start", valign="middle");
//     (-17, 8) @PIN(terminal=2, direction="left");
//     @LINE {(-17, 8) (-14, 8)};
//     (-13.7, 8) @TEXT("VG", size=1.05, halign="start", valign="middle");
//     (-17, 6) @PIN(terminal=3, direction="left");
//     @LINE {(-17, 6) (-14, 6)};
//     (-13.7, 6) @TEXT("DH", size=1.05, halign="start", valign="middle");
//     (-17, 4) @PIN(terminal=4, direction="left");
//     @LINE {(-17, 4) (-14, 4)};
//     (-13.7, 4) @TEXT("RL", size=1.05, halign="start", valign="middle");
//     (-17, 2) @PIN(terminal=5, direction="left");
//     @LINE {(-17, 2) (-14, 2)};
//     (-13.7, 2) @TEXT("EN", size=1.05, halign="start", valign="middle");
//     (-17, 0) @PIN(terminal=6, direction="left");
//     @LINE {(-17, 0) (-14, 0)};
//     (-13.7, 0) @TEXT("ENB", size=1.05, halign="start", valign="middle");
//     (-17, -2) @PIN(terminal=12, direction="left");
//     @LINE {(-17, -2) (-14, -2)};
//     (-13.7, -2) @TEXT("EQBUS", size=1.05, halign="start", valign="middle");
//     (-17, -4) @PIN(terminal=13, direction="left");
//     @LINE {(-17, -4) (-14, -4)};
//     (-13.7, -4) @TEXT("APGATE", size=1.05, halign="start", valign="middle");
//     (17, 0) @PIN(terminal=7, direction="right");
//     (-5, 15) @PIN(terminal=8, direction="up");
//     @LINE {(-5, 15) (-5, 13)};
//     (5, 15) @PIN(terminal=11, direction="up");
//     @LINE {(5, 15) (5, 13)};
//     (-5, -15) @PIN(terminal=9, direction="down");
//     @LINE {(-5, -15) (-5, -13)};
//     (5, -15) @PIN(terminal=10, direction="down");
//     @LINE {(5, -15) (5, -13)};
//     ? @TEXT("${name}", key="name", size=0.9, bold=true) => @PLACE(-7, 17);
//   };
//   # @SELECT-INSTANCE(model="mq_cdac_bit11") => @SET-SYMBOL $DRAW_mq_cdac_bit11;
//   $DRAW_mq_cdac_drv10 = @DEFINE-SYMBOL {
//     @LINE {(-4, 6) (5, 2) (-4, -2) (-4, 6)};
//     (5.7,2) @CIRCLE(radius=0.7);
//     @LINE {(6.4, 2) (9, 2)};
//     (0, 1) @TEXT("REF", size=1.05, halign="middle");
//     (0, -6.8) @TEXT("EN / high-Z", size=1.05, halign="middle");
//     (-8, 2) @PIN(terminal=1, direction="left");
//     @LINE {(-8, 2) (-5, 2)};
//     (-4.8, 2) @TEXT("HIB", size=1.05, halign="start", valign="middle");
//     (-8, -2) @PIN(terminal=2, direction="left");
//     @LINE {(-8, -2) (-5, -2)};
//     (-4.8, -2) @TEXT("EN", size=1.05, halign="start", valign="middle");
//     (-8, -5) @PIN(terminal=3, direction="left");
//     @LINE {(-8, -5) (-5, -5)};
//     (-4.8, -5) @TEXT("ENB", size=1.05, halign="start", valign="middle");
//     (9, 2) @PIN(terminal=4, direction="right");
//     (9, 1) @TEXT("BP", size=1.05, halign="middle");
//     (3, 9) @PIN(terminal=5, direction="up");
//     (3, 8) @TEXT("VREFP", size=1.05, halign="middle");
//     (3, -9) @PIN(terminal=6, direction="down");
//     (3, -8) @TEXT("VREFN", size=1.05, halign="middle");
//     (-3, -9) @PIN(terminal=7, direction="down");
//     (-3, -8) @TEXT("VSS", size=1.05, halign="middle");
//     (-3, 9) @PIN(terminal=8, direction="up");
//     (-3, 8) @TEXT("DVDD", size=1.05, halign="middle");
//     ? @TEXT("${name}", key="name", size=0.9, bold=true) => @PLACE(-7, 11);
//   };
//   # @SELECT-INSTANCE(model="mq_cdac_drv10") => @SET-SYMBOL $DRAW_mq_cdac_drv10;
//   $DRAW_mq_cdac_bit10 = @DEFINE-SYMBOL {
//     @LINE(linestyle="dashed", linecolor="#a0aec0") {(-14,-13) (14,-13) (14,13) (-14,13) (-14,-13)};
//     @LINE {(-1, 4) (3, 4)};
//     @LINE {(3, 2.6) (3, 5.4)};
//     @LINE {(4, 2.6) (4, 5.4)};
//     @LINE {(4, 4) (10, 4)};
//     @LINE {(-1, 4) (-3, 4)};
//     @LINE {(-3, 4) (-5, 2.3)};
//     @LINE {(-6, 2) (-8, 2)};
//     @LINE {(-1, -3) (3, -3)};
//     @LINE {(3, -4.4) (3, -1.6)};
//     @LINE {(4, -4.4) (4, -1.6)};
//     @LINE {(4, -3) (10, -3)};
//     @LINE {(-1, -3) (-3, -3)};
//     @LINE {(-3, -3) (-5, -4.7)};
//     @LINE {(-6, -5) (-8, -5)};
//     @LINE {(10, -3) (10, 4)};
//     @LINE {(10, 0) (17, 0)};
//     (3, 9) @TEXT("w10 = 318", size=1.8, bold=true, halign="middle");
//     (3, -9) @TEXT("2 x 159 Cu", size=1.2, halign="middle");
//     (3, -11) @TEXT("sample + reference", size=1.05, halign="middle");
//     (-17, 10) @PIN(terminal=1, direction="left");
//     @LINE {(-17, 10) (-14, 10)};
//     (-13.7, 10) @TEXT("VIN", size=1.05, halign="start", valign="middle");
//     (-17, 8) @PIN(terminal=2, direction="left");
//     @LINE {(-17, 8) (-14, 8)};
//     (-13.7, 8) @TEXT("VG", size=1.05, halign="start", valign="middle");
//     (-17, 6) @PIN(terminal=3, direction="left");
//     @LINE {(-17, 6) (-14, 6)};
//     (-13.7, 6) @TEXT("DH", size=1.05, halign="start", valign="middle");
//     (-17, 4) @PIN(terminal=4, direction="left");
//     @LINE {(-17, 4) (-14, 4)};
//     (-13.7, 4) @TEXT("RL", size=1.05, halign="start", valign="middle");
//     (-17, 2) @PIN(terminal=5, direction="left");
//     @LINE {(-17, 2) (-14, 2)};
//     (-13.7, 2) @TEXT("EN", size=1.05, halign="start", valign="middle");
//     (-17, 0) @PIN(terminal=6, direction="left");
//     @LINE {(-17, 0) (-14, 0)};
//     (-13.7, 0) @TEXT("ENB", size=1.05, halign="start", valign="middle");
//     (-17, -2) @PIN(terminal=12, direction="left");
//     @LINE {(-17, -2) (-14, -2)};
//     (-13.7, -2) @TEXT("EQBUS", size=1.05, halign="start", valign="middle");
//     (-17, -4) @PIN(terminal=13, direction="left");
//     @LINE {(-17, -4) (-14, -4)};
//     (-13.7, -4) @TEXT("APGATE", size=1.05, halign="start", valign="middle");
//     (17, 0) @PIN(terminal=7, direction="right");
//     (-5, 15) @PIN(terminal=8, direction="up");
//     @LINE {(-5, 15) (-5, 13)};
//     (5, 15) @PIN(terminal=11, direction="up");
//     @LINE {(5, 15) (5, 13)};
//     (-5, -15) @PIN(terminal=9, direction="down");
//     @LINE {(-5, -15) (-5, -13)};
//     (5, -15) @PIN(terminal=10, direction="down");
//     @LINE {(5, -15) (5, -13)};
//     ? @TEXT("${name}", key="name", size=0.9, bold=true) => @PLACE(-7, 17);
//   };
//   # @SELECT-INSTANCE(model="mq_cdac_bit10") => @SET-SYMBOL $DRAW_mq_cdac_bit10;
//   $DRAW_mq_cdac_drv9 = @DEFINE-SYMBOL {
//     @LINE {(-4, 6) (5, 2) (-4, -2) (-4, 6)};
//     (5.7,2) @CIRCLE(radius=0.7);
//     @LINE {(6.4, 2) (9, 2)};
//     (0, 1) @TEXT("REF", size=1.05, halign="middle");
//     (0, -6.8) @TEXT("EN / high-Z", size=1.05, halign="middle");
//     (-8, 2) @PIN(terminal=1, direction="left");
//     @LINE {(-8, 2) (-5, 2)};
//     (-4.8, 2) @TEXT("HIB", size=1.05, halign="start", valign="middle");
//     (-8, -2) @PIN(terminal=2, direction="left");
//     @LINE {(-8, -2) (-5, -2)};
//     (-4.8, -2) @TEXT("EN", size=1.05, halign="start", valign="middle");
//     (-8, -5) @PIN(terminal=3, direction="left");
//     @LINE {(-8, -5) (-5, -5)};
//     (-4.8, -5) @TEXT("ENB", size=1.05, halign="start", valign="middle");
//     (9, 2) @PIN(terminal=4, direction="right");
//     (9, 1) @TEXT("BP", size=1.05, halign="middle");
//     (3, 9) @PIN(terminal=5, direction="up");
//     (3, 8) @TEXT("VREFP", size=1.05, halign="middle");
//     (3, -9) @PIN(terminal=6, direction="down");
//     (3, -8) @TEXT("VREFN", size=1.05, halign="middle");
//     (-3, -9) @PIN(terminal=7, direction="down");
//     (-3, -8) @TEXT("VSS", size=1.05, halign="middle");
//     (-3, 9) @PIN(terminal=8, direction="up");
//     (-3, 8) @TEXT("DVDD", size=1.05, halign="middle");
//     ? @TEXT("${name}", key="name", size=0.9, bold=true) => @PLACE(-7, 11);
//   };
//   # @SELECT-INSTANCE(model="mq_cdac_drv9") => @SET-SYMBOL $DRAW_mq_cdac_drv9;
//   $DRAW_mq_cdac_bit9 = @DEFINE-SYMBOL {
//     @LINE(linestyle="dashed", linecolor="#a0aec0") {(-14,-13) (14,-13) (14,13) (-14,13) (-14,-13)};
//     @LINE {(-1, 4) (3, 4)};
//     @LINE {(3, 2.6) (3, 5.4)};
//     @LINE {(4, 2.6) (4, 5.4)};
//     @LINE {(4, 4) (10, 4)};
//     @LINE {(-1, 4) (-3, 4)};
//     @LINE {(-3, 4) (-5, 2.3)};
//     @LINE {(-6, 2) (-8, 2)};
//     @LINE {(-1, -3) (3, -3)};
//     @LINE {(3, -4.4) (3, -1.6)};
//     @LINE {(4, -4.4) (4, -1.6)};
//     @LINE {(4, -3) (10, -3)};
//     @LINE {(-1, -3) (-3, -3)};
//     @LINE {(-3, -3) (-5, -4.7)};
//     @LINE {(-6, -5) (-8, -5)};
//     @LINE {(10, -3) (10, 4)};
//     @LINE {(10, 0) (17, 0)};
//     (3, 9) @TEXT("w9 = 180", size=1.8, bold=true, halign="middle");
//     (3, -9) @TEXT("2 x 90 Cu", size=1.2, halign="middle");
//     (3, -11) @TEXT("not sampled", size=1.05, halign="middle");
//     (-17, 10) @PIN(terminal=1, direction="left");
//     @LINE {(-17, 10) (-14, 10)};
//     (-13.7, 10) @TEXT("DH", size=1.05, halign="start", valign="middle");
//     (-17, 8) @PIN(terminal=2, direction="left");
//     @LINE {(-17, 8) (-14, 8)};
//     (-13.7, 8) @TEXT("RL", size=1.05, halign="start", valign="middle");
//     (-17, 6) @PIN(terminal=3, direction="left");
//     @LINE {(-17, 6) (-14, 6)};
//     (-13.7, 6) @TEXT("EN", size=1.05, halign="start", valign="middle");
//     (-17, 4) @PIN(terminal=4, direction="left");
//     @LINE {(-17, 4) (-14, 4)};
//     (-13.7, 4) @TEXT("ENB", size=1.05, halign="start", valign="middle");
//     (17, 0) @PIN(terminal=5, direction="right");
//     (-5, 15) @PIN(terminal=6, direction="up");
//     @LINE {(-5, 15) (-5, 13)};
//     (5, 15) @PIN(terminal=9, direction="up");
//     @LINE {(5, 15) (5, 13)};
//     (-5, -15) @PIN(terminal=7, direction="down");
//     @LINE {(-5, -15) (-5, -13)};
//     (5, -15) @PIN(terminal=8, direction="down");
//     @LINE {(5, -15) (5, -13)};
//     ? @TEXT("${name}", key="name", size=0.9, bold=true) => @PLACE(-7, 17);
//   };
//   # @SELECT-INSTANCE(model="mq_cdac_bit9") => @SET-SYMBOL $DRAW_mq_cdac_bit9;
//   $DRAW_mq_cdac_drv8 = @DEFINE-SYMBOL {
//     @LINE {(-4, 6) (5, 2) (-4, -2) (-4, 6)};
//     (5.7,2) @CIRCLE(radius=0.7);
//     @LINE {(6.4, 2) (9, 2)};
//     (0, 1) @TEXT("REF", size=1.05, halign="middle");
//     (0, -6.8) @TEXT("EN / high-Z", size=1.05, halign="middle");
//     (-8, 2) @PIN(terminal=1, direction="left");
//     @LINE {(-8, 2) (-5, 2)};
//     (-4.8, 2) @TEXT("HIB", size=1.05, halign="start", valign="middle");
//     (-8, -2) @PIN(terminal=2, direction="left");
//     @LINE {(-8, -2) (-5, -2)};
//     (-4.8, -2) @TEXT("EN", size=1.05, halign="start", valign="middle");
//     (-8, -5) @PIN(terminal=3, direction="left");
//     @LINE {(-8, -5) (-5, -5)};
//     (-4.8, -5) @TEXT("ENB", size=1.05, halign="start", valign="middle");
//     (9, 2) @PIN(terminal=4, direction="right");
//     (9, 1) @TEXT("BP", size=1.05, halign="middle");
//     (3, 9) @PIN(terminal=5, direction="up");
//     (3, 8) @TEXT("VREFP", size=1.05, halign="middle");
//     (3, -9) @PIN(terminal=6, direction="down");
//     (3, -8) @TEXT("VREFN", size=1.05, halign="middle");
//     (-3, -9) @PIN(terminal=7, direction="down");
//     (-3, -8) @TEXT("VSS", size=1.05, halign="middle");
//     (-3, 9) @PIN(terminal=8, direction="up");
//     (-3, 8) @TEXT("DVDD", size=1.05, halign="middle");
//     ? @TEXT("${name}", key="name", size=0.9, bold=true) => @PLACE(-7, 11);
//   };
//   # @SELECT-INSTANCE(model="mq_cdac_drv8") => @SET-SYMBOL $DRAW_mq_cdac_drv8;
//   $DRAW_mq_cdac_bit8 = @DEFINE-SYMBOL {
//     @LINE(linestyle="dashed", linecolor="#a0aec0") {(-14,-13) (14,-13) (14,13) (-14,13) (-14,-13)};
//     @LINE {(-1, 4) (3, 4)};
//     @LINE {(3, 2.6) (3, 5.4)};
//     @LINE {(4, 2.6) (4, 5.4)};
//     @LINE {(4, 4) (10, 4)};
//     @LINE {(-1, 4) (-3, 4)};
//     @LINE {(-3, 4) (-5, 2.3)};
//     @LINE {(-6, 2) (-8, 2)};
//     @LINE {(-1, -3) (3, -3)};
//     @LINE {(3, -4.4) (3, -1.6)};
//     @LINE {(4, -4.4) (4, -1.6)};
//     @LINE {(4, -3) (10, -3)};
//     @LINE {(-1, -3) (-3, -3)};
//     @LINE {(-3, -3) (-5, -4.7)};
//     @LINE {(-6, -5) (-8, -5)};
//     @LINE {(10, -3) (10, 4)};
//     @LINE {(10, 0) (17, 0)};
//     (3, 9) @TEXT("w8 = 102", size=1.8, bold=true, halign="middle");
//     (3, -9) @TEXT("2 x 51 Cu", size=1.2, halign="middle");
//     (3, -11) @TEXT("sample + reference", size=1.05, halign="middle");
//     (-17, 10) @PIN(terminal=1, direction="left");
//     @LINE {(-17, 10) (-14, 10)};
//     (-13.7, 10) @TEXT("VIN", size=1.05, halign="start", valign="middle");
//     (-17, 8) @PIN(terminal=2, direction="left");
//     @LINE {(-17, 8) (-14, 8)};
//     (-13.7, 8) @TEXT("VG", size=1.05, halign="start", valign="middle");
//     (-17, 6) @PIN(terminal=3, direction="left");
//     @LINE {(-17, 6) (-14, 6)};
//     (-13.7, 6) @TEXT("DH", size=1.05, halign="start", valign="middle");
//     (-17, 4) @PIN(terminal=4, direction="left");
//     @LINE {(-17, 4) (-14, 4)};
//     (-13.7, 4) @TEXT("RL", size=1.05, halign="start", valign="middle");
//     (-17, 2) @PIN(terminal=5, direction="left");
//     @LINE {(-17, 2) (-14, 2)};
//     (-13.7, 2) @TEXT("EN", size=1.05, halign="start", valign="middle");
//     (-17, 0) @PIN(terminal=6, direction="left");
//     @LINE {(-17, 0) (-14, 0)};
//     (-13.7, 0) @TEXT("ENB", size=1.05, halign="start", valign="middle");
//     (-17, -2) @PIN(terminal=12, direction="left");
//     @LINE {(-17, -2) (-14, -2)};
//     (-13.7, -2) @TEXT("EQBUS", size=1.05, halign="start", valign="middle");
//     (-17, -4) @PIN(terminal=13, direction="left");
//     @LINE {(-17, -4) (-14, -4)};
//     (-13.7, -4) @TEXT("APGATE", size=1.05, halign="start", valign="middle");
//     (17, 0) @PIN(terminal=7, direction="right");
//     (-5, 15) @PIN(terminal=8, direction="up");
//     @LINE {(-5, 15) (-5, 13)};
//     (5, 15) @PIN(terminal=11, direction="up");
//     @LINE {(5, 15) (5, 13)};
//     (-5, -15) @PIN(terminal=9, direction="down");
//     @LINE {(-5, -15) (-5, -13)};
//     (5, -15) @PIN(terminal=10, direction="down");
//     @LINE {(5, -15) (5, -13)};
//     ? @TEXT("${name}", key="name", size=0.9, bold=true) => @PLACE(-7, 17);
//   };
//   # @SELECT-INSTANCE(model="mq_cdac_bit8") => @SET-SYMBOL $DRAW_mq_cdac_bit8;
//   $DRAW_mq_cdac_drv7 = @DEFINE-SYMBOL {
//     @LINE {(-4, 6) (5, 2) (-4, -2) (-4, 6)};
//     (5.7,2) @CIRCLE(radius=0.7);
//     @LINE {(6.4, 2) (9, 2)};
//     (0, 1) @TEXT("REF", size=1.05, halign="middle");
//     (0, -6.8) @TEXT("EN / high-Z", size=1.05, halign="middle");
//     (-8, 2) @PIN(terminal=1, direction="left");
//     @LINE {(-8, 2) (-5, 2)};
//     (-4.8, 2) @TEXT("HIB", size=1.05, halign="start", valign="middle");
//     (-8, -2) @PIN(terminal=2, direction="left");
//     @LINE {(-8, -2) (-5, -2)};
//     (-4.8, -2) @TEXT("EN", size=1.05, halign="start", valign="middle");
//     (-8, -5) @PIN(terminal=3, direction="left");
//     @LINE {(-8, -5) (-5, -5)};
//     (-4.8, -5) @TEXT("ENB", size=1.05, halign="start", valign="middle");
//     (9, 2) @PIN(terminal=4, direction="right");
//     (9, 1) @TEXT("BP", size=1.05, halign="middle");
//     (3, 9) @PIN(terminal=5, direction="up");
//     (3, 8) @TEXT("VREFP", size=1.05, halign="middle");
//     (3, -9) @PIN(terminal=6, direction="down");
//     (3, -8) @TEXT("VREFN", size=1.05, halign="middle");
//     (-3, -9) @PIN(terminal=7, direction="down");
//     (-3, -8) @TEXT("VSS", size=1.05, halign="middle");
//     (-3, 9) @PIN(terminal=8, direction="up");
//     (-3, 8) @TEXT("DVDD", size=1.05, halign="middle");
//     ? @TEXT("${name}", key="name", size=0.9, bold=true) => @PLACE(-7, 11);
//   };
//   # @SELECT-INSTANCE(model="mq_cdac_drv7") => @SET-SYMBOL $DRAW_mq_cdac_drv7;
//   $DRAW_mq_cdac_bit7 = @DEFINE-SYMBOL {
//     @LINE(linestyle="dashed", linecolor="#a0aec0") {(-14,-13) (14,-13) (14,13) (-14,13) (-14,-13)};
//     @LINE {(-1, 4) (3, 4)};
//     @LINE {(3, 2.6) (3, 5.4)};
//     @LINE {(4, 2.6) (4, 5.4)};
//     @LINE {(4, 4) (10, 4)};
//     @LINE {(-1, 4) (-3, 4)};
//     @LINE {(-3, 4) (-5, 2.3)};
//     @LINE {(-6, 2) (-8, 2)};
//     @LINE {(-1, -3) (3, -3)};
//     @LINE {(3, -4.4) (3, -1.6)};
//     @LINE {(4, -4.4) (4, -1.6)};
//     @LINE {(4, -3) (10, -3)};
//     @LINE {(-1, -3) (-3, -3)};
//     @LINE {(-3, -3) (-5, -4.7)};
//     @LINE {(-6, -5) (-8, -5)};
//     @LINE {(10, -3) (10, 4)};
//     @LINE {(10, 0) (17, 0)};
//     (3, 9) @TEXT("w7 = 57", size=1.8, bold=true, halign="middle");
//     (3, -9) @TEXT("2 x 28.5 Cu", size=1.2, halign="middle");
//     (3, -11) @TEXT("sample + reference", size=1.05, halign="middle");
//     (-17, 10) @PIN(terminal=1, direction="left");
//     @LINE {(-17, 10) (-14, 10)};
//     (-13.7, 10) @TEXT("VIN", size=1.05, halign="start", valign="middle");
//     (-17, 8) @PIN(terminal=2, direction="left");
//     @LINE {(-17, 8) (-14, 8)};
//     (-13.7, 8) @TEXT("VG", size=1.05, halign="start", valign="middle");
//     (-17, 6) @PIN(terminal=3, direction="left");
//     @LINE {(-17, 6) (-14, 6)};
//     (-13.7, 6) @TEXT("DH", size=1.05, halign="start", valign="middle");
//     (-17, 4) @PIN(terminal=4, direction="left");
//     @LINE {(-17, 4) (-14, 4)};
//     (-13.7, 4) @TEXT("RL", size=1.05, halign="start", valign="middle");
//     (-17, 2) @PIN(terminal=5, direction="left");
//     @LINE {(-17, 2) (-14, 2)};
//     (-13.7, 2) @TEXT("EN", size=1.05, halign="start", valign="middle");
//     (-17, 0) @PIN(terminal=6, direction="left");
//     @LINE {(-17, 0) (-14, 0)};
//     (-13.7, 0) @TEXT("ENB", size=1.05, halign="start", valign="middle");
//     (-17, -2) @PIN(terminal=11, direction="left");
//     @LINE {(-17, -2) (-14, -2)};
//     (-13.7, -2) @TEXT("PHI_S", size=1.05, halign="start", valign="middle");
//     (-17, -4) @PIN(terminal=13, direction="left");
//     @LINE {(-17, -4) (-14, -4)};
//     (-13.7, -4) @TEXT("PHI_SB", size=1.05, halign="start", valign="middle");
//     (-17, -6) @PIN(terminal=14, direction="left");
//     @LINE {(-17, -6) (-14, -6)};
//     (-13.7, -6) @TEXT("EQBUS", size=1.05, halign="start", valign="middle");
//     (-17, -8) @PIN(terminal=15, direction="left");
//     @LINE {(-17, -8) (-14, -8)};
//     (-13.7, -8) @TEXT("APGATE", size=1.05, halign="start", valign="middle");
//     (17, 0) @PIN(terminal=7, direction="right");
//     (-5, 15) @PIN(terminal=8, direction="up");
//     @LINE {(-5, 15) (-5, 13)};
//     (5, 15) @PIN(terminal=12, direction="up");
//     @LINE {(5, 15) (5, 13)};
//     (-5, -15) @PIN(terminal=9, direction="down");
//     @LINE {(-5, -15) (-5, -13)};
//     (5, -15) @PIN(terminal=10, direction="down");
//     @LINE {(5, -15) (5, -13)};
//     ? @TEXT("${name}", key="name", size=0.9, bold=true) => @PLACE(-7, 17);
//   };
//   # @SELECT-INSTANCE(model="mq_cdac_bit7") => @SET-SYMBOL $DRAW_mq_cdac_bit7;
//   $DRAW_mq_cdac_drv6 = @DEFINE-SYMBOL {
//     @LINE {(-4, 6) (5, 2) (-4, -2) (-4, 6)};
//     (5.7,2) @CIRCLE(radius=0.7);
//     @LINE {(6.4, 2) (9, 2)};
//     (0, 1) @TEXT("REF", size=1.05, halign="middle");
//     (0, -6.8) @TEXT("EN / high-Z", size=1.05, halign="middle");
//     (-8, 2) @PIN(terminal=1, direction="left");
//     @LINE {(-8, 2) (-5, 2)};
//     (-4.8, 2) @TEXT("HIB", size=1.05, halign="start", valign="middle");
//     (-8, -2) @PIN(terminal=2, direction="left");
//     @LINE {(-8, -2) (-5, -2)};
//     (-4.8, -2) @TEXT("EN", size=1.05, halign="start", valign="middle");
//     (-8, -5) @PIN(terminal=3, direction="left");
//     @LINE {(-8, -5) (-5, -5)};
//     (-4.8, -5) @TEXT("ENB", size=1.05, halign="start", valign="middle");
//     (9, 2) @PIN(terminal=4, direction="right");
//     (9, 1) @TEXT("BP", size=1.05, halign="middle");
//     (3, 9) @PIN(terminal=5, direction="up");
//     (3, 8) @TEXT("VREFP", size=1.05, halign="middle");
//     (3, -9) @PIN(terminal=6, direction="down");
//     (3, -8) @TEXT("VREFN", size=1.05, halign="middle");
//     (-3, -9) @PIN(terminal=7, direction="down");
//     (-3, -8) @TEXT("VSS", size=1.05, halign="middle");
//     (-3, 9) @PIN(terminal=8, direction="up");
//     (-3, 8) @TEXT("DVDD", size=1.05, halign="middle");
//     ? @TEXT("${name}", key="name", size=0.9, bold=true) => @PLACE(-7, 11);
//   };
//   # @SELECT-INSTANCE(model="mq_cdac_drv6") => @SET-SYMBOL $DRAW_mq_cdac_drv6;
//   $DRAW_mq_cdac_bit6 = @DEFINE-SYMBOL {
//     @LINE(linestyle="dashed", linecolor="#a0aec0") {(-14,-13) (14,-13) (14,13) (-14,13) (-14,-13)};
//     @LINE {(-1, 4) (3, 4)};
//     @LINE {(3, 2.6) (3, 5.4)};
//     @LINE {(4, 2.6) (4, 5.4)};
//     @LINE {(4, 4) (10, 4)};
//     @LINE {(-1, 4) (-3, 4)};
//     @LINE {(-3, 4) (-5, 2.3)};
//     @LINE {(-6, 2) (-8, 2)};
//     @LINE {(-1, -3) (3, -3)};
//     @LINE {(3, -4.4) (3, -1.6)};
//     @LINE {(4, -4.4) (4, -1.6)};
//     @LINE {(4, -3) (10, -3)};
//     @LINE {(-1, -3) (-3, -3)};
//     @LINE {(-3, -3) (-5, -4.7)};
//     @LINE {(-6, -5) (-8, -5)};
//     @LINE {(10, -3) (10, 4)};
//     @LINE {(10, 0) (17, 0)};
//     (3, 9) @TEXT("w6 = 32", size=1.8, bold=true, halign="middle");
//     (3, -9) @TEXT("2 x 16 Cu", size=1.2, halign="middle");
//     (3, -11) @TEXT("not sampled", size=1.05, halign="middle");
//     (-17, 10) @PIN(terminal=1, direction="left");
//     @LINE {(-17, 10) (-14, 10)};
//     (-13.7, 10) @TEXT("DH", size=1.05, halign="start", valign="middle");
//     (-17, 8) @PIN(terminal=2, direction="left");
//     @LINE {(-17, 8) (-14, 8)};
//     (-13.7, 8) @TEXT("RL", size=1.05, halign="start", valign="middle");
//     (-17, 6) @PIN(terminal=3, direction="left");
//     @LINE {(-17, 6) (-14, 6)};
//     (-13.7, 6) @TEXT("EN", size=1.05, halign="start", valign="middle");
//     (-17, 4) @PIN(terminal=4, direction="left");
//     @LINE {(-17, 4) (-14, 4)};
//     (-13.7, 4) @TEXT("ENB", size=1.05, halign="start", valign="middle");
//     (17, 0) @PIN(terminal=5, direction="right");
//     (-5, 15) @PIN(terminal=6, direction="up");
//     @LINE {(-5, 15) (-5, 13)};
//     (5, 15) @PIN(terminal=9, direction="up");
//     @LINE {(5, 15) (5, 13)};
//     (-5, -15) @PIN(terminal=7, direction="down");
//     @LINE {(-5, -15) (-5, -13)};
//     (5, -15) @PIN(terminal=8, direction="down");
//     @LINE {(5, -15) (5, -13)};
//     ? @TEXT("${name}", key="name", size=0.9, bold=true) => @PLACE(-7, 17);
//   };
//   # @SELECT-INSTANCE(model="mq_cdac_bit6") => @SET-SYMBOL $DRAW_mq_cdac_bit6;
//   $DRAW_mq_cdac_drv5 = @DEFINE-SYMBOL {
//     @LINE {(-4, 6) (5, 2) (-4, -2) (-4, 6)};
//     (5.7,2) @CIRCLE(radius=0.7);
//     @LINE {(6.4, 2) (9, 2)};
//     (0, 1) @TEXT("REF", size=1.05, halign="middle");
//     (0, -6.8) @TEXT("EN / high-Z", size=1.05, halign="middle");
//     (-8, 2) @PIN(terminal=1, direction="left");
//     @LINE {(-8, 2) (-5, 2)};
//     (-4.8, 2) @TEXT("HIB", size=1.05, halign="start", valign="middle");
//     (-8, -2) @PIN(terminal=2, direction="left");
//     @LINE {(-8, -2) (-5, -2)};
//     (-4.8, -2) @TEXT("EN", size=1.05, halign="start", valign="middle");
//     (-8, -5) @PIN(terminal=3, direction="left");
//     @LINE {(-8, -5) (-5, -5)};
//     (-4.8, -5) @TEXT("ENB", size=1.05, halign="start", valign="middle");
//     (9, 2) @PIN(terminal=4, direction="right");
//     (9, 1) @TEXT("BP", size=1.05, halign="middle");
//     (3, 9) @PIN(terminal=5, direction="up");
//     (3, 8) @TEXT("VREFP", size=1.05, halign="middle");
//     (3, -9) @PIN(terminal=6, direction="down");
//     (3, -8) @TEXT("VREFN", size=1.05, halign="middle");
//     (-3, -9) @PIN(terminal=7, direction="down");
//     (-3, -8) @TEXT("VSS", size=1.05, halign="middle");
//     (-3, 9) @PIN(terminal=8, direction="up");
//     (-3, 8) @TEXT("DVDD", size=1.05, halign="middle");
//     ? @TEXT("${name}", key="name", size=0.9, bold=true) => @PLACE(-7, 11);
//   };
//   # @SELECT-INSTANCE(model="mq_cdac_drv5") => @SET-SYMBOL $DRAW_mq_cdac_drv5;
//   $DRAW_mq_cdac_bit5 = @DEFINE-SYMBOL {
//     @LINE(linestyle="dashed", linecolor="#a0aec0") {(-14,-13) (14,-13) (14,13) (-14,13) (-14,-13)};
//     @LINE {(-1, 4) (3, 4)};
//     @LINE {(3, 2.6) (3, 5.4)};
//     @LINE {(4, 2.6) (4, 5.4)};
//     @LINE {(4, 4) (10, 4)};
//     @LINE {(-1, 4) (-3, 4)};
//     @LINE {(-3, 4) (-5, 2.3)};
//     @LINE {(-6, 2) (-8, 2)};
//     @LINE {(-1, -3) (3, -3)};
//     @LINE {(3, -4.4) (3, -1.6)};
//     @LINE {(4, -4.4) (4, -1.6)};
//     @LINE {(4, -3) (10, -3)};
//     @LINE {(-1, -3) (-3, -3)};
//     @LINE {(-3, -3) (-5, -4.7)};
//     @LINE {(-6, -5) (-8, -5)};
//     @LINE {(10, -3) (10, 4)};
//     @LINE {(10, 0) (17, 0)};
//     (3, 9) @TEXT("w5 = 18", size=1.8, bold=true, halign="middle");
//     (3, -9) @TEXT("2 x 9 Cu", size=1.2, halign="middle");
//     (3, -11) @TEXT("sample + reference", size=1.05, halign="middle");
//     (-17, 10) @PIN(terminal=1, direction="left");
//     @LINE {(-17, 10) (-14, 10)};
//     (-13.7, 10) @TEXT("VIN", size=1.05, halign="start", valign="middle");
//     (-17, 8) @PIN(terminal=2, direction="left");
//     @LINE {(-17, 8) (-14, 8)};
//     (-13.7, 8) @TEXT("VG", size=1.05, halign="start", valign="middle");
//     (-17, 6) @PIN(terminal=3, direction="left");
//     @LINE {(-17, 6) (-14, 6)};
//     (-13.7, 6) @TEXT("DH", size=1.05, halign="start", valign="middle");
//     (-17, 4) @PIN(terminal=4, direction="left");
//     @LINE {(-17, 4) (-14, 4)};
//     (-13.7, 4) @TEXT("RL", size=1.05, halign="start", valign="middle");
//     (-17, 2) @PIN(terminal=5, direction="left");
//     @LINE {(-17, 2) (-14, 2)};
//     (-13.7, 2) @TEXT("EN", size=1.05, halign="start", valign="middle");
//     (-17, 0) @PIN(terminal=6, direction="left");
//     @LINE {(-17, 0) (-14, 0)};
//     (-13.7, 0) @TEXT("ENB", size=1.05, halign="start", valign="middle");
//     (-17, -2) @PIN(terminal=12, direction="left");
//     @LINE {(-17, -2) (-14, -2)};
//     (-13.7, -2) @TEXT("EQBUS", size=1.05, halign="start", valign="middle");
//     (-17, -4) @PIN(terminal=13, direction="left");
//     @LINE {(-17, -4) (-14, -4)};
//     (-13.7, -4) @TEXT("APGATE", size=1.05, halign="start", valign="middle");
//     (17, 0) @PIN(terminal=7, direction="right");
//     (-5, 15) @PIN(terminal=8, direction="up");
//     @LINE {(-5, 15) (-5, 13)};
//     (5, 15) @PIN(terminal=11, direction="up");
//     @LINE {(5, 15) (5, 13)};
//     (-5, -15) @PIN(terminal=9, direction="down");
//     @LINE {(-5, -15) (-5, -13)};
//     (5, -15) @PIN(terminal=10, direction="down");
//     @LINE {(5, -15) (5, -13)};
//     ? @TEXT("${name}", key="name", size=0.9, bold=true) => @PLACE(-7, 17);
//   };
//   # @SELECT-INSTANCE(model="mq_cdac_bit5") => @SET-SYMBOL $DRAW_mq_cdac_bit5;
//   $DRAW_mq_cdac_drv4 = @DEFINE-SYMBOL {
//     @LINE {(-4, 6) (5, 2) (-4, -2) (-4, 6)};
//     (5.7,2) @CIRCLE(radius=0.7);
//     @LINE {(6.4, 2) (9, 2)};
//     (0, 1) @TEXT("REF", size=1.05, halign="middle");
//     (0, -6.8) @TEXT("EN / high-Z", size=1.05, halign="middle");
//     (-8, 2) @PIN(terminal=1, direction="left");
//     @LINE {(-8, 2) (-5, 2)};
//     (-4.8, 2) @TEXT("HIB", size=1.05, halign="start", valign="middle");
//     (-8, -2) @PIN(terminal=2, direction="left");
//     @LINE {(-8, -2) (-5, -2)};
//     (-4.8, -2) @TEXT("EN", size=1.05, halign="start", valign="middle");
//     (-8, -5) @PIN(terminal=3, direction="left");
//     @LINE {(-8, -5) (-5, -5)};
//     (-4.8, -5) @TEXT("ENB", size=1.05, halign="start", valign="middle");
//     (9, 2) @PIN(terminal=4, direction="right");
//     (9, 1) @TEXT("BP", size=1.05, halign="middle");
//     (3, 9) @PIN(terminal=5, direction="up");
//     (3, 8) @TEXT("VREFP", size=1.05, halign="middle");
//     (3, -9) @PIN(terminal=6, direction="down");
//     (3, -8) @TEXT("VREFN", size=1.05, halign="middle");
//     (-3, -9) @PIN(terminal=7, direction="down");
//     (-3, -8) @TEXT("VSS", size=1.05, halign="middle");
//     (-3, 9) @PIN(terminal=8, direction="up");
//     (-3, 8) @TEXT("DVDD", size=1.05, halign="middle");
//     ? @TEXT("${name}", key="name", size=0.9, bold=true) => @PLACE(-7, 11);
//   };
//   # @SELECT-INSTANCE(model="mq_cdac_drv4") => @SET-SYMBOL $DRAW_mq_cdac_drv4;
//   $DRAW_mq_cdac_bit4 = @DEFINE-SYMBOL {
//     @LINE(linestyle="dashed", linecolor="#a0aec0") {(-14,-13) (14,-13) (14,13) (-14,13) (-14,-13)};
//     @LINE {(-1, 4) (3, 4)};
//     @LINE {(3, 2.6) (3, 5.4)};
//     @LINE {(4, 2.6) (4, 5.4)};
//     @LINE {(4, 4) (10, 4)};
//     @LINE {(-1, 4) (-3, 4)};
//     @LINE {(-3, 4) (-5, 2.3)};
//     @LINE {(-6, 2) (-8, 2)};
//     @LINE {(-1, -3) (3, -3)};
//     @LINE {(3, -4.4) (3, -1.6)};
//     @LINE {(4, -4.4) (4, -1.6)};
//     @LINE {(4, -3) (10, -3)};
//     @LINE {(-1, -3) (-3, -3)};
//     @LINE {(-3, -3) (-5, -4.7)};
//     @LINE {(-6, -5) (-8, -5)};
//     @LINE {(10, -3) (10, 4)};
//     @LINE {(10, 0) (17, 0)};
//     (3, 9) @TEXT("w4 = 10", size=1.8, bold=true, halign="middle");
//     (3, -9) @TEXT("2 x 5 Cu", size=1.2, halign="middle");
//     (3, -11) @TEXT("sample + reference", size=1.05, halign="middle");
//     (-17, 10) @PIN(terminal=1, direction="left");
//     @LINE {(-17, 10) (-14, 10)};
//     (-13.7, 10) @TEXT("VIN", size=1.05, halign="start", valign="middle");
//     (-17, 8) @PIN(terminal=2, direction="left");
//     @LINE {(-17, 8) (-14, 8)};
//     (-13.7, 8) @TEXT("VG", size=1.05, halign="start", valign="middle");
//     (-17, 6) @PIN(terminal=3, direction="left");
//     @LINE {(-17, 6) (-14, 6)};
//     (-13.7, 6) @TEXT("DH", size=1.05, halign="start", valign="middle");
//     (-17, 4) @PIN(terminal=4, direction="left");
//     @LINE {(-17, 4) (-14, 4)};
//     (-13.7, 4) @TEXT("RL", size=1.05, halign="start", valign="middle");
//     (-17, 2) @PIN(terminal=5, direction="left");
//     @LINE {(-17, 2) (-14, 2)};
//     (-13.7, 2) @TEXT("EN", size=1.05, halign="start", valign="middle");
//     (-17, 0) @PIN(terminal=6, direction="left");
//     @LINE {(-17, 0) (-14, 0)};
//     (-13.7, 0) @TEXT("ENB", size=1.05, halign="start", valign="middle");
//     (-17, -2) @PIN(terminal=12, direction="left");
//     @LINE {(-17, -2) (-14, -2)};
//     (-13.7, -2) @TEXT("EQBUS", size=1.05, halign="start", valign="middle");
//     (-17, -4) @PIN(terminal=13, direction="left");
//     @LINE {(-17, -4) (-14, -4)};
//     (-13.7, -4) @TEXT("APGATE", size=1.05, halign="start", valign="middle");
//     (17, 0) @PIN(terminal=7, direction="right");
//     (-5, 15) @PIN(terminal=8, direction="up");
//     @LINE {(-5, 15) (-5, 13)};
//     (5, 15) @PIN(terminal=11, direction="up");
//     @LINE {(5, 15) (5, 13)};
//     (-5, -15) @PIN(terminal=9, direction="down");
//     @LINE {(-5, -15) (-5, -13)};
//     (5, -15) @PIN(terminal=10, direction="down");
//     @LINE {(5, -15) (5, -13)};
//     ? @TEXT("${name}", key="name", size=0.9, bold=true) => @PLACE(-7, 17);
//   };
//   # @SELECT-INSTANCE(model="mq_cdac_bit4") => @SET-SYMBOL $DRAW_mq_cdac_bit4;
//   $DRAW_mq_cdac_drv3 = @DEFINE-SYMBOL {
//     @LINE {(-4, 6) (5, 2) (-4, -2) (-4, 6)};
//     (5.7,2) @CIRCLE(radius=0.7);
//     @LINE {(6.4, 2) (9, 2)};
//     (0, 1) @TEXT("REF", size=1.05, halign="middle");
//     (0, -6.8) @TEXT("EN / high-Z", size=1.05, halign="middle");
//     (-8, 2) @PIN(terminal=1, direction="left");
//     @LINE {(-8, 2) (-5, 2)};
//     (-4.8, 2) @TEXT("HIB", size=1.05, halign="start", valign="middle");
//     (-8, -2) @PIN(terminal=2, direction="left");
//     @LINE {(-8, -2) (-5, -2)};
//     (-4.8, -2) @TEXT("EN", size=1.05, halign="start", valign="middle");
//     (-8, -5) @PIN(terminal=3, direction="left");
//     @LINE {(-8, -5) (-5, -5)};
//     (-4.8, -5) @TEXT("ENB", size=1.05, halign="start", valign="middle");
//     (9, 2) @PIN(terminal=4, direction="right");
//     (9, 1) @TEXT("BP", size=1.05, halign="middle");
//     (3, 9) @PIN(terminal=5, direction="up");
//     (3, 8) @TEXT("VREFP", size=1.05, halign="middle");
//     (3, -9) @PIN(terminal=6, direction="down");
//     (3, -8) @TEXT("VREFN", size=1.05, halign="middle");
//     (-3, -9) @PIN(terminal=7, direction="down");
//     (-3, -8) @TEXT("VSS", size=1.05, halign="middle");
//     (-3, 9) @PIN(terminal=8, direction="up");
//     (-3, 8) @TEXT("DVDD", size=1.05, halign="middle");
//     ? @TEXT("${name}", key="name", size=0.9, bold=true) => @PLACE(-7, 11);
//   };
//   # @SELECT-INSTANCE(model="mq_cdac_drv3") => @SET-SYMBOL $DRAW_mq_cdac_drv3;
//   $DRAW_mq_cdac_bit3 = @DEFINE-SYMBOL {
//     @LINE(linestyle="dashed", linecolor="#a0aec0") {(-14,-13) (14,-13) (14,13) (-14,13) (-14,-13)};
//     @LINE {(-1, 4) (3, 4)};
//     @LINE {(3, 2.6) (3, 5.4)};
//     @LINE {(4, 2.6) (4, 5.4)};
//     @LINE {(4, 4) (10, 4)};
//     @LINE {(-1, 4) (-3, 4)};
//     @LINE {(-3, 4) (-5, 2.3)};
//     @LINE {(-6, 2) (-8, 2)};
//     @LINE {(-1, -3) (3, -3)};
//     @LINE {(3, -4.4) (3, -1.6)};
//     @LINE {(4, -4.4) (4, -1.6)};
//     @LINE {(4, -3) (10, -3)};
//     @LINE {(-1, -3) (-3, -3)};
//     @LINE {(-3, -3) (-5, -4.7)};
//     @LINE {(-6, -5) (-8, -5)};
//     @LINE {(10, -3) (10, 4)};
//     @LINE {(10, 0) (17, 0)};
//     (3, 9) @TEXT("w3 = 6", size=1.8, bold=true, halign="middle");
//     (3, -9) @TEXT("2 x 3 Cu", size=1.2, halign="middle");
//     (3, -11) @TEXT("sample + reference", size=1.05, halign="middle");
//     (-17, 10) @PIN(terminal=1, direction="left");
//     @LINE {(-17, 10) (-14, 10)};
//     (-13.7, 10) @TEXT("VIN", size=1.05, halign="start", valign="middle");
//     (-17, 8) @PIN(terminal=2, direction="left");
//     @LINE {(-17, 8) (-14, 8)};
//     (-13.7, 8) @TEXT("VG", size=1.05, halign="start", valign="middle");
//     (-17, 6) @PIN(terminal=3, direction="left");
//     @LINE {(-17, 6) (-14, 6)};
//     (-13.7, 6) @TEXT("DH", size=1.05, halign="start", valign="middle");
//     (-17, 4) @PIN(terminal=4, direction="left");
//     @LINE {(-17, 4) (-14, 4)};
//     (-13.7, 4) @TEXT("RL", size=1.05, halign="start", valign="middle");
//     (-17, 2) @PIN(terminal=5, direction="left");
//     @LINE {(-17, 2) (-14, 2)};
//     (-13.7, 2) @TEXT("EN", size=1.05, halign="start", valign="middle");
//     (-17, 0) @PIN(terminal=6, direction="left");
//     @LINE {(-17, 0) (-14, 0)};
//     (-13.7, 0) @TEXT("ENB", size=1.05, halign="start", valign="middle");
//     (-17, -2) @PIN(terminal=12, direction="left");
//     @LINE {(-17, -2) (-14, -2)};
//     (-13.7, -2) @TEXT("EQBUS", size=1.05, halign="start", valign="middle");
//     (-17, -4) @PIN(terminal=13, direction="left");
//     @LINE {(-17, -4) (-14, -4)};
//     (-13.7, -4) @TEXT("APGATE", size=1.05, halign="start", valign="middle");
//     (17, 0) @PIN(terminal=7, direction="right");
//     (-5, 15) @PIN(terminal=8, direction="up");
//     @LINE {(-5, 15) (-5, 13)};
//     (5, 15) @PIN(terminal=11, direction="up");
//     @LINE {(5, 15) (5, 13)};
//     (-5, -15) @PIN(terminal=9, direction="down");
//     @LINE {(-5, -15) (-5, -13)};
//     (5, -15) @PIN(terminal=10, direction="down");
//     @LINE {(5, -15) (5, -13)};
//     ? @TEXT("${name}", key="name", size=0.9, bold=true) => @PLACE(-7, 17);
//   };
//   # @SELECT-INSTANCE(model="mq_cdac_bit3") => @SET-SYMBOL $DRAW_mq_cdac_bit3;
//   $DRAW_mq_cdac_drv2 = @DEFINE-SYMBOL {
//     @LINE {(-4, 6) (5, 2) (-4, -2) (-4, 6)};
//     (5.7,2) @CIRCLE(radius=0.7);
//     @LINE {(6.4, 2) (9, 2)};
//     (0, 1) @TEXT("REF", size=1.05, halign="middle");
//     (0, -6.8) @TEXT("EN / high-Z", size=1.05, halign="middle");
//     (-8, 2) @PIN(terminal=1, direction="left");
//     @LINE {(-8, 2) (-5, 2)};
//     (-4.8, 2) @TEXT("HIB", size=1.05, halign="start", valign="middle");
//     (-8, -2) @PIN(terminal=2, direction="left");
//     @LINE {(-8, -2) (-5, -2)};
//     (-4.8, -2) @TEXT("EN", size=1.05, halign="start", valign="middle");
//     (-8, -5) @PIN(terminal=3, direction="left");
//     @LINE {(-8, -5) (-5, -5)};
//     (-4.8, -5) @TEXT("ENB", size=1.05, halign="start", valign="middle");
//     (9, 2) @PIN(terminal=4, direction="right");
//     (9, 1) @TEXT("BP", size=1.05, halign="middle");
//     (3, 9) @PIN(terminal=5, direction="up");
//     (3, 8) @TEXT("VREFP", size=1.05, halign="middle");
//     (3, -9) @PIN(terminal=6, direction="down");
//     (3, -8) @TEXT("VREFN", size=1.05, halign="middle");
//     (-3, -9) @PIN(terminal=7, direction="down");
//     (-3, -8) @TEXT("VSS", size=1.05, halign="middle");
//     (-3, 9) @PIN(terminal=8, direction="up");
//     (-3, 8) @TEXT("DVDD", size=1.05, halign="middle");
//     ? @TEXT("${name}", key="name", size=0.9, bold=true) => @PLACE(-7, 11);
//   };
//   # @SELECT-INSTANCE(model="mq_cdac_drv2") => @SET-SYMBOL $DRAW_mq_cdac_drv2;
//   $DRAW_mq_cdac_bit2 = @DEFINE-SYMBOL {
//     @LINE(linestyle="dashed", linecolor="#a0aec0") {(-14,-13) (14,-13) (14,13) (-14,13) (-14,-13)};
//     @LINE {(-1, 4) (3, 4)};
//     @LINE {(3, 2.6) (3, 5.4)};
//     @LINE {(4, 2.6) (4, 5.4)};
//     @LINE {(4, 4) (10, 4)};
//     @LINE {(-1, 4) (-3, 4)};
//     @LINE {(-3, 4) (-5, 2.3)};
//     @LINE {(-6, 2) (-8, 2)};
//     @LINE {(-1, -3) (3, -3)};
//     @LINE {(3, -4.4) (3, -1.6)};
//     @LINE {(4, -4.4) (4, -1.6)};
//     @LINE {(4, -3) (10, -3)};
//     @LINE {(-1, -3) (-3, -3)};
//     @LINE {(-3, -3) (-5, -4.7)};
//     @LINE {(-6, -5) (-8, -5)};
//     @LINE {(10, -3) (10, 4)};
//     @LINE {(10, 0) (17, 0)};
//     (3, 9) @TEXT("w2 = 3", size=1.8, bold=true, halign="middle");
//     (3, -9) @TEXT("2 x 1.5 Cu", size=1.2, halign="middle");
//     (3, -11) @TEXT("sample + reference", size=1.05, halign="middle");
//     (-17, 10) @PIN(terminal=1, direction="left");
//     @LINE {(-17, 10) (-14, 10)};
//     (-13.7, 10) @TEXT("VIN", size=1.05, halign="start", valign="middle");
//     (-17, 8) @PIN(terminal=2, direction="left");
//     @LINE {(-17, 8) (-14, 8)};
//     (-13.7, 8) @TEXT("VG", size=1.05, halign="start", valign="middle");
//     (-17, 6) @PIN(terminal=3, direction="left");
//     @LINE {(-17, 6) (-14, 6)};
//     (-13.7, 6) @TEXT("DH", size=1.05, halign="start", valign="middle");
//     (-17, 4) @PIN(terminal=4, direction="left");
//     @LINE {(-17, 4) (-14, 4)};
//     (-13.7, 4) @TEXT("RL", size=1.05, halign="start", valign="middle");
//     (-17, 2) @PIN(terminal=5, direction="left");
//     @LINE {(-17, 2) (-14, 2)};
//     (-13.7, 2) @TEXT("EN", size=1.05, halign="start", valign="middle");
//     (-17, 0) @PIN(terminal=6, direction="left");
//     @LINE {(-17, 0) (-14, 0)};
//     (-13.7, 0) @TEXT("ENB", size=1.05, halign="start", valign="middle");
//     (-17, -2) @PIN(terminal=11, direction="left");
//     @LINE {(-17, -2) (-14, -2)};
//     (-13.7, -2) @TEXT("PHI_S", size=1.05, halign="start", valign="middle");
//     (-17, -4) @PIN(terminal=13, direction="left");
//     @LINE {(-17, -4) (-14, -4)};
//     (-13.7, -4) @TEXT("PHI_SB", size=1.05, halign="start", valign="middle");
//     (-17, -6) @PIN(terminal=14, direction="left");
//     @LINE {(-17, -6) (-14, -6)};
//     (-13.7, -6) @TEXT("EQBUS", size=1.05, halign="start", valign="middle");
//     (-17, -8) @PIN(terminal=15, direction="left");
//     @LINE {(-17, -8) (-14, -8)};
//     (-13.7, -8) @TEXT("APGATE", size=1.05, halign="start", valign="middle");
//     (17, 0) @PIN(terminal=7, direction="right");
//     (-5, 15) @PIN(terminal=8, direction="up");
//     @LINE {(-5, 15) (-5, 13)};
//     (5, 15) @PIN(terminal=12, direction="up");
//     @LINE {(5, 15) (5, 13)};
//     (-5, -15) @PIN(terminal=9, direction="down");
//     @LINE {(-5, -15) (-5, -13)};
//     (5, -15) @PIN(terminal=10, direction="down");
//     @LINE {(5, -15) (5, -13)};
//     ? @TEXT("${name}", key="name", size=0.9, bold=true) => @PLACE(-7, 17);
//   };
//   # @SELECT-INSTANCE(model="mq_cdac_bit2") => @SET-SYMBOL $DRAW_mq_cdac_bit2;
//   $DRAW_mq_cdac_drv1 = @DEFINE-SYMBOL {
//     @LINE {(-4, 6) (5, 2) (-4, -2) (-4, 6)};
//     (5.7,2) @CIRCLE(radius=0.7);
//     @LINE {(6.4, 2) (9, 2)};
//     (0, 1) @TEXT("REF", size=1.05, halign="middle");
//     (0, -6.8) @TEXT("EN / high-Z", size=1.05, halign="middle");
//     (-8, 2) @PIN(terminal=1, direction="left");
//     @LINE {(-8, 2) (-5, 2)};
//     (-4.8, 2) @TEXT("HIB", size=1.05, halign="start", valign="middle");
//     (-8, -2) @PIN(terminal=2, direction="left");
//     @LINE {(-8, -2) (-5, -2)};
//     (-4.8, -2) @TEXT("EN", size=1.05, halign="start", valign="middle");
//     (-8, -5) @PIN(terminal=3, direction="left");
//     @LINE {(-8, -5) (-5, -5)};
//     (-4.8, -5) @TEXT("ENB", size=1.05, halign="start", valign="middle");
//     (9, 2) @PIN(terminal=4, direction="right");
//     (9, 1) @TEXT("BP", size=1.05, halign="middle");
//     (3, 9) @PIN(terminal=5, direction="up");
//     (3, 8) @TEXT("VREFP", size=1.05, halign="middle");
//     (3, -9) @PIN(terminal=6, direction="down");
//     (3, -8) @TEXT("VREFN", size=1.05, halign="middle");
//     (-3, -9) @PIN(terminal=7, direction="down");
//     (-3, -8) @TEXT("VSS", size=1.05, halign="middle");
//     (-3, 9) @PIN(terminal=8, direction="up");
//     (-3, 8) @TEXT("DVDD", size=1.05, halign="middle");
//     ? @TEXT("${name}", key="name", size=0.9, bold=true) => @PLACE(-7, 11);
//   };
//   # @SELECT-INSTANCE(model="mq_cdac_drv1") => @SET-SYMBOL $DRAW_mq_cdac_drv1;
//   $DRAW_mq_cdac_bit1 = @DEFINE-SYMBOL {
//     @LINE(linestyle="dashed", linecolor="#a0aec0") {(-14,-13) (14,-13) (14,13) (-14,13) (-14,-13)};
//     @LINE {(-1, 4) (3, 4)};
//     @LINE {(3, 2.6) (3, 5.4)};
//     @LINE {(4, 2.6) (4, 5.4)};
//     @LINE {(4, 4) (10, 4)};
//     @LINE {(-1, 4) (-3, 4)};
//     @LINE {(-3, 4) (-5, 2.3)};
//     @LINE {(-6, 2) (-8, 2)};
//     @LINE {(-1, -3) (3, -3)};
//     @LINE {(3, -4.4) (3, -1.6)};
//     @LINE {(4, -4.4) (4, -1.6)};
//     @LINE {(4, -3) (10, -3)};
//     @LINE {(-1, -3) (-3, -3)};
//     @LINE {(-3, -3) (-5, -4.7)};
//     @LINE {(-6, -5) (-8, -5)};
//     @LINE {(10, -3) (10, 4)};
//     @LINE {(10, 0) (17, 0)};
//     (3, 9) @TEXT("w1 = 2", size=1.8, bold=true, halign="middle");
//     (3, -9) @TEXT("2 x 1 Cu", size=1.2, halign="middle");
//     (3, -11) @TEXT("sample + reference", size=1.05, halign="middle");
//     (-17, 10) @PIN(terminal=1, direction="left");
//     @LINE {(-17, 10) (-14, 10)};
//     (-13.7, 10) @TEXT("VIN", size=1.05, halign="start", valign="middle");
//     (-17, 8) @PIN(terminal=2, direction="left");
//     @LINE {(-17, 8) (-14, 8)};
//     (-13.7, 8) @TEXT("VG", size=1.05, halign="start", valign="middle");
//     (-17, 6) @PIN(terminal=3, direction="left");
//     @LINE {(-17, 6) (-14, 6)};
//     (-13.7, 6) @TEXT("DH", size=1.05, halign="start", valign="middle");
//     (-17, 4) @PIN(terminal=4, direction="left");
//     @LINE {(-17, 4) (-14, 4)};
//     (-13.7, 4) @TEXT("RL", size=1.05, halign="start", valign="middle");
//     (-17, 2) @PIN(terminal=5, direction="left");
//     @LINE {(-17, 2) (-14, 2)};
//     (-13.7, 2) @TEXT("EN", size=1.05, halign="start", valign="middle");
//     (-17, 0) @PIN(terminal=6, direction="left");
//     @LINE {(-17, 0) (-14, 0)};
//     (-13.7, 0) @TEXT("ENB", size=1.05, halign="start", valign="middle");
//     (-17, -2) @PIN(terminal=12, direction="left");
//     @LINE {(-17, -2) (-14, -2)};
//     (-13.7, -2) @TEXT("EQBUS", size=1.05, halign="start", valign="middle");
//     (-17, -4) @PIN(terminal=13, direction="left");
//     @LINE {(-17, -4) (-14, -4)};
//     (-13.7, -4) @TEXT("APGATE", size=1.05, halign="start", valign="middle");
//     (17, 0) @PIN(terminal=7, direction="right");
//     (-5, 15) @PIN(terminal=8, direction="up");
//     @LINE {(-5, 15) (-5, 13)};
//     (5, 15) @PIN(terminal=11, direction="up");
//     @LINE {(5, 15) (5, 13)};
//     (-5, -15) @PIN(terminal=9, direction="down");
//     @LINE {(-5, -15) (-5, -13)};
//     (5, -15) @PIN(terminal=10, direction="down");
//     @LINE {(5, -15) (5, -13)};
//     ? @TEXT("${name}", key="name", size=0.9, bold=true) => @PLACE(-7, 17);
//   };
//   # @SELECT-INSTANCE(model="mq_cdac_bit1") => @SET-SYMBOL $DRAW_mq_cdac_bit1;
//   $DRAW_mq_cdac_drv0 = @DEFINE-SYMBOL {
//     @LINE {(-4, 6) (5, 2) (-4, -2) (-4, 6)};
//     (5.7,2) @CIRCLE(radius=0.7);
//     @LINE {(6.4, 2) (9, 2)};
//     (0, 1) @TEXT("REF", size=1.05, halign="middle");
//     (0, -6.8) @TEXT("EN / high-Z", size=1.05, halign="middle");
//     (-8, 2) @PIN(terminal=1, direction="left");
//     @LINE {(-8, 2) (-5, 2)};
//     (-4.8, 2) @TEXT("HIB", size=1.05, halign="start", valign="middle");
//     (-8, -2) @PIN(terminal=2, direction="left");
//     @LINE {(-8, -2) (-5, -2)};
//     (-4.8, -2) @TEXT("EN", size=1.05, halign="start", valign="middle");
//     (-8, -5) @PIN(terminal=3, direction="left");
//     @LINE {(-8, -5) (-5, -5)};
//     (-4.8, -5) @TEXT("ENB", size=1.05, halign="start", valign="middle");
//     (9, 2) @PIN(terminal=4, direction="right");
//     (9, 1) @TEXT("BP", size=1.05, halign="middle");
//     (3, 9) @PIN(terminal=5, direction="up");
//     (3, 8) @TEXT("VREFP", size=1.05, halign="middle");
//     (3, -9) @PIN(terminal=6, direction="down");
//     (3, -8) @TEXT("VREFN", size=1.05, halign="middle");
//     (-3, -9) @PIN(terminal=7, direction="down");
//     (-3, -8) @TEXT("VSS", size=1.05, halign="middle");
//     (-3, 9) @PIN(terminal=8, direction="up");
//     (-3, 8) @TEXT("DVDD", size=1.05, halign="middle");
//     ? @TEXT("${name}", key="name", size=0.9, bold=true) => @PLACE(-7, 11);
//   };
//   # @SELECT-INSTANCE(model="mq_cdac_drv0") => @SET-SYMBOL $DRAW_mq_cdac_drv0;
//   $DRAW_mq_cdac_bit0 = @DEFINE-SYMBOL {
//     @LINE(linestyle="dashed", linecolor="#a0aec0") {(-14,-13) (14,-13) (14,13) (-14,13) (-14,-13)};
//     @LINE {(-1, 4) (3, 4)};
//     @LINE {(3, 2.6) (3, 5.4)};
//     @LINE {(4, 2.6) (4, 5.4)};
//     @LINE {(4, 4) (10, 4)};
//     @LINE {(-1, 4) (-3, 4)};
//     @LINE {(-3, 4) (-5, 2.3)};
//     @LINE {(-6, 2) (-8, 2)};
//     @LINE {(-1, -3) (3, -3)};
//     @LINE {(3, -4.4) (3, -1.6)};
//     @LINE {(4, -4.4) (4, -1.6)};
//     @LINE {(4, -3) (10, -3)};
//     @LINE {(-1, -3) (-3, -3)};
//     @LINE {(-3, -3) (-5, -4.7)};
//     @LINE {(-6, -5) (-8, -5)};
//     @LINE {(10, -3) (10, 4)};
//     @LINE {(10, 0) (17, 0)};
//     (3, 9) @TEXT("w0 = 1", size=1.8, bold=true, halign="middle");
//     (3, -9) @TEXT("2 x 0.5 Cu", size=1.2, halign="middle");
//     (3, -11) @TEXT("sample + reference", size=1.05, halign="middle");
//     (-17, 10) @PIN(terminal=1, direction="left");
//     @LINE {(-17, 10) (-14, 10)};
//     (-13.7, 10) @TEXT("VIN", size=1.05, halign="start", valign="middle");
//     (-17, 8) @PIN(terminal=2, direction="left");
//     @LINE {(-17, 8) (-14, 8)};
//     (-13.7, 8) @TEXT("VG", size=1.05, halign="start", valign="middle");
//     (-17, 6) @PIN(terminal=3, direction="left");
//     @LINE {(-17, 6) (-14, 6)};
//     (-13.7, 6) @TEXT("DH", size=1.05, halign="start", valign="middle");
//     (-17, 4) @PIN(terminal=4, direction="left");
//     @LINE {(-17, 4) (-14, 4)};
//     (-13.7, 4) @TEXT("RL", size=1.05, halign="start", valign="middle");
//     (-17, 2) @PIN(terminal=5, direction="left");
//     @LINE {(-17, 2) (-14, 2)};
//     (-13.7, 2) @TEXT("EN", size=1.05, halign="start", valign="middle");
//     (-17, 0) @PIN(terminal=6, direction="left");
//     @LINE {(-17, 0) (-14, 0)};
//     (-13.7, 0) @TEXT("ENB", size=1.05, halign="start", valign="middle");
//     (-17, -2) @PIN(terminal=11, direction="left");
//     @LINE {(-17, -2) (-14, -2)};
//     (-13.7, -2) @TEXT("PHI_S", size=1.05, halign="start", valign="middle");
//     (-17, -4) @PIN(terminal=13, direction="left");
//     @LINE {(-17, -4) (-14, -4)};
//     (-13.7, -4) @TEXT("PHI_SB", size=1.05, halign="start", valign="middle");
//     (-17, -6) @PIN(terminal=14, direction="left");
//     @LINE {(-17, -6) (-14, -6)};
//     (-13.7, -6) @TEXT("EQBUS", size=1.05, halign="start", valign="middle");
//     (-17, -8) @PIN(terminal=15, direction="left");
//     @LINE {(-17, -8) (-14, -8)};
//     (-13.7, -8) @TEXT("APGATE", size=1.05, halign="start", valign="middle");
//     (17, 0) @PIN(terminal=7, direction="right");
//     (-5, 15) @PIN(terminal=8, direction="up");
//     @LINE {(-5, 15) (-5, 13)};
//     (5, 15) @PIN(terminal=12, direction="up");
//     @LINE {(5, 15) (5, 13)};
//     (-5, -15) @PIN(terminal=9, direction="down");
//     @LINE {(-5, -15) (-5, -13)};
//     (5, -15) @PIN(terminal=10, direction="down");
//     @LINE {(5, -15) (5, -13)};
//     ? @TEXT("${name}", key="name", size=0.9, bold=true) => @PLACE(-7, 17);
//   };
//   # @SELECT-INSTANCE(model="mq_cdac_bit0") => @SET-SYMBOL $DRAW_mq_cdac_bit0;
//   $DRAW_mq_cdac_assist_pulse = @DEFINE-SYMBOL {
//     @LINE {(-12, 4) (-5, 4) (-5, 7) (-1, 7) (-1, 4) (2, 4)};
//     @LINE {(-12, -4) (2, -4)};
//     @LINE {(2, 5) (8, 0) (2, -5) (2, 5)};
//     @LINE {(8, 0) (12, 0)};
//     (0, -8) @TEXT("delayed assist pulse", size=1.05, halign="middle");
//     @LINE {(-5, 11) (-5, 9)};
//     @LINE {(-5, -11) (-5, -9)};
//     @LINE {(5, -11) (5, -9)};
//     (-12, 4) @PIN(terminal=1, direction="left");
//     (-12, -4) @PIN(terminal=2, direction="left");
//     (12, 0) @PIN(terminal=3, direction="right");
//     (-5, 11) @PIN(terminal=4, direction="up");
//     (-5, -11) @PIN(terminal=5, direction="down");
//     (5, -11) @PIN(terminal=6, direction="down");
//     ? @TEXT("${name}", key="name", size=0.9, bold=true) => @PLACE(-7, 11);
//   };
//   # @SELECT-INSTANCE(model="mq_cdac_assist_pulse") => @SET-SYMBOL $DRAW_mq_cdac_assist_pulse;
// }
simulator lang=spectre

// DVDD command buffer L
subckt mq_cdac_ctl_l (IN HIB DVDD VREFN VSS)
M0N (HIB IN VREFN VSS) nch_ulvt_mac w=2e-06 l=3e-08 nf=1
M0P (HIB IN DVDD DVDD) pch_ulvt_mac w=4e-06 l=3e-08 nf=2
// @RNL {
//   {&IN &HIB &DVDD &VREFN &VSS} @REMOVE-FROM $PORT_FILL_SET;
//   &VSS @ADD-TO $GROUND_NET_SET;
//   &VREFN @ADD-TO $GROUND_NET_SET;
//   #M0N @PLACE(10, -7) => @ORIENT("R0");
//   #M0N @SET-SYMBOL $NMOS;
//   #M0N @TEXT("ULVT 2u", key="model", size=1.05, dx=1.5, dy=-1);
//   #M0N @TEXT("M0N", key="name", size=1.1, dx=1.5, dy=1);
//   #M0P @PLACE(10, 7) => @ORIENT("R0");
//   #M0P @SET-SYMBOL $PMOS;
//   #M0P @TEXT("ULVT 4u", key="model", size=1.05, dx=1.5, dy=-1);
//   #M0P @TEXT("M0P", key="name", size=1.1, dx=1.5, dy=1);
//   %j1 = (10, 0);
//   %j2 = (5, 0);
//   &HIB @WIRE {#M0N:1 %j1 #M0P:1};
//   &IN @WIRE {#M0N:2 (5, -7) %j2 (5, 7) #M0P:2};
//   &IN @WIRE {%j2 (-2, 0)};
//   &HIB @WIRE {%j1 (18, 0)};
//   (-2, 1) @TEXT("IN", size=1.05);
//   (18, 1) @TEXT("HIB", size=1.05);
//   %t3 = $GROUND @ATTACH &VREFN => @PLACE(10, -11);
//   &VREFN @WIRE {#M0N:3 %t3:p};
//   %t4 = $SUPPLY @ATTACH &DVDD => @PLACE(10, 11);
//   &DVDD @WIRE {#M0P:3 %t4:p};
//   $JUNCTION @ATTACH %j1;
//   $JUNCTION @ATTACH %j2;
//   (-5, 19) @TEXT("N4 formal candidate / WIP | low command: HIB = NOT IN", size=1.4, bold=true, textcolor="#17365d");
//   (-5, 16.6) @TEXT("Drawing only | N bulk = VSS; L = 30 nm. P bulk DVDD: M0P", size=1.05, textcolor="#52606d");
// }
ends mq_cdac_ctl_l

// DVDD command buffer H
subckt mq_cdac_ctl_h (IN HIB DVDD VREFN VSS)
M0N (I0 IN VREFN VSS) nch_ulvt_mac w=4e-07 l=3e-08 nf=1
M0P (I0 IN DVDD DVDD) pch_mac w=8e-07 l=3e-08 nf=1
M1N (HIB I0 VREFN VSS) nch_ulvt_mac w=2e-06 l=3e-08 nf=1
M1P (HIB I0 DVDD DVDD) pch_ulvt_mac w=4e-06 l=3e-08 nf=2
// @RNL {
//   {&IN &HIB &DVDD &VREFN &VSS} @REMOVE-FROM $PORT_FILL_SET;
//   &VSS @ADD-TO $GROUND_NET_SET;
//   &VREFN @ADD-TO $GROUND_NET_SET;
//   #M0N @PLACE(10, -7) => @ORIENT("R0");
//   #M0N @SET-SYMBOL $NMOS;
//   #M0N @TEXT("ULVT 0.4u", key="model", size=1.05, dx=1.5, dy=-1);
//   #M0N @TEXT("M0N", key="name", size=1.1, dx=1.5, dy=1);
//   #M0P @PLACE(10, 7) => @ORIENT("R0");
//   #M0P @SET-SYMBOL $PMOS;
//   #M0P @TEXT("SVT 0.8u", key="model", size=1.05, dx=1.5, dy=-1);
//   #M0P @TEXT("M0P", key="name", size=1.1, dx=1.5, dy=1);
//   %j1 = (10, 0);
//   %j2 = (5, 0);
//   &I0 @WIRE {#M0N:1 %j1 #M0P:1};
//   &IN @WIRE {#M0N:2 (5, -7) %j2 (5, 7) #M0P:2};
//   #M1N @PLACE(34, -7) => @ORIENT("R0");
//   #M1N @SET-SYMBOL $NMOS;
//   #M1N @TEXT("ULVT 2u", key="model", size=1.05, dx=1.5, dy=-1);
//   #M1N @TEXT("M1N", key="name", size=1.1, dx=1.5, dy=1);
//   #M1P @PLACE(34, 7) => @ORIENT("R0");
//   #M1P @SET-SYMBOL $PMOS;
//   #M1P @TEXT("ULVT 4u", key="model", size=1.05, dx=1.5, dy=-1);
//   #M1P @TEXT("M1P", key="name", size=1.1, dx=1.5, dy=1);
//   %j3 = (34, 0);
//   %j4 = (29, 0);
//   &HIB @WIRE {#M1N:1 %j3 #M1P:1};
//   &I0 @WIRE {#M1N:2 (29, -7) %j4 (29, 7) #M1P:2};
//   &I0 @WIRE {%j1 %j4};
//   &IN @WIRE {%j2 (-2, 0)};
//   (-2, 1) @TEXT("IN", size=1.05);
//   &HIB @WIRE {%j3 (42, 0)};
//   (42, 1) @TEXT("HIB", size=1.05);
//   %t5 = $GROUND @ATTACH &VREFN => @PLACE(10, -11);
//   &VREFN @WIRE {#M0N:3 %t5:p};
//   %t6 = $SUPPLY @ATTACH &DVDD => @PLACE(10, 11);
//   &DVDD @WIRE {#M0P:3 %t6:p};
//   %t7 = $GROUND @ATTACH &VREFN => @PLACE(34, -11);
//   &VREFN @WIRE {#M1N:3 %t7:p};
//   %t8 = $SUPPLY @ATTACH &DVDD => @PLACE(34, 11);
//   &DVDD @WIRE {#M1P:3 %t8:p};
//   $JUNCTION @ATTACH %j1;
//   $JUNCTION @ATTACH %j2;
//   $JUNCTION @ATTACH %j3;
//   $JUNCTION @ATTACH %j4;
//   (-5, 19) @TEXT("N4 formal candidate / WIP | high command: HIB = IN", size=1.4, bold=true, textcolor="#17365d");
//   (-5, 16.6) @TEXT("Drawing only | N bulk = VSS; L = 30 nm. P bulk DVDD: M0P, M1P", size=1.05, textcolor="#52606d");
// }
ends mq_cdac_ctl_h

// DVDD conversion-enable buffer
subckt mq_cdac_enable (IN EN ENB DVDD VREFN VSS)
M0N (ENB IN VREFN VSS) nch_ulvt_mac w=4e-06 l=3e-08 nf=2
M0P (ENB IN DVDD DVDD) pch_mac w=8e-06 l=3e-08 nf=4
M1N (EN ENB VREFN VSS) nch_ulvt_mac w=2.4e-05 l=3e-08 nf=12
M1P (EN ENB DVDD DVDD) pch_ulvt_mac w=4.8e-05 l=3e-08 nf=24
// @RNL {
//   {&IN &EN &ENB &DVDD &VREFN &VSS} @REMOVE-FROM $PORT_FILL_SET;
//   &VSS @ADD-TO $GROUND_NET_SET;
//   &VREFN @ADD-TO $GROUND_NET_SET;
//   #M0N @PLACE(10, -7) => @ORIENT("R0");
//   #M0N @SET-SYMBOL $NMOS;
//   #M0N @TEXT("ULVT 4u", key="model", size=1.05, dx=1.5, dy=-1);
//   #M0N @TEXT("M0N", key="name", size=1.1, dx=1.5, dy=1);
//   #M0P @PLACE(10, 7) => @ORIENT("R0");
//   #M0P @SET-SYMBOL $PMOS;
//   #M0P @TEXT("SVT 8u", key="model", size=1.05, dx=1.5, dy=-1);
//   #M0P @TEXT("M0P", key="name", size=1.1, dx=1.5, dy=1);
//   %j1 = (10, 0);
//   %j2 = (5, 0);
//   &ENB @WIRE {#M0N:1 %j1 #M0P:1};
//   &IN @WIRE {#M0N:2 (5, -7) %j2 (5, 7) #M0P:2};
//   #M1N @PLACE(34, -7) => @ORIENT("R0");
//   #M1N @SET-SYMBOL $NMOS;
//   #M1N @TEXT("ULVT 24u", key="model", size=1.05, dx=1.5, dy=-1);
//   #M1N @TEXT("M1N", key="name", size=1.1, dx=1.5, dy=1);
//   #M1P @PLACE(34, 7) => @ORIENT("R0");
//   #M1P @SET-SYMBOL $PMOS;
//   #M1P @TEXT("ULVT 48u", key="model", size=1.05, dx=1.5, dy=-1);
//   #M1P @TEXT("M1P", key="name", size=1.1, dx=1.5, dy=1);
//   %j3 = (34, 0);
//   %j4 = (29, 0);
//   &EN @WIRE {#M1N:1 %j3 #M1P:1};
//   &ENB @WIRE {#M1N:2 (29, -7) %j4 (29, 7) #M1P:2};
//   &ENB @WIRE {%j1 %j4};
//   &IN @WIRE {%j2 (-2, 0)};
//   (-2, 1) @TEXT("IN", size=1.05);
//   &EN @WIRE {%j3 (42, 0)};
//   (42, 1) @TEXT("EN", size=1.05);
//   (17, -3) @TEXT("ENB", size=1.05);
//   %t5 = $GROUND @ATTACH &VREFN => @PLACE(10, -11);
//   &VREFN @WIRE {#M0N:3 %t5:p};
//   %t6 = $SUPPLY @ATTACH &DVDD => @PLACE(10, 11);
//   &DVDD @WIRE {#M0P:3 %t6:p};
//   %t7 = $GROUND @ATTACH &VREFN => @PLACE(34, -11);
//   &VREFN @WIRE {#M1N:3 %t7:p};
//   %t8 = $SUPPLY @ATTACH &DVDD => @PLACE(34, 11);
//   &DVDD @WIRE {#M1P:3 %t8:p};
//   $JUNCTION @ATTACH %j1;
//   $JUNCTION @ATTACH %j2;
//   $JUNCTION @ATTACH %j3;
//   $JUNCTION @ATTACH %j4;
//   (-5, 19) @TEXT("N4 formal candidate / WIP | complementary enable", size=1.4, bold=true, textcolor="#17365d");
//   (-5, 16.6) @TEXT("Drawing only | N bulk = VSS; L = 30 nm. P bulk DVDD: M0P, M1P", size=1.05, textcolor="#52606d");
// }
ends mq_cdac_enable

// Reference-rail output driver j=12
subckt mq_cdac_drv12 (HIB EN ENB BP VREFP VREFN VSS DVDD)
// DVDD prelogic: PCOND = NOR(ENB,HIB); NOFF = NAND(EN,HIB).
// Reference-powered final inverters restore GP and GN to VREFP/VREFN.
// Actual current overlap, settling and device stress require measurement.
MPA0 (AP ENB DVDD DVDD) pch_ulvt_mac w=8e-06 l=3e-08 nf=4
MPA1 (PCOND HIB AP DVDD) pch_ulvt_mac w=8e-06 l=3e-08 nf=4
MNA0 (PCOND ENB VREFN VSS) nch_ulvt_mac w=4e-06 l=3e-08 nf=2
MNA1 (PCOND HIB VREFN VSS) nch_ulvt_mac w=4e-06 l=3e-08 nf=2
MPB0 (NOFF EN DVDD DVDD) pch_ulvt_mac w=4e-06 l=3e-08 nf=2
MPB1 (NOFF HIB DVDD DVDD) pch_ulvt_mac w=4e-06 l=3e-08 nf=2
MNB0 (NOFF EN BN VSS) nch_ulvt_mac w=4e-06 l=3e-08 nf=2
MNB1 (BN HIB VREFN VSS) nch_ulvt_mac w=4e-06 l=3e-08 nf=2
MGPN (GP PCOND VREFN VSS) nch_mac w=8e-06 l=3e-08 nf=4
MGPP (GP PCOND VREFP VREFP) pch_mac w=1.2e-05 l=3e-08 nf=6
MGNN (GN NOFF VREFN VSS) nch_mac w=8e-06 l=3e-08 nf=4
MGNP (GN NOFF VREFP VREFP) pch_mac w=4e-06 l=3e-08 nf=2
MNOUT (BP GN VREFN VSS) nch_mac w=1.5e-05 l=3e-08 nf=10
MPOUT (BP GP VREFP VREFP) pch_mac w=3e-05 l=3e-08 nf=20
// @RNL {
//   {&HIB &EN &ENB &BP &VREFP &VREFN &VSS &DVDD} @REMOVE-FROM $PORT_FILL_SET;
//   &VSS @ADD-TO $GROUND_NET_SET;
//   &VREFN @ADD-TO $GROUND_NET_SET;
//   #MPA0 @PLACE(8, 32) => @ORIENT("R0");
//   #MPA0 @SET-SYMBOL $PMOS;
//   #MPA0 @TEXT("ULVT 8u", key="model", size=1.05, dx=1.5, dy=-1);
//   #MPA0 @TEXT("MPA0", key="name", size=1.1, dx=1.5, dy=1);
//   #MPA1 @PLACE(8, 24) => @ORIENT("R0");
//   #MPA1 @SET-SYMBOL $PMOS;
//   #MPA1 @TEXT("ULVT 8u", key="model", size=1.05, dx=1.5, dy=-1);
//   #MPA1 @TEXT("MPA1", key="name", size=1.1, dx=1.5, dy=1);
//   #MNA0 @PLACE(0, 8) => @ORIENT("R0");
//   #MNA0 @SET-SYMBOL $NMOS;
//   #MNA0 @TEXT("ULVT 4u", key="model", size=1.05, dx=1.5, dy=-1);
//   #MNA0 @TEXT("MNA0", key="name", size=1.1, dx=1.5, dy=1);
//   #MNA1 @PLACE(16, 8) => @ORIENT("R0");
//   #MNA1 @SET-SYMBOL $NMOS;
//   #MNA1 @TEXT("ULVT 4u", key="model", size=1.05, dx=1.5, dy=-1);
//   #MNA1 @TEXT("MNA1", key="name", size=1.1, dx=1.5, dy=1);
//   #MPB0 @PLACE(0, -8) => @ORIENT("R0");
//   #MPB0 @SET-SYMBOL $PMOS;
//   #MPB0 @TEXT("ULVT 4u", key="model", size=1.05, dx=1.5, dy=-1);
//   #MPB0 @TEXT("MPB0", key="name", size=1.1, dx=1.5, dy=1);
//   #MPB1 @PLACE(16, -8) => @ORIENT("R0");
//   #MPB1 @SET-SYMBOL $PMOS;
//   #MPB1 @TEXT("ULVT 4u", key="model", size=1.05, dx=1.5, dy=-1);
//   #MPB1 @TEXT("MPB1", key="name", size=1.1, dx=1.5, dy=1);
//   #MNB0 @PLACE(8, -24) => @ORIENT("R0");
//   #MNB0 @SET-SYMBOL $NMOS;
//   #MNB0 @TEXT("ULVT 4u", key="model", size=1.05, dx=1.5, dy=-1);
//   #MNB0 @TEXT("MNB0", key="name", size=1.1, dx=1.5, dy=1);
//   #MNB1 @PLACE(8, -32) => @ORIENT("R0");
//   #MNB1 @SET-SYMBOL $NMOS;
//   #MNB1 @TEXT("ULVT 4u", key="model", size=1.05, dx=1.5, dy=-1);
//   #MNB1 @TEXT("MNB1", key="name", size=1.1, dx=1.5, dy=1);
//   #MPOUT @PLACE(76, 18) => @ORIENT("R0");
//   #MPOUT @SET-SYMBOL $PMOS;
//   #MPOUT @TEXT("SVT 30u", key="model", size=1.05, dx=1.5, dy=-1);
//   #MPOUT @TEXT("MPOUT", key="name", size=1.1, dx=1.5, dy=1);
//   #MNOUT @PLACE(76, -18) => @ORIENT("R0");
//   #MNOUT @SET-SYMBOL $NMOS;
//   #MNOUT @TEXT("SVT 15u", key="model", size=1.05, dx=1.5, dy=-1);
//   #MNOUT @TEXT("MNOUT", key="name", size=1.1, dx=1.5, dy=1);
//   &AP @WIRE {#MPA0:1 #MPA1:3};
//   (10, 28) @TEXT("AP", size=1.05);
//   %j1 = (8, 16);
//   &PCOND @WIRE {#MNA0:1 (0, 16) %j1 (16, 16) #MNA1:1};
//   &PCOND @WIRE {#MPA1:1 %j1};
//   #MGPN @PLACE(43, 9) => @ORIENT("R0");
//   #MGPN @SET-SYMBOL $NMOS;
//   #MGPN @TEXT("SVT 8u", key="model", size=1.05, dx=1.5, dy=-1);
//   #MGPN @TEXT("MGPN", key="name", size=1.1, dx=1.5, dy=1);
//   #MGPP @PLACE(43, 23) => @ORIENT("R0");
//   #MGPP @SET-SYMBOL $PMOS;
//   #MGPP @TEXT("SVT 12u", key="model", size=1.05, dx=1.5, dy=-1);
//   #MGPP @TEXT("MGPP", key="name", size=1.1, dx=1.5, dy=1);
//   %j2 = (43, 16);
//   %j3 = (38, 16);
//   &GP @WIRE {#MGPN:1 %j2 #MGPP:1};
//   &PCOND @WIRE {#MGPN:2 (38, 9) %j3 (38, 23) #MGPP:2};
//   &PCOND @WIRE {%j1 %j3};
//   &GP @WIRE {%j2 (65, 16) (65, 18) #MPOUT:2};
//   %j4 = (8, -16);
//   &NOFF @WIRE {#MPB0:1 (0, -16) %j4 (16, -16) #MPB1:1};
//   &NOFF @WIRE {#MNB0:1 %j4};
//   &BN @WIRE {#MNB0:3 #MNB1:1};
//   (18, -14) @TEXT("NOFF", size=1.05);
//   #MGNN @PLACE(43, -23) => @ORIENT("R0");
//   #MGNN @SET-SYMBOL $NMOS;
//   #MGNN @TEXT("SVT 8u", key="model", size=1.05, dx=1.5, dy=-1);
//   #MGNN @TEXT("MGNN", key="name", size=1.1, dx=1.5, dy=1);
//   #MGNP @PLACE(43, -9) => @ORIENT("R0");
//   #MGNP @SET-SYMBOL $PMOS;
//   #MGNP @TEXT("SVT 4u", key="model", size=1.05, dx=1.5, dy=-1);
//   #MGNP @TEXT("MGNP", key="name", size=1.1, dx=1.5, dy=1);
//   %j5 = (43, -16);
//   %j6 = (38, -16);
//   &GN @WIRE {#MGNN:1 %j5 #MGNP:1};
//   &NOFF @WIRE {#MGNN:2 (38, -23) %j6 (38, -9) #MGNP:2};
//   &NOFF @WIRE {%j4 %j6};
//   &GN @WIRE {%j5 (65, -16) (65, -18) #MNOUT:2};
//   %j7 = (76, 0);
//   &BP @WIRE {#MPOUT:1 %j7 #MNOUT:1};
//   &BP @WIRE {%j7 (85, 0)};
//   (85, 1) @TEXT("BP", size=1.05);
//   (-5, 42) @TEXT("NOR: PCOND = ~(ENB | HIB)", size=1.05);
//   (-5, -42) @TEXT("NAND: NOFF = ~(EN & HIB)", size=1.05);
//   (31, 39) @TEXT("Reference gate drivers", size=1.05);
//   (67, 39) @TEXT("Output rail switch", size=1.05);
//   &ENB @WIRE {#MPA0:2 (3, 32)};
//   (2.7, 32) @TEXT("ENB", size=1.05, halign="end", valign="middle");
//   %t9 = $SUPPLY @ATTACH &DVDD => @PLACE(8, 36);
//   &DVDD @WIRE {#MPA0:3 %t9:p};
//   &HIB @WIRE {#MPA1:2 (3, 24)};
//   (2.7, 24) @TEXT("HIB", size=1.05, halign="end", valign="middle");
//   &ENB @WIRE {#MNA0:2 (-5, 8)};
//   (-5.3, 8) @TEXT("ENB", size=1.05, halign="end", valign="middle");
//   %t12 = $GROUND @ATTACH &VREFN => @PLACE(0, 4);
//   &VREFN @WIRE {#MNA0:3 %t12:p};
//   &HIB @WIRE {#MNA1:2 (11, 8)};
//   (10.7, 8) @TEXT("HIB", size=1.05, halign="end", valign="middle");
//   %t14 = $GROUND @ATTACH &VREFN => @PLACE(16, 4);
//   &VREFN @WIRE {#MNA1:3 %t14:p};
//   &EN @WIRE {#MPB0:2 (-5, -8)};
//   (-5.3, -8) @TEXT("EN", size=1.05, halign="end", valign="middle");
//   %t16 = $SUPPLY @ATTACH &DVDD => @PLACE(0, -4);
//   &DVDD @WIRE {#MPB0:3 %t16:p};
//   &HIB @WIRE {#MPB1:2 (11, -8)};
//   (10.7, -8) @TEXT("HIB", size=1.05, halign="end", valign="middle");
//   %t18 = $SUPPLY @ATTACH &DVDD => @PLACE(16, -4);
//   &DVDD @WIRE {#MPB1:3 %t18:p};
//   &EN @WIRE {#MNB0:2 (3, -24)};
//   (2.7, -24) @TEXT("EN", size=1.05, halign="end", valign="middle");
//   &HIB @WIRE {#MNB1:2 (3, -32)};
//   (2.7, -32) @TEXT("HIB", size=1.05, halign="end", valign="middle");
//   %t21 = $GROUND @ATTACH &VREFN => @PLACE(8, -36);
//   &VREFN @WIRE {#MNB1:3 %t21:p};
//   %t22 = $SUPPLY @ATTACH &VREFP => @PLACE(76, 22);
//   &VREFP @WIRE {#MPOUT:3 %t22:p};
//   %t23 = $GROUND @ATTACH &VREFN => @PLACE(76, -22);
//   &VREFN @WIRE {#MNOUT:3 %t23:p};
//   %t24 = $GROUND @ATTACH &VREFN => @PLACE(43, 5);
//   &VREFN @WIRE {#MGPN:3 %t24:p};
//   %t25 = $SUPPLY @ATTACH &VREFP => @PLACE(43, 27);
//   &VREFP @WIRE {#MGPP:3 %t25:p};
//   %t26 = $GROUND @ATTACH &VREFN => @PLACE(43, -27);
//   &VREFN @WIRE {#MGNN:3 %t26:p};
//   %t27 = $SUPPLY @ATTACH &VREFP => @PLACE(43, -5);
//   &VREFP @WIRE {#MGNP:3 %t27:p};
//   $JUNCTION @ATTACH %j1;
//   $JUNCTION @ATTACH %j2;
//   $JUNCTION @ATTACH %j3;
//   $JUNCTION @ATTACH %j4;
//   $JUNCTION @ATTACH %j5;
//   $JUNCTION @ATTACH %j6;
//   $JUNCTION @ATTACH %j7;
//   (-7, 51) @TEXT("N4 formal candidate / WIP | mq_cdac_drv12 | isolated DVDD logic / VREFP output", size=1.4, bold=true, textcolor="#17365d");
//   (-7, 48.6) @TEXT("Drawing only | N bulk = VSS; L = 30 nm. P bulk DVDD: MPA0, MPA1, MPB0, MPB1; VREFP: MGPP, MGNP, MPOUT", size=1.05, textcolor="#52606d");
// }
ends mq_cdac_drv12

// Matched half-capacitor pair j=12
subckt mq_cdac_bit12 (VIN VG DH RL EN ENB TOP VREFP VREFN VSS DVDD EQBUS APGATE)
// CP*: user-specified 5% bottom-plate estimate for every physical MOM unit, not extraction.
// Series tails retain one unit parasitic at MID and one at B.
// APGATE PMOS assist connects each bottom plate to VIN.
// Additional ENB NMOS sharing retains a common EQBUS.
XHCTL (DH HHIB DVDD VREFN VSS) mq_cdac_ctl_h
XLCTL (RL LHIB DVDD VREFN VSS) mq_cdac_ctl_l
XDH (HHIB EN ENB BH VREFP VREFN VSS DVDD) mq_cdac_drv12
CH (TOP BH) cfmom_2t w=5e-08 s=2.4e-07 nr=6 lr=1.69e-06 stm=2 spm=4 multi=490
CPH (BH VSS) capacitor c=2.45561050e-14
MSH (BH VG VIN VSS) nch_ulvt_mac w=1.143e-05 l=3e-08 nf=6
XDL (LHIB EN ENB BL VREFP VREFN VSS DVDD) mq_cdac_drv12
CL (TOP BL) cfmom_2t w=5e-08 s=2.4e-07 nr=6 lr=1.69e-06 stm=2 spm=4 multi=490
CPL (BL VSS) capacitor c=2.45561050e-14
MSL (BL VG VIN VSS) nch_ulvt_mac w=1.143e-05 l=3e-08 nf=6
MEQ1 (BH APGATE VIN VREFP) pch_ulvt_mac w=1.143e-05 l=3e-08 nf=6
MEQ2 (BL APGATE VIN VREFP) pch_ulvt_mac w=1.143e-05 l=3e-08 nf=6
MSHAREH (BH ENB EQBUS VSS) nch_ulvt_mac w=1.143e-05 l=3e-08 nf=6
MSHAREL (BL ENB EQBUS VSS) nch_ulvt_mac w=1.143e-05 l=3e-08 nf=6
// @RNL {
//   {&VIN &VG &DH &RL &EN &ENB &TOP &VREFP &VREFN &VSS &DVDD &EQBUS &APGATE} @REMOVE-FROM $PORT_FILL_SET;
//   &VSS @ADD-TO $GROUND_NET_SET;
//   &VREFN @ADD-TO $GROUND_NET_SET;
//   #XHCTL @PLACE(0, 20) => @ORIENT("R0");
//   #XDH @PLACE(19, 18) => @ORIENT("R0");
//   &HHIB @WIRE {#XHCTL:2 #XDH:1};
//   %j1 = (115, 20);
//   %j2 = (38, 20);
//   %j3 = (52, 20);
//   %j4 = (66, 20);
//   %j5 = (84, 20);
//   &BH @WIRE {#XDH:4 %j2 %j3 %j4 %j5};
//   #CH @PLACE(100, 20) => @ORIENT("R270");
//   #CH @TEXT("", key="value");
//   #CH @TEXT("", key="name");
//   (100, 22.2) @TEXT("CH", size=1.05);
//   (100, 16.8) @TEXT("490 Cu", size=1.05);
//   &BH @WIRE {%j5 #CH:2};
//   &TOP @WIRE {#CH:1 %j1};
//   #CPH @PLACE(84, 12) => @ORIENT("R0");
//   #CPH @TEXT("", key="value");
//   #CPH @TEXT("", key="name");
//   (86, 13) @TEXT("CPH", size=1.05);
//   (86, 11) @TEXT("24.56 fF / 5%", size=1.05);
//   &BH @WIRE {%j5 #CPH:1};
//   #MSH @PLACE(38, 7) => @ORIENT("R0");
//   #MSH @SET-SYMBOL $NMOS;
//   #MSH @TEXT("ULVT 11.43u", key="model", size=1.05, dx=1.5, dy=-1);
//   #MSH @TEXT("MSH", key="name", size=1.1, dx=1.5, dy=1);
//   &BH @WIRE {%j2 #MSH:1};
//   #MEQ1 @PLACE(52, 7) => @ORIENT("MX");
//   #MEQ1 @SET-SYMBOL $PMOS;
//   #MEQ1 @TEXT("ULVT 11.43u", key="model", size=1.05, dx=1.5, dy=-1);
//   #MEQ1 @TEXT("MEQ1", key="name", size=1.1, dx=1.5, dy=1);
//   &BH @WIRE {%j3 #MEQ1:1};
//   #MSHAREH @PLACE(66, 7) => @ORIENT("R0");
//   #MSHAREH @SET-SYMBOL $NMOS;
//   #MSHAREH @TEXT("ULVT 11.43u", key="model", size=1.05, dx=1.5, dy=-1);
//   #MSHAREH @TEXT("MSHAREH", key="name", size=1.1, dx=1.5, dy=1);
//   &BH @WIRE {%j4 #MSHAREH:1};
//   (-8, 35) @TEXT("High bank", size=1.05);
//   #XLCTL @PLACE(0, -18) => @ORIENT("R0");
//   #XDL @PLACE(19, -20) => @ORIENT("R0");
//   &LHIB @WIRE {#XLCTL:2 #XDL:1};
//   %j6 = (115, -18);
//   %j7 = (38, -18);
//   %j8 = (52, -18);
//   %j9 = (66, -18);
//   %j10 = (84, -18);
//   &BL @WIRE {#XDL:4 %j7 %j8 %j9 %j10};
//   #CL @PLACE(100, -18) => @ORIENT("R270");
//   #CL @TEXT("", key="value");
//   #CL @TEXT("", key="name");
//   (100, -15.8) @TEXT("CL", size=1.05);
//   (100, -21.2) @TEXT("490 Cu", size=1.05);
//   &BL @WIRE {%j10 #CL:2};
//   &TOP @WIRE {#CL:1 %j6};
//   #CPL @PLACE(84, -26) => @ORIENT("R0");
//   #CPL @TEXT("", key="value");
//   #CPL @TEXT("", key="name");
//   (86, -25) @TEXT("CPL", size=1.05);
//   (86, -27) @TEXT("24.56 fF / 5%", size=1.05);
//   &BL @WIRE {%j10 #CPL:1};
//   #MSL @PLACE(38, -31) => @ORIENT("R0");
//   #MSL @SET-SYMBOL $NMOS;
//   #MSL @TEXT("ULVT 11.43u", key="model", size=1.05, dx=1.5, dy=-1);
//   #MSL @TEXT("MSL", key="name", size=1.1, dx=1.5, dy=1);
//   &BL @WIRE {%j7 #MSL:1};
//   #MEQ2 @PLACE(52, -31) => @ORIENT("MX");
//   #MEQ2 @SET-SYMBOL $PMOS;
//   #MEQ2 @TEXT("ULVT 11.43u", key="model", size=1.05, dx=1.5, dy=-1);
//   #MEQ2 @TEXT("MEQ2", key="name", size=1.1, dx=1.5, dy=1);
//   &BL @WIRE {%j8 #MEQ2:1};
//   #MSHAREL @PLACE(66, -31) => @ORIENT("R0");
//   #MSHAREL @SET-SYMBOL $NMOS;
//   #MSHAREL @TEXT("ULVT 11.43u", key="model", size=1.05, dx=1.5, dy=-1);
//   #MSHAREL @TEXT("MSHAREL", key="name", size=1.1, dx=1.5, dy=1);
//   &BL @WIRE {%j9 #MSHAREL:1};
//   (-8, -3) @TEXT("Low bank", size=1.05);
//   &TOP @WIRE {%j1 %j6};
//   (116, -3) @TEXT("TOP", size=1.05);
//   (-8, -42) @TEXT("Cu = 1.00229 fF. Cp = 5% of every physical MOM, including series MID.", size=1.05);
//   (-8, -45) @TEXT("DH -> buffer; RL -> inverter. Control supply: DVDD / VREFN; body: VSS.", size=1.05);
//   (-8, -48) @TEXT("5% Cp is a user estimate, not extraction.", size=1.05);
//   &DH @WIRE {#XHCTL:1 (-6, 20)};
//   (-6.3, 20) @TEXT("DH", size=1.05, halign="end", valign="middle");
//   &EN @WIRE {#XDH:2 (9, 16)};
//   (8.7, 16) @TEXT("EN", size=1.05, halign="end", valign="middle");
//   &ENB @WIRE {#XDH:3 (9, 13)};
//   (8.7, 13) @TEXT("ENB", size=1.05, halign="end", valign="middle");
//   %t14 = $SUPPLY @ATTACH &VREFP => @PLACE(22, 29);
//   &VREFP @WIRE {#XDH:5 %t14:p};
//   %t15 = $GROUND @ATTACH &VREFN => @PLACE(22, 7);
//   &VREFN @WIRE {#XDH:6 %t15:p};
//   %t16 = $GROUND @ATTACH &VSS => @PLACE(16, 7);
//   &VSS @WIRE {#XDH:7 %t16:p};
//   %t17 = $SUPPLY @ATTACH &DVDD => @PLACE(16, 29);
//   &DVDD @WIRE {#XDH:8 %t17:p};
//   %t18 = $GROUND @ATTACH &VSS => @PLACE(84, 8);
//   &VSS @WIRE {#CPH:2 %t18:p};
//   &VG @WIRE {#MSH:2 (33, 7)};
//   (32.7, 10.2) @TEXT("VG", size=1.05, halign="end", valign="middle");
//   &VIN @WIRE {#MSH:3 (38, 3)};
//   (38, 2.4) @TEXT("VIN", size=1.05, halign="middle", valign="top");
//   &APGATE @WIRE {#MEQ1:2 (47, 7)};
//   (46.7, 10.2) @TEXT("APGATE", size=1.05, halign="end", valign="middle");
//   &VIN @WIRE {#MEQ1:3 (52, 3)};
//   (52, 2.4) @TEXT("VIN", size=1.05, halign="middle", valign="top");
//   &ENB @WIRE {#MSHAREH:2 (61, 7)};
//   (60.7, 10.2) @TEXT("ENB", size=1.05, halign="end", valign="middle");
//   &EQBUS @WIRE {#MSHAREH:3 (66, 3)};
//   (66, 2.4) @TEXT("EQBUS", size=1.05, halign="middle", valign="top");
//   &RL @WIRE {#XLCTL:1 (-6, -18)};
//   (-6.3, -18) @TEXT("RL", size=1.05, halign="end", valign="middle");
//   &EN @WIRE {#XDL:2 (9, -22)};
//   (8.7, -22) @TEXT("EN", size=1.05, halign="end", valign="middle");
//   &ENB @WIRE {#XDL:3 (9, -25)};
//   (8.7, -25) @TEXT("ENB", size=1.05, halign="end", valign="middle");
//   %t28 = $SUPPLY @ATTACH &VREFP => @PLACE(22, -9);
//   &VREFP @WIRE {#XDL:5 %t28:p};
//   %t29 = $GROUND @ATTACH &VREFN => @PLACE(22, -31);
//   &VREFN @WIRE {#XDL:6 %t29:p};
//   %t30 = $GROUND @ATTACH &VSS => @PLACE(16, -31);
//   &VSS @WIRE {#XDL:7 %t30:p};
//   %t31 = $SUPPLY @ATTACH &DVDD => @PLACE(16, -9);
//   &DVDD @WIRE {#XDL:8 %t31:p};
//   %t32 = $GROUND @ATTACH &VSS => @PLACE(84, -30);
//   &VSS @WIRE {#CPL:2 %t32:p};
//   &VG @WIRE {#MSL:2 (33, -31)};
//   (32.7, -27.8) @TEXT("VG", size=1.05, halign="end", valign="middle");
//   &VIN @WIRE {#MSL:3 (38, -35)};
//   (38, -35.6) @TEXT("VIN", size=1.05, halign="middle", valign="top");
//   &APGATE @WIRE {#MEQ2:2 (47, -31)};
//   (46.7, -27.8) @TEXT("APGATE", size=1.05, halign="end", valign="middle");
//   &VIN @WIRE {#MEQ2:3 (52, -35)};
//   (52, -35.6) @TEXT("VIN", size=1.05, halign="middle", valign="top");
//   &ENB @WIRE {#MSHAREL:2 (61, -31)};
//   (60.7, -27.8) @TEXT("ENB", size=1.05, halign="end", valign="middle");
//   &EQBUS @WIRE {#MSHAREL:3 (66, -35)};
//   (66, -35.6) @TEXT("EQBUS", size=1.05, halign="middle", valign="top");
//   $JUNCTION @ATTACH %j2;
//   $JUNCTION @ATTACH %j3;
//   $JUNCTION @ATTACH %j4;
//   $JUNCTION @ATTACH %j5;
//   $JUNCTION @ATTACH %j7;
//   $JUNCTION @ATTACH %j8;
//   $JUNCTION @ATTACH %j9;
//   $JUNCTION @ATTACH %j10;
//   (-8, 44) @TEXT("N4 formal candidate / WIP | weight 12: 980 | matched H/L banks", size=1.4, bold=true, textcolor="#17365d");
//   (-8, 41.6) @TEXT("Drawing only | N bulk = VSS; L = 30 nm. P bulk VREFP: MEQ1, MEQ2", size=1.05, textcolor="#52606d");
// }
ends mq_cdac_bit12

// Reference-rail output driver j=11
subckt mq_cdac_drv11 (HIB EN ENB BP VREFP VREFN VSS DVDD)
// DVDD prelogic: PCOND = NOR(ENB,HIB); NOFF = NAND(EN,HIB).
// Reference-powered final inverters restore GP and GN to VREFP/VREFN.
// Actual current overlap, settling and device stress require measurement.
MPA0 (AP ENB DVDD DVDD) pch_ulvt_mac w=4.575e-06 l=3e-08 nf=3
MPA1 (PCOND HIB AP DVDD) pch_ulvt_mac w=4.575e-06 l=3e-08 nf=3
MNA0 (PCOND ENB VREFN VSS) nch_ulvt_mac w=2.29e-06 l=3e-08 nf=2
MNA1 (PCOND HIB VREFN VSS) nch_ulvt_mac w=2.29e-06 l=3e-08 nf=2
MPB0 (NOFF EN DVDD DVDD) pch_ulvt_mac w=2.29e-06 l=3e-08 nf=2
MPB1 (NOFF HIB DVDD DVDD) pch_ulvt_mac w=2.29e-06 l=3e-08 nf=2
MNB0 (NOFF EN BN VSS) nch_ulvt_mac w=2.29e-06 l=3e-08 nf=2
MNB1 (BN HIB VREFN VSS) nch_ulvt_mac w=2.29e-06 l=3e-08 nf=2
MGPN (GP PCOND VREFN VSS) nch_mac w=4.575e-06 l=3e-08 nf=3
MGPP (GP PCOND VREFP VREFP) pch_mac w=6.86e-06 l=3e-08 nf=4
MGNN (GN NOFF VREFN VSS) nch_mac w=4.575e-06 l=3e-08 nf=3
MGNP (GN NOFF VREFP VREFP) pch_mac w=2.29e-06 l=3e-08 nf=2
MNOUT (BP GN VREFN VSS) nch_mac w=8.58e-06 l=3e-08 nf=6
MPOUT (BP GP VREFP VREFP) pch_mac w=1.716e-05 l=3e-08 nf=12
// @RNL {
//   {&HIB &EN &ENB &BP &VREFP &VREFN &VSS &DVDD} @REMOVE-FROM $PORT_FILL_SET;
//   &VSS @ADD-TO $GROUND_NET_SET;
//   &VREFN @ADD-TO $GROUND_NET_SET;
//   #MPA0 @PLACE(8, 32) => @ORIENT("R0");
//   #MPA0 @SET-SYMBOL $PMOS;
//   #MPA0 @TEXT("ULVT 4.575u", key="model", size=1.05, dx=1.5, dy=-1);
//   #MPA0 @TEXT("MPA0", key="name", size=1.1, dx=1.5, dy=1);
//   #MPA1 @PLACE(8, 24) => @ORIENT("R0");
//   #MPA1 @SET-SYMBOL $PMOS;
//   #MPA1 @TEXT("ULVT 4.575u", key="model", size=1.05, dx=1.5, dy=-1);
//   #MPA1 @TEXT("MPA1", key="name", size=1.1, dx=1.5, dy=1);
//   #MNA0 @PLACE(0, 8) => @ORIENT("R0");
//   #MNA0 @SET-SYMBOL $NMOS;
//   #MNA0 @TEXT("ULVT 2.29u", key="model", size=1.05, dx=1.5, dy=-1);
//   #MNA0 @TEXT("MNA0", key="name", size=1.1, dx=1.5, dy=1);
//   #MNA1 @PLACE(16, 8) => @ORIENT("R0");
//   #MNA1 @SET-SYMBOL $NMOS;
//   #MNA1 @TEXT("ULVT 2.29u", key="model", size=1.05, dx=1.5, dy=-1);
//   #MNA1 @TEXT("MNA1", key="name", size=1.1, dx=1.5, dy=1);
//   #MPB0 @PLACE(0, -8) => @ORIENT("R0");
//   #MPB0 @SET-SYMBOL $PMOS;
//   #MPB0 @TEXT("ULVT 2.29u", key="model", size=1.05, dx=1.5, dy=-1);
//   #MPB0 @TEXT("MPB0", key="name", size=1.1, dx=1.5, dy=1);
//   #MPB1 @PLACE(16, -8) => @ORIENT("R0");
//   #MPB1 @SET-SYMBOL $PMOS;
//   #MPB1 @TEXT("ULVT 2.29u", key="model", size=1.05, dx=1.5, dy=-1);
//   #MPB1 @TEXT("MPB1", key="name", size=1.1, dx=1.5, dy=1);
//   #MNB0 @PLACE(8, -24) => @ORIENT("R0");
//   #MNB0 @SET-SYMBOL $NMOS;
//   #MNB0 @TEXT("ULVT 2.29u", key="model", size=1.05, dx=1.5, dy=-1);
//   #MNB0 @TEXT("MNB0", key="name", size=1.1, dx=1.5, dy=1);
//   #MNB1 @PLACE(8, -32) => @ORIENT("R0");
//   #MNB1 @SET-SYMBOL $NMOS;
//   #MNB1 @TEXT("ULVT 2.29u", key="model", size=1.05, dx=1.5, dy=-1);
//   #MNB1 @TEXT("MNB1", key="name", size=1.1, dx=1.5, dy=1);
//   #MPOUT @PLACE(76, 18) => @ORIENT("R0");
//   #MPOUT @SET-SYMBOL $PMOS;
//   #MPOUT @TEXT("SVT 17.16u", key="model", size=1.05, dx=1.5, dy=-1);
//   #MPOUT @TEXT("MPOUT", key="name", size=1.1, dx=1.5, dy=1);
//   #MNOUT @PLACE(76, -18) => @ORIENT("R0");
//   #MNOUT @SET-SYMBOL $NMOS;
//   #MNOUT @TEXT("SVT 8.58u", key="model", size=1.05, dx=1.5, dy=-1);
//   #MNOUT @TEXT("MNOUT", key="name", size=1.1, dx=1.5, dy=1);
//   &AP @WIRE {#MPA0:1 #MPA1:3};
//   (10, 28) @TEXT("AP", size=1.05);
//   %j1 = (8, 16);
//   &PCOND @WIRE {#MNA0:1 (0, 16) %j1 (16, 16) #MNA1:1};
//   &PCOND @WIRE {#MPA1:1 %j1};
//   #MGPN @PLACE(43, 9) => @ORIENT("R0");
//   #MGPN @SET-SYMBOL $NMOS;
//   #MGPN @TEXT("SVT 4.575u", key="model", size=1.05, dx=1.5, dy=-1);
//   #MGPN @TEXT("MGPN", key="name", size=1.1, dx=1.5, dy=1);
//   #MGPP @PLACE(43, 23) => @ORIENT("R0");
//   #MGPP @SET-SYMBOL $PMOS;
//   #MGPP @TEXT("SVT 6.86u", key="model", size=1.05, dx=1.5, dy=-1);
//   #MGPP @TEXT("MGPP", key="name", size=1.1, dx=1.5, dy=1);
//   %j2 = (43, 16);
//   %j3 = (38, 16);
//   &GP @WIRE {#MGPN:1 %j2 #MGPP:1};
//   &PCOND @WIRE {#MGPN:2 (38, 9) %j3 (38, 23) #MGPP:2};
//   &PCOND @WIRE {%j1 %j3};
//   &GP @WIRE {%j2 (65, 16) (65, 18) #MPOUT:2};
//   %j4 = (8, -16);
//   &NOFF @WIRE {#MPB0:1 (0, -16) %j4 (16, -16) #MPB1:1};
//   &NOFF @WIRE {#MNB0:1 %j4};
//   &BN @WIRE {#MNB0:3 #MNB1:1};
//   (18, -14) @TEXT("NOFF", size=1.05);
//   #MGNN @PLACE(43, -23) => @ORIENT("R0");
//   #MGNN @SET-SYMBOL $NMOS;
//   #MGNN @TEXT("SVT 4.575u", key="model", size=1.05, dx=1.5, dy=-1);
//   #MGNN @TEXT("MGNN", key="name", size=1.1, dx=1.5, dy=1);
//   #MGNP @PLACE(43, -9) => @ORIENT("R0");
//   #MGNP @SET-SYMBOL $PMOS;
//   #MGNP @TEXT("SVT 2.29u", key="model", size=1.05, dx=1.5, dy=-1);
//   #MGNP @TEXT("MGNP", key="name", size=1.1, dx=1.5, dy=1);
//   %j5 = (43, -16);
//   %j6 = (38, -16);
//   &GN @WIRE {#MGNN:1 %j5 #MGNP:1};
//   &NOFF @WIRE {#MGNN:2 (38, -23) %j6 (38, -9) #MGNP:2};
//   &NOFF @WIRE {%j4 %j6};
//   &GN @WIRE {%j5 (65, -16) (65, -18) #MNOUT:2};
//   %j7 = (76, 0);
//   &BP @WIRE {#MPOUT:1 %j7 #MNOUT:1};
//   &BP @WIRE {%j7 (85, 0)};
//   (85, 1) @TEXT("BP", size=1.05);
//   (-5, 42) @TEXT("NOR: PCOND = ~(ENB | HIB)", size=1.05);
//   (-5, -42) @TEXT("NAND: NOFF = ~(EN & HIB)", size=1.05);
//   (31, 39) @TEXT("Reference gate drivers", size=1.05);
//   (67, 39) @TEXT("Output rail switch", size=1.05);
//   &ENB @WIRE {#MPA0:2 (3, 32)};
//   (2.7, 32) @TEXT("ENB", size=1.05, halign="end", valign="middle");
//   %t9 = $SUPPLY @ATTACH &DVDD => @PLACE(8, 36);
//   &DVDD @WIRE {#MPA0:3 %t9:p};
//   &HIB @WIRE {#MPA1:2 (3, 24)};
//   (2.7, 24) @TEXT("HIB", size=1.05, halign="end", valign="middle");
//   &ENB @WIRE {#MNA0:2 (-5, 8)};
//   (-5.3, 8) @TEXT("ENB", size=1.05, halign="end", valign="middle");
//   %t12 = $GROUND @ATTACH &VREFN => @PLACE(0, 4);
//   &VREFN @WIRE {#MNA0:3 %t12:p};
//   &HIB @WIRE {#MNA1:2 (11, 8)};
//   (10.7, 8) @TEXT("HIB", size=1.05, halign="end", valign="middle");
//   %t14 = $GROUND @ATTACH &VREFN => @PLACE(16, 4);
//   &VREFN @WIRE {#MNA1:3 %t14:p};
//   &EN @WIRE {#MPB0:2 (-5, -8)};
//   (-5.3, -8) @TEXT("EN", size=1.05, halign="end", valign="middle");
//   %t16 = $SUPPLY @ATTACH &DVDD => @PLACE(0, -4);
//   &DVDD @WIRE {#MPB0:3 %t16:p};
//   &HIB @WIRE {#MPB1:2 (11, -8)};
//   (10.7, -8) @TEXT("HIB", size=1.05, halign="end", valign="middle");
//   %t18 = $SUPPLY @ATTACH &DVDD => @PLACE(16, -4);
//   &DVDD @WIRE {#MPB1:3 %t18:p};
//   &EN @WIRE {#MNB0:2 (3, -24)};
//   (2.7, -24) @TEXT("EN", size=1.05, halign="end", valign="middle");
//   &HIB @WIRE {#MNB1:2 (3, -32)};
//   (2.7, -32) @TEXT("HIB", size=1.05, halign="end", valign="middle");
//   %t21 = $GROUND @ATTACH &VREFN => @PLACE(8, -36);
//   &VREFN @WIRE {#MNB1:3 %t21:p};
//   %t22 = $SUPPLY @ATTACH &VREFP => @PLACE(76, 22);
//   &VREFP @WIRE {#MPOUT:3 %t22:p};
//   %t23 = $GROUND @ATTACH &VREFN => @PLACE(76, -22);
//   &VREFN @WIRE {#MNOUT:3 %t23:p};
//   %t24 = $GROUND @ATTACH &VREFN => @PLACE(43, 5);
//   &VREFN @WIRE {#MGPN:3 %t24:p};
//   %t25 = $SUPPLY @ATTACH &VREFP => @PLACE(43, 27);
//   &VREFP @WIRE {#MGPP:3 %t25:p};
//   %t26 = $GROUND @ATTACH &VREFN => @PLACE(43, -27);
//   &VREFN @WIRE {#MGNN:3 %t26:p};
//   %t27 = $SUPPLY @ATTACH &VREFP => @PLACE(43, -5);
//   &VREFP @WIRE {#MGNP:3 %t27:p};
//   $JUNCTION @ATTACH %j1;
//   $JUNCTION @ATTACH %j2;
//   $JUNCTION @ATTACH %j3;
//   $JUNCTION @ATTACH %j4;
//   $JUNCTION @ATTACH %j5;
//   $JUNCTION @ATTACH %j6;
//   $JUNCTION @ATTACH %j7;
//   (-7, 51) @TEXT("N4 formal candidate / WIP | mq_cdac_drv11 | isolated DVDD logic / VREFP output", size=1.4, bold=true, textcolor="#17365d");
//   (-7, 48.6) @TEXT("Drawing only | N bulk = VSS; L = 30 nm. P bulk DVDD: MPA0, MPA1, MPB0, MPB1; VREFP: MGPP, MGNP, MPOUT", size=1.05, textcolor="#52606d");
// }
ends mq_cdac_drv11

// Matched half-capacitor pair j=11
subckt mq_cdac_bit11 (VIN VG DH RL EN ENB TOP VREFP VREFN VSS DVDD EQBUS APGATE)
// CP*: user-specified 5% bottom-plate estimate for every physical MOM unit, not extraction.
// Series tails retain one unit parasitic at MID and one at B.
// APGATE PMOS assist connects each bottom plate to VIN.
// Additional ENB NMOS sharing retains a common EQBUS.
XHCTL (DH HHIB DVDD VREFN VSS) mq_cdac_ctl_h
XLCTL (RL LHIB DVDD VREFN VSS) mq_cdac_ctl_l
XDH (HHIB EN ENB BH VREFP VREFN VSS DVDD) mq_cdac_drv11
CH (TOP BH) cfmom_2t w=5e-08 s=2.4e-07 nr=6 lr=1.69e-06 stm=2 spm=4 multi=280
CPH (BH VSS) capacitor c=1.40320600e-14
MSH (BH VG VIN VSS) nch_ulvt_mac w=6.54e-06 l=3e-08 nf=4
XDL (LHIB EN ENB BL VREFP VREFN VSS DVDD) mq_cdac_drv11
CL (TOP BL) cfmom_2t w=5e-08 s=2.4e-07 nr=6 lr=1.69e-06 stm=2 spm=4 multi=280
CPL (BL VSS) capacitor c=1.40320600e-14
MSL (BL VG VIN VSS) nch_ulvt_mac w=6.54e-06 l=3e-08 nf=4
MEQ1 (BH APGATE VIN VREFP) pch_ulvt_mac w=6.54e-06 l=3e-08 nf=4
MEQ2 (BL APGATE VIN VREFP) pch_ulvt_mac w=6.54e-06 l=3e-08 nf=4
MSHAREH (BH ENB EQBUS VSS) nch_ulvt_mac w=6.54e-06 l=3e-08 nf=4
MSHAREL (BL ENB EQBUS VSS) nch_ulvt_mac w=6.54e-06 l=3e-08 nf=4
// @RNL {
//   {&VIN &VG &DH &RL &EN &ENB &TOP &VREFP &VREFN &VSS &DVDD &EQBUS &APGATE} @REMOVE-FROM $PORT_FILL_SET;
//   &VSS @ADD-TO $GROUND_NET_SET;
//   &VREFN @ADD-TO $GROUND_NET_SET;
//   #XHCTL @PLACE(0, 20) => @ORIENT("R0");
//   #XDH @PLACE(19, 18) => @ORIENT("R0");
//   &HHIB @WIRE {#XHCTL:2 #XDH:1};
//   %j1 = (115, 20);
//   %j2 = (38, 20);
//   %j3 = (52, 20);
//   %j4 = (66, 20);
//   %j5 = (84, 20);
//   &BH @WIRE {#XDH:4 %j2 %j3 %j4 %j5};
//   #CH @PLACE(100, 20) => @ORIENT("R270");
//   #CH @TEXT("", key="value");
//   #CH @TEXT("", key="name");
//   (100, 22.2) @TEXT("CH", size=1.05);
//   (100, 16.8) @TEXT("280 Cu", size=1.05);
//   &BH @WIRE {%j5 #CH:2};
//   &TOP @WIRE {#CH:1 %j1};
//   #CPH @PLACE(84, 12) => @ORIENT("R0");
//   #CPH @TEXT("", key="value");
//   #CPH @TEXT("", key="name");
//   (86, 13) @TEXT("CPH", size=1.05);
//   (86, 11) @TEXT("14.03 fF / 5%", size=1.05);
//   &BH @WIRE {%j5 #CPH:1};
//   #MSH @PLACE(38, 7) => @ORIENT("R0");
//   #MSH @SET-SYMBOL $NMOS;
//   #MSH @TEXT("ULVT 6.54u", key="model", size=1.05, dx=1.5, dy=-1);
//   #MSH @TEXT("MSH", key="name", size=1.1, dx=1.5, dy=1);
//   &BH @WIRE {%j2 #MSH:1};
//   #MEQ1 @PLACE(52, 7) => @ORIENT("MX");
//   #MEQ1 @SET-SYMBOL $PMOS;
//   #MEQ1 @TEXT("ULVT 6.54u", key="model", size=1.05, dx=1.5, dy=-1);
//   #MEQ1 @TEXT("MEQ1", key="name", size=1.1, dx=1.5, dy=1);
//   &BH @WIRE {%j3 #MEQ1:1};
//   #MSHAREH @PLACE(66, 7) => @ORIENT("R0");
//   #MSHAREH @SET-SYMBOL $NMOS;
//   #MSHAREH @TEXT("ULVT 6.54u", key="model", size=1.05, dx=1.5, dy=-1);
//   #MSHAREH @TEXT("MSHAREH", key="name", size=1.1, dx=1.5, dy=1);
//   &BH @WIRE {%j4 #MSHAREH:1};
//   (-8, 35) @TEXT("High bank", size=1.05);
//   #XLCTL @PLACE(0, -18) => @ORIENT("R0");
//   #XDL @PLACE(19, -20) => @ORIENT("R0");
//   &LHIB @WIRE {#XLCTL:2 #XDL:1};
//   %j6 = (115, -18);
//   %j7 = (38, -18);
//   %j8 = (52, -18);
//   %j9 = (66, -18);
//   %j10 = (84, -18);
//   &BL @WIRE {#XDL:4 %j7 %j8 %j9 %j10};
//   #CL @PLACE(100, -18) => @ORIENT("R270");
//   #CL @TEXT("", key="value");
//   #CL @TEXT("", key="name");
//   (100, -15.8) @TEXT("CL", size=1.05);
//   (100, -21.2) @TEXT("280 Cu", size=1.05);
//   &BL @WIRE {%j10 #CL:2};
//   &TOP @WIRE {#CL:1 %j6};
//   #CPL @PLACE(84, -26) => @ORIENT("R0");
//   #CPL @TEXT("", key="value");
//   #CPL @TEXT("", key="name");
//   (86, -25) @TEXT("CPL", size=1.05);
//   (86, -27) @TEXT("14.03 fF / 5%", size=1.05);
//   &BL @WIRE {%j10 #CPL:1};
//   #MSL @PLACE(38, -31) => @ORIENT("R0");
//   #MSL @SET-SYMBOL $NMOS;
//   #MSL @TEXT("ULVT 6.54u", key="model", size=1.05, dx=1.5, dy=-1);
//   #MSL @TEXT("MSL", key="name", size=1.1, dx=1.5, dy=1);
//   &BL @WIRE {%j7 #MSL:1};
//   #MEQ2 @PLACE(52, -31) => @ORIENT("MX");
//   #MEQ2 @SET-SYMBOL $PMOS;
//   #MEQ2 @TEXT("ULVT 6.54u", key="model", size=1.05, dx=1.5, dy=-1);
//   #MEQ2 @TEXT("MEQ2", key="name", size=1.1, dx=1.5, dy=1);
//   &BL @WIRE {%j8 #MEQ2:1};
//   #MSHAREL @PLACE(66, -31) => @ORIENT("R0");
//   #MSHAREL @SET-SYMBOL $NMOS;
//   #MSHAREL @TEXT("ULVT 6.54u", key="model", size=1.05, dx=1.5, dy=-1);
//   #MSHAREL @TEXT("MSHAREL", key="name", size=1.1, dx=1.5, dy=1);
//   &BL @WIRE {%j9 #MSHAREL:1};
//   (-8, -3) @TEXT("Low bank", size=1.05);
//   &TOP @WIRE {%j1 %j6};
//   (116, -3) @TEXT("TOP", size=1.05);
//   (-8, -42) @TEXT("Cu = 1.00229 fF. Cp = 5% of every physical MOM, including series MID.", size=1.05);
//   (-8, -45) @TEXT("DH -> buffer; RL -> inverter. Control supply: DVDD / VREFN; body: VSS.", size=1.05);
//   (-8, -48) @TEXT("5% Cp is a user estimate, not extraction.", size=1.05);
//   &DH @WIRE {#XHCTL:1 (-6, 20)};
//   (-6.3, 20) @TEXT("DH", size=1.05, halign="end", valign="middle");
//   &EN @WIRE {#XDH:2 (9, 16)};
//   (8.7, 16) @TEXT("EN", size=1.05, halign="end", valign="middle");
//   &ENB @WIRE {#XDH:3 (9, 13)};
//   (8.7, 13) @TEXT("ENB", size=1.05, halign="end", valign="middle");
//   %t14 = $SUPPLY @ATTACH &VREFP => @PLACE(22, 29);
//   &VREFP @WIRE {#XDH:5 %t14:p};
//   %t15 = $GROUND @ATTACH &VREFN => @PLACE(22, 7);
//   &VREFN @WIRE {#XDH:6 %t15:p};
//   %t16 = $GROUND @ATTACH &VSS => @PLACE(16, 7);
//   &VSS @WIRE {#XDH:7 %t16:p};
//   %t17 = $SUPPLY @ATTACH &DVDD => @PLACE(16, 29);
//   &DVDD @WIRE {#XDH:8 %t17:p};
//   %t18 = $GROUND @ATTACH &VSS => @PLACE(84, 8);
//   &VSS @WIRE {#CPH:2 %t18:p};
//   &VG @WIRE {#MSH:2 (33, 7)};
//   (32.7, 10.2) @TEXT("VG", size=1.05, halign="end", valign="middle");
//   &VIN @WIRE {#MSH:3 (38, 3)};
//   (38, 2.4) @TEXT("VIN", size=1.05, halign="middle", valign="top");
//   &APGATE @WIRE {#MEQ1:2 (47, 7)};
//   (46.7, 10.2) @TEXT("APGATE", size=1.05, halign="end", valign="middle");
//   &VIN @WIRE {#MEQ1:3 (52, 3)};
//   (52, 2.4) @TEXT("VIN", size=1.05, halign="middle", valign="top");
//   &ENB @WIRE {#MSHAREH:2 (61, 7)};
//   (60.7, 10.2) @TEXT("ENB", size=1.05, halign="end", valign="middle");
//   &EQBUS @WIRE {#MSHAREH:3 (66, 3)};
//   (66, 2.4) @TEXT("EQBUS", size=1.05, halign="middle", valign="top");
//   &RL @WIRE {#XLCTL:1 (-6, -18)};
//   (-6.3, -18) @TEXT("RL", size=1.05, halign="end", valign="middle");
//   &EN @WIRE {#XDL:2 (9, -22)};
//   (8.7, -22) @TEXT("EN", size=1.05, halign="end", valign="middle");
//   &ENB @WIRE {#XDL:3 (9, -25)};
//   (8.7, -25) @TEXT("ENB", size=1.05, halign="end", valign="middle");
//   %t28 = $SUPPLY @ATTACH &VREFP => @PLACE(22, -9);
//   &VREFP @WIRE {#XDL:5 %t28:p};
//   %t29 = $GROUND @ATTACH &VREFN => @PLACE(22, -31);
//   &VREFN @WIRE {#XDL:6 %t29:p};
//   %t30 = $GROUND @ATTACH &VSS => @PLACE(16, -31);
//   &VSS @WIRE {#XDL:7 %t30:p};
//   %t31 = $SUPPLY @ATTACH &DVDD => @PLACE(16, -9);
//   &DVDD @WIRE {#XDL:8 %t31:p};
//   %t32 = $GROUND @ATTACH &VSS => @PLACE(84, -30);
//   &VSS @WIRE {#CPL:2 %t32:p};
//   &VG @WIRE {#MSL:2 (33, -31)};
//   (32.7, -27.8) @TEXT("VG", size=1.05, halign="end", valign="middle");
//   &VIN @WIRE {#MSL:3 (38, -35)};
//   (38, -35.6) @TEXT("VIN", size=1.05, halign="middle", valign="top");
//   &APGATE @WIRE {#MEQ2:2 (47, -31)};
//   (46.7, -27.8) @TEXT("APGATE", size=1.05, halign="end", valign="middle");
//   &VIN @WIRE {#MEQ2:3 (52, -35)};
//   (52, -35.6) @TEXT("VIN", size=1.05, halign="middle", valign="top");
//   &ENB @WIRE {#MSHAREL:2 (61, -31)};
//   (60.7, -27.8) @TEXT("ENB", size=1.05, halign="end", valign="middle");
//   &EQBUS @WIRE {#MSHAREL:3 (66, -35)};
//   (66, -35.6) @TEXT("EQBUS", size=1.05, halign="middle", valign="top");
//   $JUNCTION @ATTACH %j2;
//   $JUNCTION @ATTACH %j3;
//   $JUNCTION @ATTACH %j4;
//   $JUNCTION @ATTACH %j5;
//   $JUNCTION @ATTACH %j7;
//   $JUNCTION @ATTACH %j8;
//   $JUNCTION @ATTACH %j9;
//   $JUNCTION @ATTACH %j10;
//   (-8, 44) @TEXT("N4 formal candidate / WIP | weight 11: 560 | matched H/L banks", size=1.4, bold=true, textcolor="#17365d");
//   (-8, 41.6) @TEXT("Drawing only | N bulk = VSS; L = 30 nm. P bulk VREFP: MEQ1, MEQ2", size=1.05, textcolor="#52606d");
// }
ends mq_cdac_bit11

// Reference-rail output driver j=10
subckt mq_cdac_drv10 (HIB EN ENB BP VREFP VREFN VSS DVDD)
// DVDD prelogic: PCOND = NOR(ENB,HIB); NOFF = NAND(EN,HIB).
// Reference-powered final inverters restore GP and GN to VREFP/VREFN.
// Actual current overlap, settling and device stress require measurement.
MPA0 (AP ENB DVDD DVDD) pch_ulvt_mac w=2.6e-06 l=3e-08 nf=2
MPA1 (PCOND HIB AP DVDD) pch_ulvt_mac w=2.6e-06 l=3e-08 nf=2
MNA0 (PCOND ENB VREFN VSS) nch_ulvt_mac w=1.3e-06 l=3e-08 nf=1
MNA1 (PCOND HIB VREFN VSS) nch_ulvt_mac w=1.3e-06 l=3e-08 nf=1
MPB0 (NOFF EN DVDD DVDD) pch_ulvt_mac w=1.3e-06 l=3e-08 nf=1
MPB1 (NOFF HIB DVDD DVDD) pch_ulvt_mac w=1.3e-06 l=3e-08 nf=1
MNB0 (NOFF EN BN VSS) nch_ulvt_mac w=1.3e-06 l=3e-08 nf=1
MNB1 (BN HIB VREFN VSS) nch_ulvt_mac w=1.3e-06 l=3e-08 nf=1
MGPN (GP PCOND VREFN VSS) nch_mac w=2.6e-06 l=3e-08 nf=2
MGPP (GP PCOND VREFP VREFP) pch_mac w=3.89e-06 l=3e-08 nf=2
MGNN (GN NOFF VREFN VSS) nch_mac w=2.6e-06 l=3e-08 nf=2
MGNP (GN NOFF VREFP VREFP) pch_mac w=1.3e-06 l=3e-08 nf=1
MNOUT (BP GN VREFN VSS) nch_mac w=4.86e-06 l=3e-08 nf=4
MPOUT (BP GP VREFP VREFP) pch_mac w=9.73e-06 l=3e-08 nf=7
// @RNL {
//   {&HIB &EN &ENB &BP &VREFP &VREFN &VSS &DVDD} @REMOVE-FROM $PORT_FILL_SET;
//   &VSS @ADD-TO $GROUND_NET_SET;
//   &VREFN @ADD-TO $GROUND_NET_SET;
//   #MPA0 @PLACE(8, 32) => @ORIENT("R0");
//   #MPA0 @SET-SYMBOL $PMOS;
//   #MPA0 @TEXT("ULVT 2.6u", key="model", size=1.05, dx=1.5, dy=-1);
//   #MPA0 @TEXT("MPA0", key="name", size=1.1, dx=1.5, dy=1);
//   #MPA1 @PLACE(8, 24) => @ORIENT("R0");
//   #MPA1 @SET-SYMBOL $PMOS;
//   #MPA1 @TEXT("ULVT 2.6u", key="model", size=1.05, dx=1.5, dy=-1);
//   #MPA1 @TEXT("MPA1", key="name", size=1.1, dx=1.5, dy=1);
//   #MNA0 @PLACE(0, 8) => @ORIENT("R0");
//   #MNA0 @SET-SYMBOL $NMOS;
//   #MNA0 @TEXT("ULVT 1.3u", key="model", size=1.05, dx=1.5, dy=-1);
//   #MNA0 @TEXT("MNA0", key="name", size=1.1, dx=1.5, dy=1);
//   #MNA1 @PLACE(16, 8) => @ORIENT("R0");
//   #MNA1 @SET-SYMBOL $NMOS;
//   #MNA1 @TEXT("ULVT 1.3u", key="model", size=1.05, dx=1.5, dy=-1);
//   #MNA1 @TEXT("MNA1", key="name", size=1.1, dx=1.5, dy=1);
//   #MPB0 @PLACE(0, -8) => @ORIENT("R0");
//   #MPB0 @SET-SYMBOL $PMOS;
//   #MPB0 @TEXT("ULVT 1.3u", key="model", size=1.05, dx=1.5, dy=-1);
//   #MPB0 @TEXT("MPB0", key="name", size=1.1, dx=1.5, dy=1);
//   #MPB1 @PLACE(16, -8) => @ORIENT("R0");
//   #MPB1 @SET-SYMBOL $PMOS;
//   #MPB1 @TEXT("ULVT 1.3u", key="model", size=1.05, dx=1.5, dy=-1);
//   #MPB1 @TEXT("MPB1", key="name", size=1.1, dx=1.5, dy=1);
//   #MNB0 @PLACE(8, -24) => @ORIENT("R0");
//   #MNB0 @SET-SYMBOL $NMOS;
//   #MNB0 @TEXT("ULVT 1.3u", key="model", size=1.05, dx=1.5, dy=-1);
//   #MNB0 @TEXT("MNB0", key="name", size=1.1, dx=1.5, dy=1);
//   #MNB1 @PLACE(8, -32) => @ORIENT("R0");
//   #MNB1 @SET-SYMBOL $NMOS;
//   #MNB1 @TEXT("ULVT 1.3u", key="model", size=1.05, dx=1.5, dy=-1);
//   #MNB1 @TEXT("MNB1", key="name", size=1.1, dx=1.5, dy=1);
//   #MPOUT @PLACE(76, 18) => @ORIENT("R0");
//   #MPOUT @SET-SYMBOL $PMOS;
//   #MPOUT @TEXT("SVT 9.73u", key="model", size=1.05, dx=1.5, dy=-1);
//   #MPOUT @TEXT("MPOUT", key="name", size=1.1, dx=1.5, dy=1);
//   #MNOUT @PLACE(76, -18) => @ORIENT("R0");
//   #MNOUT @SET-SYMBOL $NMOS;
//   #MNOUT @TEXT("SVT 4.86u", key="model", size=1.05, dx=1.5, dy=-1);
//   #MNOUT @TEXT("MNOUT", key="name", size=1.1, dx=1.5, dy=1);
//   &AP @WIRE {#MPA0:1 #MPA1:3};
//   (10, 28) @TEXT("AP", size=1.05);
//   %j1 = (8, 16);
//   &PCOND @WIRE {#MNA0:1 (0, 16) %j1 (16, 16) #MNA1:1};
//   &PCOND @WIRE {#MPA1:1 %j1};
//   #MGPN @PLACE(43, 9) => @ORIENT("R0");
//   #MGPN @SET-SYMBOL $NMOS;
//   #MGPN @TEXT("SVT 2.6u", key="model", size=1.05, dx=1.5, dy=-1);
//   #MGPN @TEXT("MGPN", key="name", size=1.1, dx=1.5, dy=1);
//   #MGPP @PLACE(43, 23) => @ORIENT("R0");
//   #MGPP @SET-SYMBOL $PMOS;
//   #MGPP @TEXT("SVT 3.89u", key="model", size=1.05, dx=1.5, dy=-1);
//   #MGPP @TEXT("MGPP", key="name", size=1.1, dx=1.5, dy=1);
//   %j2 = (43, 16);
//   %j3 = (38, 16);
//   &GP @WIRE {#MGPN:1 %j2 #MGPP:1};
//   &PCOND @WIRE {#MGPN:2 (38, 9) %j3 (38, 23) #MGPP:2};
//   &PCOND @WIRE {%j1 %j3};
//   &GP @WIRE {%j2 (65, 16) (65, 18) #MPOUT:2};
//   %j4 = (8, -16);
//   &NOFF @WIRE {#MPB0:1 (0, -16) %j4 (16, -16) #MPB1:1};
//   &NOFF @WIRE {#MNB0:1 %j4};
//   &BN @WIRE {#MNB0:3 #MNB1:1};
//   (18, -14) @TEXT("NOFF", size=1.05);
//   #MGNN @PLACE(43, -23) => @ORIENT("R0");
//   #MGNN @SET-SYMBOL $NMOS;
//   #MGNN @TEXT("SVT 2.6u", key="model", size=1.05, dx=1.5, dy=-1);
//   #MGNN @TEXT("MGNN", key="name", size=1.1, dx=1.5, dy=1);
//   #MGNP @PLACE(43, -9) => @ORIENT("R0");
//   #MGNP @SET-SYMBOL $PMOS;
//   #MGNP @TEXT("SVT 1.3u", key="model", size=1.05, dx=1.5, dy=-1);
//   #MGNP @TEXT("MGNP", key="name", size=1.1, dx=1.5, dy=1);
//   %j5 = (43, -16);
//   %j6 = (38, -16);
//   &GN @WIRE {#MGNN:1 %j5 #MGNP:1};
//   &NOFF @WIRE {#MGNN:2 (38, -23) %j6 (38, -9) #MGNP:2};
//   &NOFF @WIRE {%j4 %j6};
//   &GN @WIRE {%j5 (65, -16) (65, -18) #MNOUT:2};
//   %j7 = (76, 0);
//   &BP @WIRE {#MPOUT:1 %j7 #MNOUT:1};
//   &BP @WIRE {%j7 (85, 0)};
//   (85, 1) @TEXT("BP", size=1.05);
//   (-5, 42) @TEXT("NOR: PCOND = ~(ENB | HIB)", size=1.05);
//   (-5, -42) @TEXT("NAND: NOFF = ~(EN & HIB)", size=1.05);
//   (31, 39) @TEXT("Reference gate drivers", size=1.05);
//   (67, 39) @TEXT("Output rail switch", size=1.05);
//   &ENB @WIRE {#MPA0:2 (3, 32)};
//   (2.7, 32) @TEXT("ENB", size=1.05, halign="end", valign="middle");
//   %t9 = $SUPPLY @ATTACH &DVDD => @PLACE(8, 36);
//   &DVDD @WIRE {#MPA0:3 %t9:p};
//   &HIB @WIRE {#MPA1:2 (3, 24)};
//   (2.7, 24) @TEXT("HIB", size=1.05, halign="end", valign="middle");
//   &ENB @WIRE {#MNA0:2 (-5, 8)};
//   (-5.3, 8) @TEXT("ENB", size=1.05, halign="end", valign="middle");
//   %t12 = $GROUND @ATTACH &VREFN => @PLACE(0, 4);
//   &VREFN @WIRE {#MNA0:3 %t12:p};
//   &HIB @WIRE {#MNA1:2 (11, 8)};
//   (10.7, 8) @TEXT("HIB", size=1.05, halign="end", valign="middle");
//   %t14 = $GROUND @ATTACH &VREFN => @PLACE(16, 4);
//   &VREFN @WIRE {#MNA1:3 %t14:p};
//   &EN @WIRE {#MPB0:2 (-5, -8)};
//   (-5.3, -8) @TEXT("EN", size=1.05, halign="end", valign="middle");
//   %t16 = $SUPPLY @ATTACH &DVDD => @PLACE(0, -4);
//   &DVDD @WIRE {#MPB0:3 %t16:p};
//   &HIB @WIRE {#MPB1:2 (11, -8)};
//   (10.7, -8) @TEXT("HIB", size=1.05, halign="end", valign="middle");
//   %t18 = $SUPPLY @ATTACH &DVDD => @PLACE(16, -4);
//   &DVDD @WIRE {#MPB1:3 %t18:p};
//   &EN @WIRE {#MNB0:2 (3, -24)};
//   (2.7, -24) @TEXT("EN", size=1.05, halign="end", valign="middle");
//   &HIB @WIRE {#MNB1:2 (3, -32)};
//   (2.7, -32) @TEXT("HIB", size=1.05, halign="end", valign="middle");
//   %t21 = $GROUND @ATTACH &VREFN => @PLACE(8, -36);
//   &VREFN @WIRE {#MNB1:3 %t21:p};
//   %t22 = $SUPPLY @ATTACH &VREFP => @PLACE(76, 22);
//   &VREFP @WIRE {#MPOUT:3 %t22:p};
//   %t23 = $GROUND @ATTACH &VREFN => @PLACE(76, -22);
//   &VREFN @WIRE {#MNOUT:3 %t23:p};
//   %t24 = $GROUND @ATTACH &VREFN => @PLACE(43, 5);
//   &VREFN @WIRE {#MGPN:3 %t24:p};
//   %t25 = $SUPPLY @ATTACH &VREFP => @PLACE(43, 27);
//   &VREFP @WIRE {#MGPP:3 %t25:p};
//   %t26 = $GROUND @ATTACH &VREFN => @PLACE(43, -27);
//   &VREFN @WIRE {#MGNN:3 %t26:p};
//   %t27 = $SUPPLY @ATTACH &VREFP => @PLACE(43, -5);
//   &VREFP @WIRE {#MGNP:3 %t27:p};
//   $JUNCTION @ATTACH %j1;
//   $JUNCTION @ATTACH %j2;
//   $JUNCTION @ATTACH %j3;
//   $JUNCTION @ATTACH %j4;
//   $JUNCTION @ATTACH %j5;
//   $JUNCTION @ATTACH %j6;
//   $JUNCTION @ATTACH %j7;
//   (-7, 51) @TEXT("N4 formal candidate / WIP | mq_cdac_drv10 | isolated DVDD logic / VREFP output", size=1.4, bold=true, textcolor="#17365d");
//   (-7, 48.6) @TEXT("Drawing only | N bulk = VSS; L = 30 nm. P bulk DVDD: MPA0, MPA1, MPB0, MPB1; VREFP: MGPP, MGNP, MPOUT", size=1.05, textcolor="#52606d");
// }
ends mq_cdac_drv10

// Matched half-capacitor pair j=10
subckt mq_cdac_bit10 (VIN VG DH RL EN ENB TOP VREFP VREFN VSS DVDD EQBUS APGATE)
// CP*: user-specified 5% bottom-plate estimate for every physical MOM unit, not extraction.
// Series tails retain one unit parasitic at MID and one at B.
// APGATE PMOS assist connects each bottom plate to VIN.
// Additional ENB NMOS sharing retains a common EQBUS.
XHCTL (DH HHIB DVDD VREFN VSS) mq_cdac_ctl_h
XLCTL (RL LHIB DVDD VREFN VSS) mq_cdac_ctl_l
XDH (HHIB EN ENB BH VREFP VREFN VSS DVDD) mq_cdac_drv10
CH (TOP BH) cfmom_2t w=5e-08 s=2.4e-07 nr=6 lr=1.69e-06 stm=2 spm=4 multi=159
CPH (BH VSS) capacitor c=7.9682055e-15
MSH (BH VG VIN VSS) nch_ulvt_mac w=3.71e-06 l=3e-08 nf=2
XDL (LHIB EN ENB BL VREFP VREFN VSS DVDD) mq_cdac_drv10
CL (TOP BL) cfmom_2t w=5e-08 s=2.4e-07 nr=6 lr=1.69e-06 stm=2 spm=4 multi=159
CPL (BL VSS) capacitor c=7.9682055e-15
MSL (BL VG VIN VSS) nch_ulvt_mac w=3.71e-06 l=3e-08 nf=2
MEQ1 (BH APGATE VIN VREFP) pch_ulvt_mac w=3.71e-06 l=3e-08 nf=2
MEQ2 (BL APGATE VIN VREFP) pch_ulvt_mac w=3.71e-06 l=3e-08 nf=2
MSHAREH (BH ENB EQBUS VSS) nch_ulvt_mac w=3.71e-06 l=3e-08 nf=2
MSHAREL (BL ENB EQBUS VSS) nch_ulvt_mac w=3.71e-06 l=3e-08 nf=2
// @RNL {
//   {&VIN &VG &DH &RL &EN &ENB &TOP &VREFP &VREFN &VSS &DVDD &EQBUS &APGATE} @REMOVE-FROM $PORT_FILL_SET;
//   &VSS @ADD-TO $GROUND_NET_SET;
//   &VREFN @ADD-TO $GROUND_NET_SET;
//   #XHCTL @PLACE(0, 20) => @ORIENT("R0");
//   #XDH @PLACE(19, 18) => @ORIENT("R0");
//   &HHIB @WIRE {#XHCTL:2 #XDH:1};
//   %j1 = (115, 20);
//   %j2 = (38, 20);
//   %j3 = (52, 20);
//   %j4 = (66, 20);
//   %j5 = (84, 20);
//   &BH @WIRE {#XDH:4 %j2 %j3 %j4 %j5};
//   #CH @PLACE(100, 20) => @ORIENT("R270");
//   #CH @TEXT("", key="value");
//   #CH @TEXT("", key="name");
//   (100, 22.2) @TEXT("CH", size=1.05);
//   (100, 16.8) @TEXT("159 Cu", size=1.05);
//   &BH @WIRE {%j5 #CH:2};
//   &TOP @WIRE {#CH:1 %j1};
//   #CPH @PLACE(84, 12) => @ORIENT("R0");
//   #CPH @TEXT("", key="value");
//   #CPH @TEXT("", key="name");
//   (86, 13) @TEXT("CPH", size=1.05);
//   (86, 11) @TEXT("7.968 fF / 5%", size=1.05);
//   &BH @WIRE {%j5 #CPH:1};
//   #MSH @PLACE(38, 7) => @ORIENT("R0");
//   #MSH @SET-SYMBOL $NMOS;
//   #MSH @TEXT("ULVT 3.71u", key="model", size=1.05, dx=1.5, dy=-1);
//   #MSH @TEXT("MSH", key="name", size=1.1, dx=1.5, dy=1);
//   &BH @WIRE {%j2 #MSH:1};
//   #MEQ1 @PLACE(52, 7) => @ORIENT("MX");
//   #MEQ1 @SET-SYMBOL $PMOS;
//   #MEQ1 @TEXT("ULVT 3.71u", key="model", size=1.05, dx=1.5, dy=-1);
//   #MEQ1 @TEXT("MEQ1", key="name", size=1.1, dx=1.5, dy=1);
//   &BH @WIRE {%j3 #MEQ1:1};
//   #MSHAREH @PLACE(66, 7) => @ORIENT("R0");
//   #MSHAREH @SET-SYMBOL $NMOS;
//   #MSHAREH @TEXT("ULVT 3.71u", key="model", size=1.05, dx=1.5, dy=-1);
//   #MSHAREH @TEXT("MSHAREH", key="name", size=1.1, dx=1.5, dy=1);
//   &BH @WIRE {%j4 #MSHAREH:1};
//   (-8, 35) @TEXT("High bank", size=1.05);
//   #XLCTL @PLACE(0, -18) => @ORIENT("R0");
//   #XDL @PLACE(19, -20) => @ORIENT("R0");
//   &LHIB @WIRE {#XLCTL:2 #XDL:1};
//   %j6 = (115, -18);
//   %j7 = (38, -18);
//   %j8 = (52, -18);
//   %j9 = (66, -18);
//   %j10 = (84, -18);
//   &BL @WIRE {#XDL:4 %j7 %j8 %j9 %j10};
//   #CL @PLACE(100, -18) => @ORIENT("R270");
//   #CL @TEXT("", key="value");
//   #CL @TEXT("", key="name");
//   (100, -15.8) @TEXT("CL", size=1.05);
//   (100, -21.2) @TEXT("159 Cu", size=1.05);
//   &BL @WIRE {%j10 #CL:2};
//   &TOP @WIRE {#CL:1 %j6};
//   #CPL @PLACE(84, -26) => @ORIENT("R0");
//   #CPL @TEXT("", key="value");
//   #CPL @TEXT("", key="name");
//   (86, -25) @TEXT("CPL", size=1.05);
//   (86, -27) @TEXT("7.968 fF / 5%", size=1.05);
//   &BL @WIRE {%j10 #CPL:1};
//   #MSL @PLACE(38, -31) => @ORIENT("R0");
//   #MSL @SET-SYMBOL $NMOS;
//   #MSL @TEXT("ULVT 3.71u", key="model", size=1.05, dx=1.5, dy=-1);
//   #MSL @TEXT("MSL", key="name", size=1.1, dx=1.5, dy=1);
//   &BL @WIRE {%j7 #MSL:1};
//   #MEQ2 @PLACE(52, -31) => @ORIENT("MX");
//   #MEQ2 @SET-SYMBOL $PMOS;
//   #MEQ2 @TEXT("ULVT 3.71u", key="model", size=1.05, dx=1.5, dy=-1);
//   #MEQ2 @TEXT("MEQ2", key="name", size=1.1, dx=1.5, dy=1);
//   &BL @WIRE {%j8 #MEQ2:1};
//   #MSHAREL @PLACE(66, -31) => @ORIENT("R0");
//   #MSHAREL @SET-SYMBOL $NMOS;
//   #MSHAREL @TEXT("ULVT 3.71u", key="model", size=1.05, dx=1.5, dy=-1);
//   #MSHAREL @TEXT("MSHAREL", key="name", size=1.1, dx=1.5, dy=1);
//   &BL @WIRE {%j9 #MSHAREL:1};
//   (-8, -3) @TEXT("Low bank", size=1.05);
//   &TOP @WIRE {%j1 %j6};
//   (116, -3) @TEXT("TOP", size=1.05);
//   (-8, -42) @TEXT("Cu = 1.00229 fF. Cp = 5% of every physical MOM, including series MID.", size=1.05);
//   (-8, -45) @TEXT("DH -> buffer; RL -> inverter. Control supply: DVDD / VREFN; body: VSS.", size=1.05);
//   (-8, -48) @TEXT("5% Cp is a user estimate, not extraction.", size=1.05);
//   &DH @WIRE {#XHCTL:1 (-6, 20)};
//   (-6.3, 20) @TEXT("DH", size=1.05, halign="end", valign="middle");
//   &EN @WIRE {#XDH:2 (9, 16)};
//   (8.7, 16) @TEXT("EN", size=1.05, halign="end", valign="middle");
//   &ENB @WIRE {#XDH:3 (9, 13)};
//   (8.7, 13) @TEXT("ENB", size=1.05, halign="end", valign="middle");
//   %t14 = $SUPPLY @ATTACH &VREFP => @PLACE(22, 29);
//   &VREFP @WIRE {#XDH:5 %t14:p};
//   %t15 = $GROUND @ATTACH &VREFN => @PLACE(22, 7);
//   &VREFN @WIRE {#XDH:6 %t15:p};
//   %t16 = $GROUND @ATTACH &VSS => @PLACE(16, 7);
//   &VSS @WIRE {#XDH:7 %t16:p};
//   %t17 = $SUPPLY @ATTACH &DVDD => @PLACE(16, 29);
//   &DVDD @WIRE {#XDH:8 %t17:p};
//   %t18 = $GROUND @ATTACH &VSS => @PLACE(84, 8);
//   &VSS @WIRE {#CPH:2 %t18:p};
//   &VG @WIRE {#MSH:2 (33, 7)};
//   (32.7, 10.2) @TEXT("VG", size=1.05, halign="end", valign="middle");
//   &VIN @WIRE {#MSH:3 (38, 3)};
//   (38, 2.4) @TEXT("VIN", size=1.05, halign="middle", valign="top");
//   &APGATE @WIRE {#MEQ1:2 (47, 7)};
//   (46.7, 10.2) @TEXT("APGATE", size=1.05, halign="end", valign="middle");
//   &VIN @WIRE {#MEQ1:3 (52, 3)};
//   (52, 2.4) @TEXT("VIN", size=1.05, halign="middle", valign="top");
//   &ENB @WIRE {#MSHAREH:2 (61, 7)};
//   (60.7, 10.2) @TEXT("ENB", size=1.05, halign="end", valign="middle");
//   &EQBUS @WIRE {#MSHAREH:3 (66, 3)};
//   (66, 2.4) @TEXT("EQBUS", size=1.05, halign="middle", valign="top");
//   &RL @WIRE {#XLCTL:1 (-6, -18)};
//   (-6.3, -18) @TEXT("RL", size=1.05, halign="end", valign="middle");
//   &EN @WIRE {#XDL:2 (9, -22)};
//   (8.7, -22) @TEXT("EN", size=1.05, halign="end", valign="middle");
//   &ENB @WIRE {#XDL:3 (9, -25)};
//   (8.7, -25) @TEXT("ENB", size=1.05, halign="end", valign="middle");
//   %t28 = $SUPPLY @ATTACH &VREFP => @PLACE(22, -9);
//   &VREFP @WIRE {#XDL:5 %t28:p};
//   %t29 = $GROUND @ATTACH &VREFN => @PLACE(22, -31);
//   &VREFN @WIRE {#XDL:6 %t29:p};
//   %t30 = $GROUND @ATTACH &VSS => @PLACE(16, -31);
//   &VSS @WIRE {#XDL:7 %t30:p};
//   %t31 = $SUPPLY @ATTACH &DVDD => @PLACE(16, -9);
//   &DVDD @WIRE {#XDL:8 %t31:p};
//   %t32 = $GROUND @ATTACH &VSS => @PLACE(84, -30);
//   &VSS @WIRE {#CPL:2 %t32:p};
//   &VG @WIRE {#MSL:2 (33, -31)};
//   (32.7, -27.8) @TEXT("VG", size=1.05, halign="end", valign="middle");
//   &VIN @WIRE {#MSL:3 (38, -35)};
//   (38, -35.6) @TEXT("VIN", size=1.05, halign="middle", valign="top");
//   &APGATE @WIRE {#MEQ2:2 (47, -31)};
//   (46.7, -27.8) @TEXT("APGATE", size=1.05, halign="end", valign="middle");
//   &VIN @WIRE {#MEQ2:3 (52, -35)};
//   (52, -35.6) @TEXT("VIN", size=1.05, halign="middle", valign="top");
//   &ENB @WIRE {#MSHAREL:2 (61, -31)};
//   (60.7, -27.8) @TEXT("ENB", size=1.05, halign="end", valign="middle");
//   &EQBUS @WIRE {#MSHAREL:3 (66, -35)};
//   (66, -35.6) @TEXT("EQBUS", size=1.05, halign="middle", valign="top");
//   $JUNCTION @ATTACH %j2;
//   $JUNCTION @ATTACH %j3;
//   $JUNCTION @ATTACH %j4;
//   $JUNCTION @ATTACH %j5;
//   $JUNCTION @ATTACH %j7;
//   $JUNCTION @ATTACH %j8;
//   $JUNCTION @ATTACH %j9;
//   $JUNCTION @ATTACH %j10;
//   (-8, 44) @TEXT("N4 formal candidate / WIP | weight 10: 318 | matched H/L banks", size=1.4, bold=true, textcolor="#17365d");
//   (-8, 41.6) @TEXT("Drawing only | N bulk = VSS; L = 30 nm. P bulk VREFP: MEQ1, MEQ2", size=1.05, textcolor="#52606d");
// }
ends mq_cdac_bit10

// Reference-rail output driver j=9
subckt mq_cdac_drv9 (HIB EN ENB BP VREFP VREFN VSS DVDD)
// DVDD prelogic: PCOND = NOR(ENB,HIB); NOFF = NAND(EN,HIB).
// Reference-powered final inverters restore GP and GN to VREFP/VREFN.
// Actual current overlap, settling and device stress require measurement.
MPA0 (AP ENB DVDD DVDD) pch_ulvt_mac w=1.47e-06 l=3e-08 nf=1
MPA1 (PCOND HIB AP DVDD) pch_ulvt_mac w=1.47e-06 l=3e-08 nf=1
MNA0 (PCOND ENB VREFN VSS) nch_ulvt_mac w=7.35e-07 l=3e-08 nf=1
MNA1 (PCOND HIB VREFN VSS) nch_ulvt_mac w=7.35e-07 l=3e-08 nf=1
MPB0 (NOFF EN DVDD DVDD) pch_ulvt_mac w=7.35e-07 l=3e-08 nf=1
MPB1 (NOFF HIB DVDD DVDD) pch_ulvt_mac w=7.35e-07 l=3e-08 nf=1
MNB0 (NOFF EN BN VSS) nch_ulvt_mac w=7.35e-07 l=3e-08 nf=1
MNB1 (BN HIB VREFN VSS) nch_ulvt_mac w=7.35e-07 l=3e-08 nf=1
MGPN (GP PCOND VREFN VSS) nch_mac w=1.47e-06 l=3e-08 nf=1
MGPP (GP PCOND VREFP VREFP) pch_mac w=2.2e-06 l=3e-08 nf=2
MGNN (GN NOFF VREFN VSS) nch_mac w=1.47e-06 l=3e-08 nf=1
MGNP (GN NOFF VREFP VREFP) pch_mac w=7.35e-07 l=3e-08 nf=1
MNOUT (BP GN VREFN VSS) nch_mac w=8.25e-06 l=3e-08 nf=6
MPOUT (BP GP VREFP VREFP) pch_mac w=1.65e-05 l=3e-08 nf=12
// @RNL {
//   {&HIB &EN &ENB &BP &VREFP &VREFN &VSS &DVDD} @REMOVE-FROM $PORT_FILL_SET;
//   &VSS @ADD-TO $GROUND_NET_SET;
//   &VREFN @ADD-TO $GROUND_NET_SET;
//   #MPA0 @PLACE(8, 32) => @ORIENT("R0");
//   #MPA0 @SET-SYMBOL $PMOS;
//   #MPA0 @TEXT("ULVT 1.47u", key="model", size=1.05, dx=1.5, dy=-1);
//   #MPA0 @TEXT("MPA0", key="name", size=1.1, dx=1.5, dy=1);
//   #MPA1 @PLACE(8, 24) => @ORIENT("R0");
//   #MPA1 @SET-SYMBOL $PMOS;
//   #MPA1 @TEXT("ULVT 1.47u", key="model", size=1.05, dx=1.5, dy=-1);
//   #MPA1 @TEXT("MPA1", key="name", size=1.1, dx=1.5, dy=1);
//   #MNA0 @PLACE(0, 8) => @ORIENT("R0");
//   #MNA0 @SET-SYMBOL $NMOS;
//   #MNA0 @TEXT("ULVT 0.735u", key="model", size=1.05, dx=1.5, dy=-1);
//   #MNA0 @TEXT("MNA0", key="name", size=1.1, dx=1.5, dy=1);
//   #MNA1 @PLACE(16, 8) => @ORIENT("R0");
//   #MNA1 @SET-SYMBOL $NMOS;
//   #MNA1 @TEXT("ULVT 0.735u", key="model", size=1.05, dx=1.5, dy=-1);
//   #MNA1 @TEXT("MNA1", key="name", size=1.1, dx=1.5, dy=1);
//   #MPB0 @PLACE(0, -8) => @ORIENT("R0");
//   #MPB0 @SET-SYMBOL $PMOS;
//   #MPB0 @TEXT("ULVT 0.735u", key="model", size=1.05, dx=1.5, dy=-1);
//   #MPB0 @TEXT("MPB0", key="name", size=1.1, dx=1.5, dy=1);
//   #MPB1 @PLACE(16, -8) => @ORIENT("R0");
//   #MPB1 @SET-SYMBOL $PMOS;
//   #MPB1 @TEXT("ULVT 0.735u", key="model", size=1.05, dx=1.5, dy=-1);
//   #MPB1 @TEXT("MPB1", key="name", size=1.1, dx=1.5, dy=1);
//   #MNB0 @PLACE(8, -24) => @ORIENT("R0");
//   #MNB0 @SET-SYMBOL $NMOS;
//   #MNB0 @TEXT("ULVT 0.735u", key="model", size=1.05, dx=1.5, dy=-1);
//   #MNB0 @TEXT("MNB0", key="name", size=1.1, dx=1.5, dy=1);
//   #MNB1 @PLACE(8, -32) => @ORIENT("R0");
//   #MNB1 @SET-SYMBOL $NMOS;
//   #MNB1 @TEXT("ULVT 0.735u", key="model", size=1.05, dx=1.5, dy=-1);
//   #MNB1 @TEXT("MNB1", key="name", size=1.1, dx=1.5, dy=1);
//   #MPOUT @PLACE(76, 18) => @ORIENT("R0");
//   #MPOUT @SET-SYMBOL $PMOS;
//   #MPOUT @TEXT("SVT 16.5u", key="model", size=1.05, dx=1.5, dy=-1);
//   #MPOUT @TEXT("MPOUT", key="name", size=1.1, dx=1.5, dy=1);
//   #MNOUT @PLACE(76, -18) => @ORIENT("R0");
//   #MNOUT @SET-SYMBOL $NMOS;
//   #MNOUT @TEXT("SVT 8.25u", key="model", size=1.05, dx=1.5, dy=-1);
//   #MNOUT @TEXT("MNOUT", key="name", size=1.1, dx=1.5, dy=1);
//   &AP @WIRE {#MPA0:1 #MPA1:3};
//   (10, 28) @TEXT("AP", size=1.05);
//   %j1 = (8, 16);
//   &PCOND @WIRE {#MNA0:1 (0, 16) %j1 (16, 16) #MNA1:1};
//   &PCOND @WIRE {#MPA1:1 %j1};
//   #MGPN @PLACE(43, 9) => @ORIENT("R0");
//   #MGPN @SET-SYMBOL $NMOS;
//   #MGPN @TEXT("SVT 1.47u", key="model", size=1.05, dx=1.5, dy=-1);
//   #MGPN @TEXT("MGPN", key="name", size=1.1, dx=1.5, dy=1);
//   #MGPP @PLACE(43, 23) => @ORIENT("R0");
//   #MGPP @SET-SYMBOL $PMOS;
//   #MGPP @TEXT("SVT 2.2u", key="model", size=1.05, dx=1.5, dy=-1);
//   #MGPP @TEXT("MGPP", key="name", size=1.1, dx=1.5, dy=1);
//   %j2 = (43, 16);
//   %j3 = (38, 16);
//   &GP @WIRE {#MGPN:1 %j2 #MGPP:1};
//   &PCOND @WIRE {#MGPN:2 (38, 9) %j3 (38, 23) #MGPP:2};
//   &PCOND @WIRE {%j1 %j3};
//   &GP @WIRE {%j2 (65, 16) (65, 18) #MPOUT:2};
//   %j4 = (8, -16);
//   &NOFF @WIRE {#MPB0:1 (0, -16) %j4 (16, -16) #MPB1:1};
//   &NOFF @WIRE {#MNB0:1 %j4};
//   &BN @WIRE {#MNB0:3 #MNB1:1};
//   (18, -14) @TEXT("NOFF", size=1.05);
//   #MGNN @PLACE(43, -23) => @ORIENT("R0");
//   #MGNN @SET-SYMBOL $NMOS;
//   #MGNN @TEXT("SVT 1.47u", key="model", size=1.05, dx=1.5, dy=-1);
//   #MGNN @TEXT("MGNN", key="name", size=1.1, dx=1.5, dy=1);
//   #MGNP @PLACE(43, -9) => @ORIENT("R0");
//   #MGNP @SET-SYMBOL $PMOS;
//   #MGNP @TEXT("SVT 0.735u", key="model", size=1.05, dx=1.5, dy=-1);
//   #MGNP @TEXT("MGNP", key="name", size=1.1, dx=1.5, dy=1);
//   %j5 = (43, -16);
//   %j6 = (38, -16);
//   &GN @WIRE {#MGNN:1 %j5 #MGNP:1};
//   &NOFF @WIRE {#MGNN:2 (38, -23) %j6 (38, -9) #MGNP:2};
//   &NOFF @WIRE {%j4 %j6};
//   &GN @WIRE {%j5 (65, -16) (65, -18) #MNOUT:2};
//   %j7 = (76, 0);
//   &BP @WIRE {#MPOUT:1 %j7 #MNOUT:1};
//   &BP @WIRE {%j7 (85, 0)};
//   (85, 1) @TEXT("BP", size=1.05);
//   (-5, 42) @TEXT("NOR: PCOND = ~(ENB | HIB)", size=1.05);
//   (-5, -42) @TEXT("NAND: NOFF = ~(EN & HIB)", size=1.05);
//   (31, 39) @TEXT("Reference gate drivers", size=1.05);
//   (67, 39) @TEXT("Output rail switch", size=1.05);
//   &ENB @WIRE {#MPA0:2 (3, 32)};
//   (2.7, 32) @TEXT("ENB", size=1.05, halign="end", valign="middle");
//   %t9 = $SUPPLY @ATTACH &DVDD => @PLACE(8, 36);
//   &DVDD @WIRE {#MPA0:3 %t9:p};
//   &HIB @WIRE {#MPA1:2 (3, 24)};
//   (2.7, 24) @TEXT("HIB", size=1.05, halign="end", valign="middle");
//   &ENB @WIRE {#MNA0:2 (-5, 8)};
//   (-5.3, 8) @TEXT("ENB", size=1.05, halign="end", valign="middle");
//   %t12 = $GROUND @ATTACH &VREFN => @PLACE(0, 4);
//   &VREFN @WIRE {#MNA0:3 %t12:p};
//   &HIB @WIRE {#MNA1:2 (11, 8)};
//   (10.7, 8) @TEXT("HIB", size=1.05, halign="end", valign="middle");
//   %t14 = $GROUND @ATTACH &VREFN => @PLACE(16, 4);
//   &VREFN @WIRE {#MNA1:3 %t14:p};
//   &EN @WIRE {#MPB0:2 (-5, -8)};
//   (-5.3, -8) @TEXT("EN", size=1.05, halign="end", valign="middle");
//   %t16 = $SUPPLY @ATTACH &DVDD => @PLACE(0, -4);
//   &DVDD @WIRE {#MPB0:3 %t16:p};
//   &HIB @WIRE {#MPB1:2 (11, -8)};
//   (10.7, -8) @TEXT("HIB", size=1.05, halign="end", valign="middle");
//   %t18 = $SUPPLY @ATTACH &DVDD => @PLACE(16, -4);
//   &DVDD @WIRE {#MPB1:3 %t18:p};
//   &EN @WIRE {#MNB0:2 (3, -24)};
//   (2.7, -24) @TEXT("EN", size=1.05, halign="end", valign="middle");
//   &HIB @WIRE {#MNB1:2 (3, -32)};
//   (2.7, -32) @TEXT("HIB", size=1.05, halign="end", valign="middle");
//   %t21 = $GROUND @ATTACH &VREFN => @PLACE(8, -36);
//   &VREFN @WIRE {#MNB1:3 %t21:p};
//   %t22 = $SUPPLY @ATTACH &VREFP => @PLACE(76, 22);
//   &VREFP @WIRE {#MPOUT:3 %t22:p};
//   %t23 = $GROUND @ATTACH &VREFN => @PLACE(76, -22);
//   &VREFN @WIRE {#MNOUT:3 %t23:p};
//   %t24 = $GROUND @ATTACH &VREFN => @PLACE(43, 5);
//   &VREFN @WIRE {#MGPN:3 %t24:p};
//   %t25 = $SUPPLY @ATTACH &VREFP => @PLACE(43, 27);
//   &VREFP @WIRE {#MGPP:3 %t25:p};
//   %t26 = $GROUND @ATTACH &VREFN => @PLACE(43, -27);
//   &VREFN @WIRE {#MGNN:3 %t26:p};
//   %t27 = $SUPPLY @ATTACH &VREFP => @PLACE(43, -5);
//   &VREFP @WIRE {#MGNP:3 %t27:p};
//   $JUNCTION @ATTACH %j1;
//   $JUNCTION @ATTACH %j2;
//   $JUNCTION @ATTACH %j3;
//   $JUNCTION @ATTACH %j4;
//   $JUNCTION @ATTACH %j5;
//   $JUNCTION @ATTACH %j6;
//   $JUNCTION @ATTACH %j7;
//   (-7, 51) @TEXT("N4 formal candidate / WIP | mq_cdac_drv9 | isolated DVDD logic / VREFP output", size=1.4, bold=true, textcolor="#17365d");
//   (-7, 48.6) @TEXT("Drawing only | N bulk = VSS; L = 30 nm. P bulk DVDD: MPA0, MPA1, MPB0, MPB1; VREFP: MGPP, MGNP, MPOUT", size=1.05, textcolor="#52606d");
// }
ends mq_cdac_drv9

// Matched half-capacitor pair j=9
subckt mq_cdac_bit9 (DH RL EN ENB TOP VREFP VREFN VSS DVDD)
// CP*: user-specified 5% bottom-plate estimate for every physical MOM unit, not extraction.
// Series tails retain one unit parasitic at MID and one at B.
XHCTL (DH HHIB DVDD VREFN VSS) mq_cdac_ctl_h
XLCTL (RL LHIB DVDD VREFN VSS) mq_cdac_ctl_l
XDH (HHIB EN ENB BH VREFP VREFN VSS DVDD) mq_cdac_drv9
CH (TOP BH) cfmom_2t w=5e-08 s=2.4e-07 nr=6 lr=1.69e-06 stm=2 spm=4 multi=90
CPH (BH VSS) capacitor c=4.5103050e-15
XDL (LHIB EN ENB BL VREFP VREFN VSS DVDD) mq_cdac_drv9
CL (TOP BL) cfmom_2t w=5e-08 s=2.4e-07 nr=6 lr=1.69e-06 stm=2 spm=4 multi=90
CPL (BL VSS) capacitor c=4.5103050e-15
// @RNL {
//   {&DH &RL &EN &ENB &TOP &VREFP &VREFN &VSS &DVDD} @REMOVE-FROM $PORT_FILL_SET;
//   &VSS @ADD-TO $GROUND_NET_SET;
//   &VREFN @ADD-TO $GROUND_NET_SET;
//   #XHCTL @PLACE(0, 20) => @ORIENT("R0");
//   #XDH @PLACE(19, 18) => @ORIENT("R0");
//   &HHIB @WIRE {#XHCTL:2 #XDH:1};
//   %j1 = (115, 20);
//   %j2 = (38, 20);
//   %j3 = (52, 20);
//   %j4 = (66, 20);
//   %j5 = (84, 20);
//   &BH @WIRE {#XDH:4 %j2 %j3 %j4 %j5};
//   #CH @PLACE(100, 20) => @ORIENT("R270");
//   #CH @TEXT("", key="value");
//   #CH @TEXT("", key="name");
//   (100, 22.2) @TEXT("CH", size=1.05);
//   (100, 16.8) @TEXT("90 Cu", size=1.05);
//   &BH @WIRE {%j5 #CH:2};
//   &TOP @WIRE {#CH:1 %j1};
//   #CPH @PLACE(84, 12) => @ORIENT("R0");
//   #CPH @TEXT("", key="value");
//   #CPH @TEXT("", key="name");
//   (86, 13) @TEXT("CPH", size=1.05);
//   (86, 11) @TEXT("4.51 fF / 5%", size=1.05);
//   &BH @WIRE {%j5 #CPH:1};
//   (-8, 35) @TEXT("High bank", size=1.05);
//   #XLCTL @PLACE(0, -18) => @ORIENT("R0");
//   #XDL @PLACE(19, -20) => @ORIENT("R0");
//   &LHIB @WIRE {#XLCTL:2 #XDL:1};
//   %j6 = (115, -18);
//   %j7 = (38, -18);
//   %j8 = (52, -18);
//   %j9 = (66, -18);
//   %j10 = (84, -18);
//   &BL @WIRE {#XDL:4 %j7 %j8 %j9 %j10};
//   #CL @PLACE(100, -18) => @ORIENT("R270");
//   #CL @TEXT("", key="value");
//   #CL @TEXT("", key="name");
//   (100, -15.8) @TEXT("CL", size=1.05);
//   (100, -21.2) @TEXT("90 Cu", size=1.05);
//   &BL @WIRE {%j10 #CL:2};
//   &TOP @WIRE {#CL:1 %j6};
//   #CPL @PLACE(84, -26) => @ORIENT("R0");
//   #CPL @TEXT("", key="value");
//   #CPL @TEXT("", key="name");
//   (86, -25) @TEXT("CPL", size=1.05);
//   (86, -27) @TEXT("4.51 fF / 5%", size=1.05);
//   &BL @WIRE {%j10 #CPL:1};
//   (-8, -3) @TEXT("Low bank", size=1.05);
//   &TOP @WIRE {%j1 %j6};
//   (116, -3) @TEXT("TOP", size=1.05);
//   (-8, -42) @TEXT("Cu = 1.00229 fF. Cp = 5% of every physical MOM, including series MID.", size=1.05);
//   (-8, -45) @TEXT("DH -> buffer; RL -> inverter. Control supply: DVDD / VREFN; body: VSS.", size=1.05);
//   (-8, -48) @TEXT("5% Cp is a user estimate, not extraction.", size=1.05);
//   &DH @WIRE {#XHCTL:1 (-6, 20)};
//   (-6.3, 20) @TEXT("DH", size=1.05, halign="end", valign="middle");
//   &EN @WIRE {#XDH:2 (9, 16)};
//   (8.7, 16) @TEXT("EN", size=1.05, halign="end", valign="middle");
//   &ENB @WIRE {#XDH:3 (9, 13)};
//   (8.7, 13) @TEXT("ENB", size=1.05, halign="end", valign="middle");
//   %t14 = $SUPPLY @ATTACH &VREFP => @PLACE(22, 29);
//   &VREFP @WIRE {#XDH:5 %t14:p};
//   %t15 = $GROUND @ATTACH &VREFN => @PLACE(22, 7);
//   &VREFN @WIRE {#XDH:6 %t15:p};
//   %t16 = $GROUND @ATTACH &VSS => @PLACE(16, 7);
//   &VSS @WIRE {#XDH:7 %t16:p};
//   %t17 = $SUPPLY @ATTACH &DVDD => @PLACE(16, 29);
//   &DVDD @WIRE {#XDH:8 %t17:p};
//   %t18 = $GROUND @ATTACH &VSS => @PLACE(84, 8);
//   &VSS @WIRE {#CPH:2 %t18:p};
//   &RL @WIRE {#XLCTL:1 (-6, -18)};
//   (-6.3, -18) @TEXT("RL", size=1.05, halign="end", valign="middle");
//   &EN @WIRE {#XDL:2 (9, -22)};
//   (8.7, -22) @TEXT("EN", size=1.05, halign="end", valign="middle");
//   &ENB @WIRE {#XDL:3 (9, -25)};
//   (8.7, -25) @TEXT("ENB", size=1.05, halign="end", valign="middle");
//   %t22 = $SUPPLY @ATTACH &VREFP => @PLACE(22, -9);
//   &VREFP @WIRE {#XDL:5 %t22:p};
//   %t23 = $GROUND @ATTACH &VREFN => @PLACE(22, -31);
//   &VREFN @WIRE {#XDL:6 %t23:p};
//   %t24 = $GROUND @ATTACH &VSS => @PLACE(16, -31);
//   &VSS @WIRE {#XDL:7 %t24:p};
//   %t25 = $SUPPLY @ATTACH &DVDD => @PLACE(16, -9);
//   &DVDD @WIRE {#XDL:8 %t25:p};
//   %t26 = $GROUND @ATTACH &VSS => @PLACE(84, -30);
//   &VSS @WIRE {#CPL:2 %t26:p};
//   $JUNCTION @ATTACH %j5;
//   $JUNCTION @ATTACH %j10;
//   (-8, 44) @TEXT("N4 formal candidate / WIP | weight 9: 180 | matched H/L banks", size=1.4, bold=true, textcolor="#17365d");
//   (-8, 41.6) @TEXT("Drawing only | N bulk = VSS; L = 30 nm. P bulk ", size=1.05, textcolor="#52606d");
// }
ends mq_cdac_bit9

// Reference-rail output driver j=8
subckt mq_cdac_drv8 (HIB EN ENB BP VREFP VREFN VSS DVDD)
// DVDD prelogic: PCOND = NOR(ENB,HIB); NOFF = NAND(EN,HIB).
// Reference-powered final inverters restore GP and GN to VREFP/VREFN.
// Actual current overlap, settling and device stress require measurement.
MPA0 (AP ENB DVDD DVDD) pch_ulvt_mac w=8.35e-07 l=3e-08 nf=1
MPA1 (PCOND HIB AP DVDD) pch_ulvt_mac w=8.35e-07 l=3e-08 nf=1
MNA0 (PCOND ENB VREFN VSS) nch_ulvt_mac w=4.15e-07 l=3e-08 nf=1
MNA1 (PCOND HIB VREFN VSS) nch_ulvt_mac w=4.15e-07 l=3e-08 nf=1
MPB0 (NOFF EN DVDD DVDD) pch_ulvt_mac w=4.15e-07 l=3e-08 nf=1
MPB1 (NOFF HIB DVDD DVDD) pch_ulvt_mac w=4.15e-07 l=3e-08 nf=1
MNB0 (NOFF EN BN VSS) nch_ulvt_mac w=4.15e-07 l=3e-08 nf=1
MNB1 (BN HIB VREFN VSS) nch_ulvt_mac w=4.15e-07 l=3e-08 nf=1
MGPN (GP PCOND VREFN VSS) nch_mac w=8.35e-07 l=3e-08 nf=1
MGPP (GP PCOND VREFP VREFP) pch_mac w=1.25e-06 l=3e-08 nf=1
MGNN (GN NOFF VREFN VSS) nch_mac w=8.35e-07 l=3e-08 nf=1
MGNP (GN NOFF VREFP VREFP) pch_mac w=4.15e-07 l=3e-08 nf=1
MNOUT (BP GN VREFN VSS) nch_mac w=1.56e-06 l=3e-08 nf=2
MPOUT (BP GP VREFP VREFP) pch_mac w=3.12e-06 l=3e-08 nf=3
// @RNL {
//   {&HIB &EN &ENB &BP &VREFP &VREFN &VSS &DVDD} @REMOVE-FROM $PORT_FILL_SET;
//   &VSS @ADD-TO $GROUND_NET_SET;
//   &VREFN @ADD-TO $GROUND_NET_SET;
//   #MPA0 @PLACE(8, 32) => @ORIENT("R0");
//   #MPA0 @SET-SYMBOL $PMOS;
//   #MPA0 @TEXT("ULVT 0.835u", key="model", size=1.05, dx=1.5, dy=-1);
//   #MPA0 @TEXT("MPA0", key="name", size=1.1, dx=1.5, dy=1);
//   #MPA1 @PLACE(8, 24) => @ORIENT("R0");
//   #MPA1 @SET-SYMBOL $PMOS;
//   #MPA1 @TEXT("ULVT 0.835u", key="model", size=1.05, dx=1.5, dy=-1);
//   #MPA1 @TEXT("MPA1", key="name", size=1.1, dx=1.5, dy=1);
//   #MNA0 @PLACE(0, 8) => @ORIENT("R0");
//   #MNA0 @SET-SYMBOL $NMOS;
//   #MNA0 @TEXT("ULVT 0.415u", key="model", size=1.05, dx=1.5, dy=-1);
//   #MNA0 @TEXT("MNA0", key="name", size=1.1, dx=1.5, dy=1);
//   #MNA1 @PLACE(16, 8) => @ORIENT("R0");
//   #MNA1 @SET-SYMBOL $NMOS;
//   #MNA1 @TEXT("ULVT 0.415u", key="model", size=1.05, dx=1.5, dy=-1);
//   #MNA1 @TEXT("MNA1", key="name", size=1.1, dx=1.5, dy=1);
//   #MPB0 @PLACE(0, -8) => @ORIENT("R0");
//   #MPB0 @SET-SYMBOL $PMOS;
//   #MPB0 @TEXT("ULVT 0.415u", key="model", size=1.05, dx=1.5, dy=-1);
//   #MPB0 @TEXT("MPB0", key="name", size=1.1, dx=1.5, dy=1);
//   #MPB1 @PLACE(16, -8) => @ORIENT("R0");
//   #MPB1 @SET-SYMBOL $PMOS;
//   #MPB1 @TEXT("ULVT 0.415u", key="model", size=1.05, dx=1.5, dy=-1);
//   #MPB1 @TEXT("MPB1", key="name", size=1.1, dx=1.5, dy=1);
//   #MNB0 @PLACE(8, -24) => @ORIENT("R0");
//   #MNB0 @SET-SYMBOL $NMOS;
//   #MNB0 @TEXT("ULVT 0.415u", key="model", size=1.05, dx=1.5, dy=-1);
//   #MNB0 @TEXT("MNB0", key="name", size=1.1, dx=1.5, dy=1);
//   #MNB1 @PLACE(8, -32) => @ORIENT("R0");
//   #MNB1 @SET-SYMBOL $NMOS;
//   #MNB1 @TEXT("ULVT 0.415u", key="model", size=1.05, dx=1.5, dy=-1);
//   #MNB1 @TEXT("MNB1", key="name", size=1.1, dx=1.5, dy=1);
//   #MPOUT @PLACE(76, 18) => @ORIENT("R0");
//   #MPOUT @SET-SYMBOL $PMOS;
//   #MPOUT @TEXT("SVT 3.12u", key="model", size=1.05, dx=1.5, dy=-1);
//   #MPOUT @TEXT("MPOUT", key="name", size=1.1, dx=1.5, dy=1);
//   #MNOUT @PLACE(76, -18) => @ORIENT("R0");
//   #MNOUT @SET-SYMBOL $NMOS;
//   #MNOUT @TEXT("SVT 1.56u", key="model", size=1.05, dx=1.5, dy=-1);
//   #MNOUT @TEXT("MNOUT", key="name", size=1.1, dx=1.5, dy=1);
//   &AP @WIRE {#MPA0:1 #MPA1:3};
//   (10, 28) @TEXT("AP", size=1.05);
//   %j1 = (8, 16);
//   &PCOND @WIRE {#MNA0:1 (0, 16) %j1 (16, 16) #MNA1:1};
//   &PCOND @WIRE {#MPA1:1 %j1};
//   #MGPN @PLACE(43, 9) => @ORIENT("R0");
//   #MGPN @SET-SYMBOL $NMOS;
//   #MGPN @TEXT("SVT 0.835u", key="model", size=1.05, dx=1.5, dy=-1);
//   #MGPN @TEXT("MGPN", key="name", size=1.1, dx=1.5, dy=1);
//   #MGPP @PLACE(43, 23) => @ORIENT("R0");
//   #MGPP @SET-SYMBOL $PMOS;
//   #MGPP @TEXT("SVT 1.25u", key="model", size=1.05, dx=1.5, dy=-1);
//   #MGPP @TEXT("MGPP", key="name", size=1.1, dx=1.5, dy=1);
//   %j2 = (43, 16);
//   %j3 = (38, 16);
//   &GP @WIRE {#MGPN:1 %j2 #MGPP:1};
//   &PCOND @WIRE {#MGPN:2 (38, 9) %j3 (38, 23) #MGPP:2};
//   &PCOND @WIRE {%j1 %j3};
//   &GP @WIRE {%j2 (65, 16) (65, 18) #MPOUT:2};
//   %j4 = (8, -16);
//   &NOFF @WIRE {#MPB0:1 (0, -16) %j4 (16, -16) #MPB1:1};
//   &NOFF @WIRE {#MNB0:1 %j4};
//   &BN @WIRE {#MNB0:3 #MNB1:1};
//   (18, -14) @TEXT("NOFF", size=1.05);
//   #MGNN @PLACE(43, -23) => @ORIENT("R0");
//   #MGNN @SET-SYMBOL $NMOS;
//   #MGNN @TEXT("SVT 0.835u", key="model", size=1.05, dx=1.5, dy=-1);
//   #MGNN @TEXT("MGNN", key="name", size=1.1, dx=1.5, dy=1);
//   #MGNP @PLACE(43, -9) => @ORIENT("R0");
//   #MGNP @SET-SYMBOL $PMOS;
//   #MGNP @TEXT("SVT 0.415u", key="model", size=1.05, dx=1.5, dy=-1);
//   #MGNP @TEXT("MGNP", key="name", size=1.1, dx=1.5, dy=1);
//   %j5 = (43, -16);
//   %j6 = (38, -16);
//   &GN @WIRE {#MGNN:1 %j5 #MGNP:1};
//   &NOFF @WIRE {#MGNN:2 (38, -23) %j6 (38, -9) #MGNP:2};
//   &NOFF @WIRE {%j4 %j6};
//   &GN @WIRE {%j5 (65, -16) (65, -18) #MNOUT:2};
//   %j7 = (76, 0);
//   &BP @WIRE {#MPOUT:1 %j7 #MNOUT:1};
//   &BP @WIRE {%j7 (85, 0)};
//   (85, 1) @TEXT("BP", size=1.05);
//   (-5, 42) @TEXT("NOR: PCOND = ~(ENB | HIB)", size=1.05);
//   (-5, -42) @TEXT("NAND: NOFF = ~(EN & HIB)", size=1.05);
//   (31, 39) @TEXT("Reference gate drivers", size=1.05);
//   (67, 39) @TEXT("Output rail switch", size=1.05);
//   &ENB @WIRE {#MPA0:2 (3, 32)};
//   (2.7, 32) @TEXT("ENB", size=1.05, halign="end", valign="middle");
//   %t9 = $SUPPLY @ATTACH &DVDD => @PLACE(8, 36);
//   &DVDD @WIRE {#MPA0:3 %t9:p};
//   &HIB @WIRE {#MPA1:2 (3, 24)};
//   (2.7, 24) @TEXT("HIB", size=1.05, halign="end", valign="middle");
//   &ENB @WIRE {#MNA0:2 (-5, 8)};
//   (-5.3, 8) @TEXT("ENB", size=1.05, halign="end", valign="middle");
//   %t12 = $GROUND @ATTACH &VREFN => @PLACE(0, 4);
//   &VREFN @WIRE {#MNA0:3 %t12:p};
//   &HIB @WIRE {#MNA1:2 (11, 8)};
//   (10.7, 8) @TEXT("HIB", size=1.05, halign="end", valign="middle");
//   %t14 = $GROUND @ATTACH &VREFN => @PLACE(16, 4);
//   &VREFN @WIRE {#MNA1:3 %t14:p};
//   &EN @WIRE {#MPB0:2 (-5, -8)};
//   (-5.3, -8) @TEXT("EN", size=1.05, halign="end", valign="middle");
//   %t16 = $SUPPLY @ATTACH &DVDD => @PLACE(0, -4);
//   &DVDD @WIRE {#MPB0:3 %t16:p};
//   &HIB @WIRE {#MPB1:2 (11, -8)};
//   (10.7, -8) @TEXT("HIB", size=1.05, halign="end", valign="middle");
//   %t18 = $SUPPLY @ATTACH &DVDD => @PLACE(16, -4);
//   &DVDD @WIRE {#MPB1:3 %t18:p};
//   &EN @WIRE {#MNB0:2 (3, -24)};
//   (2.7, -24) @TEXT("EN", size=1.05, halign="end", valign="middle");
//   &HIB @WIRE {#MNB1:2 (3, -32)};
//   (2.7, -32) @TEXT("HIB", size=1.05, halign="end", valign="middle");
//   %t21 = $GROUND @ATTACH &VREFN => @PLACE(8, -36);
//   &VREFN @WIRE {#MNB1:3 %t21:p};
//   %t22 = $SUPPLY @ATTACH &VREFP => @PLACE(76, 22);
//   &VREFP @WIRE {#MPOUT:3 %t22:p};
//   %t23 = $GROUND @ATTACH &VREFN => @PLACE(76, -22);
//   &VREFN @WIRE {#MNOUT:3 %t23:p};
//   %t24 = $GROUND @ATTACH &VREFN => @PLACE(43, 5);
//   &VREFN @WIRE {#MGPN:3 %t24:p};
//   %t25 = $SUPPLY @ATTACH &VREFP => @PLACE(43, 27);
//   &VREFP @WIRE {#MGPP:3 %t25:p};
//   %t26 = $GROUND @ATTACH &VREFN => @PLACE(43, -27);
//   &VREFN @WIRE {#MGNN:3 %t26:p};
//   %t27 = $SUPPLY @ATTACH &VREFP => @PLACE(43, -5);
//   &VREFP @WIRE {#MGNP:3 %t27:p};
//   $JUNCTION @ATTACH %j1;
//   $JUNCTION @ATTACH %j2;
//   $JUNCTION @ATTACH %j3;
//   $JUNCTION @ATTACH %j4;
//   $JUNCTION @ATTACH %j5;
//   $JUNCTION @ATTACH %j6;
//   $JUNCTION @ATTACH %j7;
//   (-7, 51) @TEXT("N4 formal candidate / WIP | mq_cdac_drv8 | isolated DVDD logic / VREFP output", size=1.4, bold=true, textcolor="#17365d");
//   (-7, 48.6) @TEXT("Drawing only | N bulk = VSS; L = 30 nm. P bulk DVDD: MPA0, MPA1, MPB0, MPB1; VREFP: MGPP, MGNP, MPOUT", size=1.05, textcolor="#52606d");
// }
ends mq_cdac_drv8

// Matched half-capacitor pair j=8
subckt mq_cdac_bit8 (VIN VG DH RL EN ENB TOP VREFP VREFN VSS DVDD EQBUS APGATE)
// CP*: user-specified 5% bottom-plate estimate for every physical MOM unit, not extraction.
// Series tails retain one unit parasitic at MID and one at B.
// APGATE PMOS assist connects each bottom plate to VIN.
// Additional ENB NMOS sharing retains a common EQBUS.
XHCTL (DH HHIB DVDD VREFN VSS) mq_cdac_ctl_h
XLCTL (RL LHIB DVDD VREFN VSS) mq_cdac_ctl_l
XDH (HHIB EN ENB BH VREFP VREFN VSS DVDD) mq_cdac_drv8
CH (TOP BH) cfmom_2t w=5e-08 s=2.4e-07 nr=6 lr=1.69e-06 stm=2 spm=4 multi=51
CPH (BH VSS) capacitor c=2.5558395e-15
MSH (BH VG VIN VSS) nch_ulvt_mac w=1.19e-06 l=3e-08 nf=1
XDL (LHIB EN ENB BL VREFP VREFN VSS DVDD) mq_cdac_drv8
CL (TOP BL) cfmom_2t w=5e-08 s=2.4e-07 nr=6 lr=1.69e-06 stm=2 spm=4 multi=51
CPL (BL VSS) capacitor c=2.5558395e-15
MSL (BL VG VIN VSS) nch_ulvt_mac w=1.19e-06 l=3e-08 nf=1
MEQ1 (BH APGATE VIN VREFP) pch_ulvt_mac w=1.19e-06 l=3e-08 nf=1
MEQ2 (BL APGATE VIN VREFP) pch_ulvt_mac w=1.19e-06 l=3e-08 nf=1
MSHAREH (BH ENB EQBUS VSS) nch_ulvt_mac w=1.19e-06 l=3e-08 nf=1
MSHAREL (BL ENB EQBUS VSS) nch_ulvt_mac w=1.19e-06 l=3e-08 nf=1
// @RNL {
//   {&VIN &VG &DH &RL &EN &ENB &TOP &VREFP &VREFN &VSS &DVDD &EQBUS &APGATE} @REMOVE-FROM $PORT_FILL_SET;
//   &VSS @ADD-TO $GROUND_NET_SET;
//   &VREFN @ADD-TO $GROUND_NET_SET;
//   #XHCTL @PLACE(0, 20) => @ORIENT("R0");
//   #XDH @PLACE(19, 18) => @ORIENT("R0");
//   &HHIB @WIRE {#XHCTL:2 #XDH:1};
//   %j1 = (115, 20);
//   %j2 = (38, 20);
//   %j3 = (52, 20);
//   %j4 = (66, 20);
//   %j5 = (84, 20);
//   &BH @WIRE {#XDH:4 %j2 %j3 %j4 %j5};
//   #CH @PLACE(100, 20) => @ORIENT("R270");
//   #CH @TEXT("", key="value");
//   #CH @TEXT("", key="name");
//   (100, 22.2) @TEXT("CH", size=1.05);
//   (100, 16.8) @TEXT("51 Cu", size=1.05);
//   &BH @WIRE {%j5 #CH:2};
//   &TOP @WIRE {#CH:1 %j1};
//   #CPH @PLACE(84, 12) => @ORIENT("R0");
//   #CPH @TEXT("", key="value");
//   #CPH @TEXT("", key="name");
//   (86, 13) @TEXT("CPH", size=1.05);
//   (86, 11) @TEXT("2.556 fF / 5%", size=1.05);
//   &BH @WIRE {%j5 #CPH:1};
//   #MSH @PLACE(38, 7) => @ORIENT("R0");
//   #MSH @SET-SYMBOL $NMOS;
//   #MSH @TEXT("ULVT 1.19u", key="model", size=1.05, dx=1.5, dy=-1);
//   #MSH @TEXT("MSH", key="name", size=1.1, dx=1.5, dy=1);
//   &BH @WIRE {%j2 #MSH:1};
//   #MEQ1 @PLACE(52, 7) => @ORIENT("MX");
//   #MEQ1 @SET-SYMBOL $PMOS;
//   #MEQ1 @TEXT("ULVT 1.19u", key="model", size=1.05, dx=1.5, dy=-1);
//   #MEQ1 @TEXT("MEQ1", key="name", size=1.1, dx=1.5, dy=1);
//   &BH @WIRE {%j3 #MEQ1:1};
//   #MSHAREH @PLACE(66, 7) => @ORIENT("R0");
//   #MSHAREH @SET-SYMBOL $NMOS;
//   #MSHAREH @TEXT("ULVT 1.19u", key="model", size=1.05, dx=1.5, dy=-1);
//   #MSHAREH @TEXT("MSHAREH", key="name", size=1.1, dx=1.5, dy=1);
//   &BH @WIRE {%j4 #MSHAREH:1};
//   (-8, 35) @TEXT("High bank", size=1.05);
//   #XLCTL @PLACE(0, -18) => @ORIENT("R0");
//   #XDL @PLACE(19, -20) => @ORIENT("R0");
//   &LHIB @WIRE {#XLCTL:2 #XDL:1};
//   %j6 = (115, -18);
//   %j7 = (38, -18);
//   %j8 = (52, -18);
//   %j9 = (66, -18);
//   %j10 = (84, -18);
//   &BL @WIRE {#XDL:4 %j7 %j8 %j9 %j10};
//   #CL @PLACE(100, -18) => @ORIENT("R270");
//   #CL @TEXT("", key="value");
//   #CL @TEXT("", key="name");
//   (100, -15.8) @TEXT("CL", size=1.05);
//   (100, -21.2) @TEXT("51 Cu", size=1.05);
//   &BL @WIRE {%j10 #CL:2};
//   &TOP @WIRE {#CL:1 %j6};
//   #CPL @PLACE(84, -26) => @ORIENT("R0");
//   #CPL @TEXT("", key="value");
//   #CPL @TEXT("", key="name");
//   (86, -25) @TEXT("CPL", size=1.05);
//   (86, -27) @TEXT("2.556 fF / 5%", size=1.05);
//   &BL @WIRE {%j10 #CPL:1};
//   #MSL @PLACE(38, -31) => @ORIENT("R0");
//   #MSL @SET-SYMBOL $NMOS;
//   #MSL @TEXT("ULVT 1.19u", key="model", size=1.05, dx=1.5, dy=-1);
//   #MSL @TEXT("MSL", key="name", size=1.1, dx=1.5, dy=1);
//   &BL @WIRE {%j7 #MSL:1};
//   #MEQ2 @PLACE(52, -31) => @ORIENT("MX");
//   #MEQ2 @SET-SYMBOL $PMOS;
//   #MEQ2 @TEXT("ULVT 1.19u", key="model", size=1.05, dx=1.5, dy=-1);
//   #MEQ2 @TEXT("MEQ2", key="name", size=1.1, dx=1.5, dy=1);
//   &BL @WIRE {%j8 #MEQ2:1};
//   #MSHAREL @PLACE(66, -31) => @ORIENT("R0");
//   #MSHAREL @SET-SYMBOL $NMOS;
//   #MSHAREL @TEXT("ULVT 1.19u", key="model", size=1.05, dx=1.5, dy=-1);
//   #MSHAREL @TEXT("MSHAREL", key="name", size=1.1, dx=1.5, dy=1);
//   &BL @WIRE {%j9 #MSHAREL:1};
//   (-8, -3) @TEXT("Low bank", size=1.05);
//   &TOP @WIRE {%j1 %j6};
//   (116, -3) @TEXT("TOP", size=1.05);
//   (-8, -42) @TEXT("Cu = 1.00229 fF. Cp = 5% of every physical MOM, including series MID.", size=1.05);
//   (-8, -45) @TEXT("DH -> buffer; RL -> inverter. Control supply: DVDD / VREFN; body: VSS.", size=1.05);
//   (-8, -48) @TEXT("5% Cp is a user estimate, not extraction.", size=1.05);
//   &DH @WIRE {#XHCTL:1 (-6, 20)};
//   (-6.3, 20) @TEXT("DH", size=1.05, halign="end", valign="middle");
//   &EN @WIRE {#XDH:2 (9, 16)};
//   (8.7, 16) @TEXT("EN", size=1.05, halign="end", valign="middle");
//   &ENB @WIRE {#XDH:3 (9, 13)};
//   (8.7, 13) @TEXT("ENB", size=1.05, halign="end", valign="middle");
//   %t14 = $SUPPLY @ATTACH &VREFP => @PLACE(22, 29);
//   &VREFP @WIRE {#XDH:5 %t14:p};
//   %t15 = $GROUND @ATTACH &VREFN => @PLACE(22, 7);
//   &VREFN @WIRE {#XDH:6 %t15:p};
//   %t16 = $GROUND @ATTACH &VSS => @PLACE(16, 7);
//   &VSS @WIRE {#XDH:7 %t16:p};
//   %t17 = $SUPPLY @ATTACH &DVDD => @PLACE(16, 29);
//   &DVDD @WIRE {#XDH:8 %t17:p};
//   %t18 = $GROUND @ATTACH &VSS => @PLACE(84, 8);
//   &VSS @WIRE {#CPH:2 %t18:p};
//   &VG @WIRE {#MSH:2 (33, 7)};
//   (32.7, 10.2) @TEXT("VG", size=1.05, halign="end", valign="middle");
//   &VIN @WIRE {#MSH:3 (38, 3)};
//   (38, 2.4) @TEXT("VIN", size=1.05, halign="middle", valign="top");
//   &APGATE @WIRE {#MEQ1:2 (47, 7)};
//   (46.7, 10.2) @TEXT("APGATE", size=1.05, halign="end", valign="middle");
//   &VIN @WIRE {#MEQ1:3 (52, 3)};
//   (52, 2.4) @TEXT("VIN", size=1.05, halign="middle", valign="top");
//   &ENB @WIRE {#MSHAREH:2 (61, 7)};
//   (60.7, 10.2) @TEXT("ENB", size=1.05, halign="end", valign="middle");
//   &EQBUS @WIRE {#MSHAREH:3 (66, 3)};
//   (66, 2.4) @TEXT("EQBUS", size=1.05, halign="middle", valign="top");
//   &RL @WIRE {#XLCTL:1 (-6, -18)};
//   (-6.3, -18) @TEXT("RL", size=1.05, halign="end", valign="middle");
//   &EN @WIRE {#XDL:2 (9, -22)};
//   (8.7, -22) @TEXT("EN", size=1.05, halign="end", valign="middle");
//   &ENB @WIRE {#XDL:3 (9, -25)};
//   (8.7, -25) @TEXT("ENB", size=1.05, halign="end", valign="middle");
//   %t28 = $SUPPLY @ATTACH &VREFP => @PLACE(22, -9);
//   &VREFP @WIRE {#XDL:5 %t28:p};
//   %t29 = $GROUND @ATTACH &VREFN => @PLACE(22, -31);
//   &VREFN @WIRE {#XDL:6 %t29:p};
//   %t30 = $GROUND @ATTACH &VSS => @PLACE(16, -31);
//   &VSS @WIRE {#XDL:7 %t30:p};
//   %t31 = $SUPPLY @ATTACH &DVDD => @PLACE(16, -9);
//   &DVDD @WIRE {#XDL:8 %t31:p};
//   %t32 = $GROUND @ATTACH &VSS => @PLACE(84, -30);
//   &VSS @WIRE {#CPL:2 %t32:p};
//   &VG @WIRE {#MSL:2 (33, -31)};
//   (32.7, -27.8) @TEXT("VG", size=1.05, halign="end", valign="middle");
//   &VIN @WIRE {#MSL:3 (38, -35)};
//   (38, -35.6) @TEXT("VIN", size=1.05, halign="middle", valign="top");
//   &APGATE @WIRE {#MEQ2:2 (47, -31)};
//   (46.7, -27.8) @TEXT("APGATE", size=1.05, halign="end", valign="middle");
//   &VIN @WIRE {#MEQ2:3 (52, -35)};
//   (52, -35.6) @TEXT("VIN", size=1.05, halign="middle", valign="top");
//   &ENB @WIRE {#MSHAREL:2 (61, -31)};
//   (60.7, -27.8) @TEXT("ENB", size=1.05, halign="end", valign="middle");
//   &EQBUS @WIRE {#MSHAREL:3 (66, -35)};
//   (66, -35.6) @TEXT("EQBUS", size=1.05, halign="middle", valign="top");
//   $JUNCTION @ATTACH %j2;
//   $JUNCTION @ATTACH %j3;
//   $JUNCTION @ATTACH %j4;
//   $JUNCTION @ATTACH %j5;
//   $JUNCTION @ATTACH %j7;
//   $JUNCTION @ATTACH %j8;
//   $JUNCTION @ATTACH %j9;
//   $JUNCTION @ATTACH %j10;
//   (-8, 44) @TEXT("N4 formal candidate / WIP | weight 8: 102 | matched H/L banks", size=1.4, bold=true, textcolor="#17365d");
//   (-8, 41.6) @TEXT("Drawing only | N bulk = VSS; L = 30 nm. P bulk VREFP: MEQ1, MEQ2", size=1.05, textcolor="#52606d");
// }
ends mq_cdac_bit8

// Reference-rail output driver j=7
subckt mq_cdac_drv7 (HIB EN ENB BP VREFP VREFN VSS DVDD)
// DVDD prelogic: PCOND = NOR(ENB,HIB); NOFF = NAND(EN,HIB).
// Reference-powered final inverters restore GP and GN to VREFP/VREFN.
// Actual current overlap, settling and device stress require measurement.
MPA0 (AP ENB DVDD DVDD) pch_ulvt_mac w=4.65e-07 l=3e-08 nf=1
MPA1 (PCOND HIB AP DVDD) pch_ulvt_mac w=4.65e-07 l=3e-08 nf=1
MNA0 (PCOND ENB VREFN VSS) nch_ulvt_mac w=2.35e-07 l=3e-08 nf=1
MNA1 (PCOND HIB VREFN VSS) nch_ulvt_mac w=2.35e-07 l=3e-08 nf=1
MPB0 (NOFF EN DVDD DVDD) pch_ulvt_mac w=2.35e-07 l=3e-08 nf=1
MPB1 (NOFF HIB DVDD DVDD) pch_ulvt_mac w=2.35e-07 l=3e-08 nf=1
MNB0 (NOFF EN BN VSS) nch_ulvt_mac w=2.35e-07 l=3e-08 nf=1
MNB1 (BN HIB VREFN VSS) nch_ulvt_mac w=2.35e-07 l=3e-08 nf=1
MGPN (GP PCOND VREFN VSS) nch_mac w=4.65e-07 l=3e-08 nf=1
MGPP (GP PCOND VREFP VREFP) pch_mac w=7e-07 l=3e-08 nf=1
MGNN (GN NOFF VREFN VSS) nch_mac w=4.65e-07 l=3e-08 nf=1
MGNP (GN NOFF VREFP VREFP) pch_mac w=2.35e-07 l=3e-08 nf=1
MNOUT (BP GN VREFN VSS) nch_mac w=8.75e-07 l=3e-08 nf=1
MPOUT (BP GP VREFP VREFP) pch_mac w=1.75e-06 l=3e-08 nf=2
// @RNL {
//   {&HIB &EN &ENB &BP &VREFP &VREFN &VSS &DVDD} @REMOVE-FROM $PORT_FILL_SET;
//   &VSS @ADD-TO $GROUND_NET_SET;
//   &VREFN @ADD-TO $GROUND_NET_SET;
//   #MPA0 @PLACE(8, 32) => @ORIENT("R0");
//   #MPA0 @SET-SYMBOL $PMOS;
//   #MPA0 @TEXT("ULVT 0.465u", key="model", size=1.05, dx=1.5, dy=-1);
//   #MPA0 @TEXT("MPA0", key="name", size=1.1, dx=1.5, dy=1);
//   #MPA1 @PLACE(8, 24) => @ORIENT("R0");
//   #MPA1 @SET-SYMBOL $PMOS;
//   #MPA1 @TEXT("ULVT 0.465u", key="model", size=1.05, dx=1.5, dy=-1);
//   #MPA1 @TEXT("MPA1", key="name", size=1.1, dx=1.5, dy=1);
//   #MNA0 @PLACE(0, 8) => @ORIENT("R0");
//   #MNA0 @SET-SYMBOL $NMOS;
//   #MNA0 @TEXT("ULVT 0.235u", key="model", size=1.05, dx=1.5, dy=-1);
//   #MNA0 @TEXT("MNA0", key="name", size=1.1, dx=1.5, dy=1);
//   #MNA1 @PLACE(16, 8) => @ORIENT("R0");
//   #MNA1 @SET-SYMBOL $NMOS;
//   #MNA1 @TEXT("ULVT 0.235u", key="model", size=1.05, dx=1.5, dy=-1);
//   #MNA1 @TEXT("MNA1", key="name", size=1.1, dx=1.5, dy=1);
//   #MPB0 @PLACE(0, -8) => @ORIENT("R0");
//   #MPB0 @SET-SYMBOL $PMOS;
//   #MPB0 @TEXT("ULVT 0.235u", key="model", size=1.05, dx=1.5, dy=-1);
//   #MPB0 @TEXT("MPB0", key="name", size=1.1, dx=1.5, dy=1);
//   #MPB1 @PLACE(16, -8) => @ORIENT("R0");
//   #MPB1 @SET-SYMBOL $PMOS;
//   #MPB1 @TEXT("ULVT 0.235u", key="model", size=1.05, dx=1.5, dy=-1);
//   #MPB1 @TEXT("MPB1", key="name", size=1.1, dx=1.5, dy=1);
//   #MNB0 @PLACE(8, -24) => @ORIENT("R0");
//   #MNB0 @SET-SYMBOL $NMOS;
//   #MNB0 @TEXT("ULVT 0.235u", key="model", size=1.05, dx=1.5, dy=-1);
//   #MNB0 @TEXT("MNB0", key="name", size=1.1, dx=1.5, dy=1);
//   #MNB1 @PLACE(8, -32) => @ORIENT("R0");
//   #MNB1 @SET-SYMBOL $NMOS;
//   #MNB1 @TEXT("ULVT 0.235u", key="model", size=1.05, dx=1.5, dy=-1);
//   #MNB1 @TEXT("MNB1", key="name", size=1.1, dx=1.5, dy=1);
//   #MPOUT @PLACE(76, 18) => @ORIENT("R0");
//   #MPOUT @SET-SYMBOL $PMOS;
//   #MPOUT @TEXT("SVT 1.75u", key="model", size=1.05, dx=1.5, dy=-1);
//   #MPOUT @TEXT("MPOUT", key="name", size=1.1, dx=1.5, dy=1);
//   #MNOUT @PLACE(76, -18) => @ORIENT("R0");
//   #MNOUT @SET-SYMBOL $NMOS;
//   #MNOUT @TEXT("SVT 0.875u", key="model", size=1.05, dx=1.5, dy=-1);
//   #MNOUT @TEXT("MNOUT", key="name", size=1.1, dx=1.5, dy=1);
//   &AP @WIRE {#MPA0:1 #MPA1:3};
//   (10, 28) @TEXT("AP", size=1.05);
//   %j1 = (8, 16);
//   &PCOND @WIRE {#MNA0:1 (0, 16) %j1 (16, 16) #MNA1:1};
//   &PCOND @WIRE {#MPA1:1 %j1};
//   #MGPN @PLACE(43, 9) => @ORIENT("R0");
//   #MGPN @SET-SYMBOL $NMOS;
//   #MGPN @TEXT("SVT 0.465u", key="model", size=1.05, dx=1.5, dy=-1);
//   #MGPN @TEXT("MGPN", key="name", size=1.1, dx=1.5, dy=1);
//   #MGPP @PLACE(43, 23) => @ORIENT("R0");
//   #MGPP @SET-SYMBOL $PMOS;
//   #MGPP @TEXT("SVT 0.7u", key="model", size=1.05, dx=1.5, dy=-1);
//   #MGPP @TEXT("MGPP", key="name", size=1.1, dx=1.5, dy=1);
//   %j2 = (43, 16);
//   %j3 = (38, 16);
//   &GP @WIRE {#MGPN:1 %j2 #MGPP:1};
//   &PCOND @WIRE {#MGPN:2 (38, 9) %j3 (38, 23) #MGPP:2};
//   &PCOND @WIRE {%j1 %j3};
//   &GP @WIRE {%j2 (65, 16) (65, 18) #MPOUT:2};
//   %j4 = (8, -16);
//   &NOFF @WIRE {#MPB0:1 (0, -16) %j4 (16, -16) #MPB1:1};
//   &NOFF @WIRE {#MNB0:1 %j4};
//   &BN @WIRE {#MNB0:3 #MNB1:1};
//   (18, -14) @TEXT("NOFF", size=1.05);
//   #MGNN @PLACE(43, -23) => @ORIENT("R0");
//   #MGNN @SET-SYMBOL $NMOS;
//   #MGNN @TEXT("SVT 0.465u", key="model", size=1.05, dx=1.5, dy=-1);
//   #MGNN @TEXT("MGNN", key="name", size=1.1, dx=1.5, dy=1);
//   #MGNP @PLACE(43, -9) => @ORIENT("R0");
//   #MGNP @SET-SYMBOL $PMOS;
//   #MGNP @TEXT("SVT 0.235u", key="model", size=1.05, dx=1.5, dy=-1);
//   #MGNP @TEXT("MGNP", key="name", size=1.1, dx=1.5, dy=1);
//   %j5 = (43, -16);
//   %j6 = (38, -16);
//   &GN @WIRE {#MGNN:1 %j5 #MGNP:1};
//   &NOFF @WIRE {#MGNN:2 (38, -23) %j6 (38, -9) #MGNP:2};
//   &NOFF @WIRE {%j4 %j6};
//   &GN @WIRE {%j5 (65, -16) (65, -18) #MNOUT:2};
//   %j7 = (76, 0);
//   &BP @WIRE {#MPOUT:1 %j7 #MNOUT:1};
//   &BP @WIRE {%j7 (85, 0)};
//   (85, 1) @TEXT("BP", size=1.05);
//   (-5, 42) @TEXT("NOR: PCOND = ~(ENB | HIB)", size=1.05);
//   (-5, -42) @TEXT("NAND: NOFF = ~(EN & HIB)", size=1.05);
//   (31, 39) @TEXT("Reference gate drivers", size=1.05);
//   (67, 39) @TEXT("Output rail switch", size=1.05);
//   &ENB @WIRE {#MPA0:2 (3, 32)};
//   (2.7, 32) @TEXT("ENB", size=1.05, halign="end", valign="middle");
//   %t9 = $SUPPLY @ATTACH &DVDD => @PLACE(8, 36);
//   &DVDD @WIRE {#MPA0:3 %t9:p};
//   &HIB @WIRE {#MPA1:2 (3, 24)};
//   (2.7, 24) @TEXT("HIB", size=1.05, halign="end", valign="middle");
//   &ENB @WIRE {#MNA0:2 (-5, 8)};
//   (-5.3, 8) @TEXT("ENB", size=1.05, halign="end", valign="middle");
//   %t12 = $GROUND @ATTACH &VREFN => @PLACE(0, 4);
//   &VREFN @WIRE {#MNA0:3 %t12:p};
//   &HIB @WIRE {#MNA1:2 (11, 8)};
//   (10.7, 8) @TEXT("HIB", size=1.05, halign="end", valign="middle");
//   %t14 = $GROUND @ATTACH &VREFN => @PLACE(16, 4);
//   &VREFN @WIRE {#MNA1:3 %t14:p};
//   &EN @WIRE {#MPB0:2 (-5, -8)};
//   (-5.3, -8) @TEXT("EN", size=1.05, halign="end", valign="middle");
//   %t16 = $SUPPLY @ATTACH &DVDD => @PLACE(0, -4);
//   &DVDD @WIRE {#MPB0:3 %t16:p};
//   &HIB @WIRE {#MPB1:2 (11, -8)};
//   (10.7, -8) @TEXT("HIB", size=1.05, halign="end", valign="middle");
//   %t18 = $SUPPLY @ATTACH &DVDD => @PLACE(16, -4);
//   &DVDD @WIRE {#MPB1:3 %t18:p};
//   &EN @WIRE {#MNB0:2 (3, -24)};
//   (2.7, -24) @TEXT("EN", size=1.05, halign="end", valign="middle");
//   &HIB @WIRE {#MNB1:2 (3, -32)};
//   (2.7, -32) @TEXT("HIB", size=1.05, halign="end", valign="middle");
//   %t21 = $GROUND @ATTACH &VREFN => @PLACE(8, -36);
//   &VREFN @WIRE {#MNB1:3 %t21:p};
//   %t22 = $SUPPLY @ATTACH &VREFP => @PLACE(76, 22);
//   &VREFP @WIRE {#MPOUT:3 %t22:p};
//   %t23 = $GROUND @ATTACH &VREFN => @PLACE(76, -22);
//   &VREFN @WIRE {#MNOUT:3 %t23:p};
//   %t24 = $GROUND @ATTACH &VREFN => @PLACE(43, 5);
//   &VREFN @WIRE {#MGPN:3 %t24:p};
//   %t25 = $SUPPLY @ATTACH &VREFP => @PLACE(43, 27);
//   &VREFP @WIRE {#MGPP:3 %t25:p};
//   %t26 = $GROUND @ATTACH &VREFN => @PLACE(43, -27);
//   &VREFN @WIRE {#MGNN:3 %t26:p};
//   %t27 = $SUPPLY @ATTACH &VREFP => @PLACE(43, -5);
//   &VREFP @WIRE {#MGNP:3 %t27:p};
//   $JUNCTION @ATTACH %j1;
//   $JUNCTION @ATTACH %j2;
//   $JUNCTION @ATTACH %j3;
//   $JUNCTION @ATTACH %j4;
//   $JUNCTION @ATTACH %j5;
//   $JUNCTION @ATTACH %j6;
//   $JUNCTION @ATTACH %j7;
//   (-7, 51) @TEXT("N4 formal candidate / WIP | mq_cdac_drv7 | isolated DVDD logic / VREFP output", size=1.4, bold=true, textcolor="#17365d");
//   (-7, 48.6) @TEXT("Drawing only | N bulk = VSS; L = 30 nm. P bulk DVDD: MPA0, MPA1, MPB0, MPB1; VREFP: MGPP, MGNP, MPOUT", size=1.05, textcolor="#52606d");
// }
ends mq_cdac_drv7

// Matched half-capacitor pair j=7
subckt mq_cdac_bit7 (VIN VG DH RL EN ENB TOP VREFP VREFN VSS PHI_S DVDD PHI_SB EQBUS APGATE)
// CP*: user-specified 5% bottom-plate estimate for every physical MOM unit, not extraction.
// Series tails retain one unit parasitic at MID and one at B.
// APGATE PMOS assist connects each bottom plate to VIN.
// MID-to-VIN transmission gates provide physical initialization during PHI_S.
// Additional ENB NMOS sharing retains a common EQBUS.
XHCTL (DH HHIB DVDD VREFN VSS) mq_cdac_ctl_h
XLCTL (RL LHIB DVDD VREFN VSS) mq_cdac_ctl_l
XDH (HHIB EN ENB BH VREFP VREFN VSS DVDD) mq_cdac_drv7
CH (TOP BH) cfmom_2t w=5e-08 s=2.4e-07 nr=6 lr=1.69e-06 stm=2 spm=4 multi=28
CPH (BH VSS) capacitor c=1.4032060e-15
CHA (TOP MIDH) cfmom_2t w=5e-08 s=2.4e-07 nr=6 lr=1.69e-06 stm=2 spm=4 multi=1
CPHA (MIDH VSS) capacitor c=5.01145e-17
CHB (MIDH BH) cfmom_2t w=5e-08 s=2.4e-07 nr=6 lr=1.69e-06 stm=2 spm=4 multi=1
CPHB (BH VSS) capacitor c=5.01145e-17
MSH (BH VG VIN VSS) nch_ulvt_mac w=6.65e-07 l=3e-08 nf=1
XDL (LHIB EN ENB BL VREFP VREFN VSS DVDD) mq_cdac_drv7
CL (TOP BL) cfmom_2t w=5e-08 s=2.4e-07 nr=6 lr=1.69e-06 stm=2 spm=4 multi=28
CPL (BL VSS) capacitor c=1.4032060e-15
CLA (TOP MIDL) cfmom_2t w=5e-08 s=2.4e-07 nr=6 lr=1.69e-06 stm=2 spm=4 multi=1
CPLA (MIDL VSS) capacitor c=5.01145e-17
CLB (MIDL BL) cfmom_2t w=5e-08 s=2.4e-07 nr=6 lr=1.69e-06 stm=2 spm=4 multi=1
CPLB (BL VSS) capacitor c=5.01145e-17
MSL (BL VG VIN VSS) nch_ulvt_mac w=6.65e-07 l=3e-08 nf=1
MEQ1 (BH APGATE VIN VREFP) pch_ulvt_mac w=6.65e-07 l=3e-08 nf=1
MEQ2 (BL APGATE VIN VREFP) pch_ulvt_mac w=6.65e-07 l=3e-08 nf=1
MMIDNH (MIDH PHI_S VIN VSS) nch_ulvt_mac w=1.2e-07 l=3e-08 nf=1
MMIDPH (MIDH PHI_SB VIN VREFP) pch_mac w=1.2e-07 l=3e-08 nf=1
MMIDNL (MIDL PHI_S VIN VSS) nch_ulvt_mac w=1.2e-07 l=3e-08 nf=1
MMIDPL (MIDL PHI_SB VIN VREFP) pch_mac w=1.2e-07 l=3e-08 nf=1
MSHAREH (BH ENB EQBUS VSS) nch_ulvt_mac w=6.65e-07 l=3e-08 nf=1
MSHAREL (BL ENB EQBUS VSS) nch_ulvt_mac w=6.65e-07 l=3e-08 nf=1
// @RNL {
//   {&VIN &VG &DH &RL &EN &ENB &TOP &VREFP &VREFN &VSS &PHI_S &DVDD &PHI_SB &EQBUS &APGATE} @REMOVE-FROM $PORT_FILL_SET;
//   &VSS @ADD-TO $GROUND_NET_SET;
//   &VREFN @ADD-TO $GROUND_NET_SET;
//   #XHCTL @PLACE(0, 20) => @ORIENT("R0");
//   #XDH @PLACE(19, 18) => @ORIENT("R0");
//   &HHIB @WIRE {#XHCTL:2 #XDH:1};
//   %j1 = (115, 20);
//   %j2 = (38, 20);
//   %j3 = (52, 20);
//   %j4 = (66, 20);
//   %j5 = (84, 20);
//   &BH @WIRE {#XDH:4 %j2 %j3 %j4 %j5};
//   #CH @PLACE(100, 20) => @ORIENT("R270");
//   #CH @TEXT("", key="value");
//   #CH @TEXT("", key="name");
//   (100, 22.2) @TEXT("CH", size=1.05);
//   (100, 16.8) @TEXT("28 Cu", size=1.05);
//   &BH @WIRE {%j5 #CH:2};
//   &TOP @WIRE {#CH:1 %j1};
//   #CHA @PLACE(106, 40) => @ORIENT("R270");
//   #CHA @TEXT("", key="value");
//   #CHA @TEXT("", key="name");
//   (106, 42.2) @TEXT("CHA", size=1.05);
//   (106, 36.8) @TEXT("1 Cu", size=1.05);
//   #CHB @PLACE(84, 40) => @ORIENT("R270");
//   #CHB @TEXT("", key="value");
//   #CHB @TEXT("", key="name");
//   (84, 42.2) @TEXT("CHB", size=1.05);
//   (84, 36.8) @TEXT("1 Cu", size=1.05);
//   &BH @WIRE {%j5 (76, 20) (76, 40) #CHB:2};
//   %j6 = (94, 40);
//   &MIDH @WIRE {#CHB:1 %j6 #CHA:2};
//   (94, 42) @TEXT("MIDH", size=1.05);
//   %j7 = (115, 40);
//   &TOP @WIRE {#CHA:1 %j7};
//   #CPHA @PLACE(94, 31) => @ORIENT("R0");
//   #CPHA @TEXT("", key="value");
//   #CPHA @TEXT("", key="name");
//   (96, 32) @TEXT("CPHA", size=1.05);
//   (96, 30) @TEXT("0.05011 fF / 5%", size=1.05);
//   &MIDH @WIRE {%j6 #CPHA:1};
//   #CPHB @PLACE(98, 12) => @ORIENT("R0");
//   #CPHB @TEXT("", key="value");
//   #CPHB @TEXT("", key="name");
//   (100, 13) @TEXT("CPHB", size=1.05);
//   (100, 11) @TEXT("0.05011 fF / 5%", size=1.05);
//   &BH @WIRE {%j5 (98, 20) #CPHB:1};
//   #CPH @PLACE(84, 12) => @ORIENT("R0");
//   #CPH @TEXT("", key="value");
//   #CPH @TEXT("", key="name");
//   (86, 13) @TEXT("CPH", size=1.05);
//   (86, 11) @TEXT("1.403 fF / 5%", size=1.05);
//   &BH @WIRE {%j5 #CPH:1};
//   #MSH @PLACE(38, 7) => @ORIENT("R0");
//   #MSH @SET-SYMBOL $NMOS;
//   #MSH @TEXT("ULVT 0.665u", key="model", size=1.05, dx=1.5, dy=-1);
//   #MSH @TEXT("MSH", key="name", size=1.1, dx=1.5, dy=1);
//   &BH @WIRE {%j2 #MSH:1};
//   #MEQ1 @PLACE(52, 7) => @ORIENT("MX");
//   #MEQ1 @SET-SYMBOL $PMOS;
//   #MEQ1 @TEXT("ULVT 0.665u", key="model", size=1.05, dx=1.5, dy=-1);
//   #MEQ1 @TEXT("MEQ1", key="name", size=1.1, dx=1.5, dy=1);
//   &BH @WIRE {%j3 #MEQ1:1};
//   #MSHAREH @PLACE(66, 7) => @ORIENT("R0");
//   #MSHAREH @SET-SYMBOL $NMOS;
//   #MSHAREH @TEXT("ULVT 0.665u", key="model", size=1.05, dx=1.5, dy=-1);
//   #MSHAREH @TEXT("MSHAREH", key="name", size=1.1, dx=1.5, dy=1);
//   &BH @WIRE {%j4 #MSHAREH:1};
//   #MMIDNH @PLACE(126, 14) => @ORIENT("R0");
//   #MMIDNH @SET-SYMBOL $NMOS;
//   #MMIDNH @TEXT("ULVT 0.12u", key="model", size=1.05, dx=1.5, dy=-1);
//   #MMIDNH @TEXT("MMIDNH", key="name", size=1.1, dx=1.5, dy=1);
//   #MMIDPH @PLACE(142, 14) => @ORIENT("MX");
//   #MMIDPH @SET-SYMBOL $PMOS;
//   #MMIDPH @TEXT("SVT 0.12u", key="model", size=1.05, dx=1.5, dy=-1);
//   #MMIDPH @TEXT("MMIDPH", key="name", size=1.1, dx=1.5, dy=1);
//   &MIDH @WIRE {#MMIDNH:1 (126, 23) (142, 23) #MMIDPH:1};
//   (132, 24) @TEXT("MIDH", size=1.05);
//   (123, 27) @TEXT("MIDH sampling TG", size=1.05);
//   (-8, 35) @TEXT("High bank", size=1.05);
//   #XLCTL @PLACE(0, -27) => @ORIENT("R0");
//   #XDL @PLACE(19, -29) => @ORIENT("R0");
//   &LHIB @WIRE {#XLCTL:2 #XDL:1};
//   %j8 = (115, -27);
//   %j9 = (38, -27);
//   %j10 = (52, -27);
//   %j11 = (66, -27);
//   %j12 = (84, -27);
//   &BL @WIRE {#XDL:4 %j9 %j10 %j11 %j12};
//   #CL @PLACE(100, -27) => @ORIENT("R270");
//   #CL @TEXT("", key="value");
//   #CL @TEXT("", key="name");
//   (100, -24.8) @TEXT("CL", size=1.05);
//   (100, -30.2) @TEXT("28 Cu", size=1.05);
//   &BL @WIRE {%j12 #CL:2};
//   &TOP @WIRE {#CL:1 %j8};
//   #CLA @PLACE(106, -7) => @ORIENT("R270");
//   #CLA @TEXT("", key="value");
//   #CLA @TEXT("", key="name");
//   (106, -4.8) @TEXT("CLA", size=1.05);
//   (106, -10.2) @TEXT("1 Cu", size=1.05);
//   #CLB @PLACE(84, -7) => @ORIENT("R270");
//   #CLB @TEXT("", key="value");
//   #CLB @TEXT("", key="name");
//   (84, -4.8) @TEXT("CLB", size=1.05);
//   (84, -10.2) @TEXT("1 Cu", size=1.05);
//   &BL @WIRE {%j12 (76, -27) (76, -7) #CLB:2};
//   %j13 = (94, -7);
//   &MIDL @WIRE {#CLB:1 %j13 #CLA:2};
//   (94, -5) @TEXT("MIDL", size=1.05);
//   %j14 = (115, -7);
//   &TOP @WIRE {#CLA:1 %j14};
//   #CPLA @PLACE(94, -16) => @ORIENT("R0");
//   #CPLA @TEXT("", key="value");
//   #CPLA @TEXT("", key="name");
//   (96, -15) @TEXT("CPLA", size=1.05);
//   (96, -17) @TEXT("0.05011 fF / 5%", size=1.05);
//   &MIDL @WIRE {%j13 #CPLA:1};
//   #CPLB @PLACE(98, -35) => @ORIENT("R0");
//   #CPLB @TEXT("", key="value");
//   #CPLB @TEXT("", key="name");
//   (100, -34) @TEXT("CPLB", size=1.05);
//   (100, -36) @TEXT("0.05011 fF / 5%", size=1.05);
//   &BL @WIRE {%j12 (98, -27) #CPLB:1};
//   #CPL @PLACE(84, -35) => @ORIENT("R0");
//   #CPL @TEXT("", key="value");
//   #CPL @TEXT("", key="name");
//   (86, -34) @TEXT("CPL", size=1.05);
//   (86, -36) @TEXT("1.403 fF / 5%", size=1.05);
//   &BL @WIRE {%j12 #CPL:1};
//   #MSL @PLACE(38, -40) => @ORIENT("R0");
//   #MSL @SET-SYMBOL $NMOS;
//   #MSL @TEXT("ULVT 0.665u", key="model", size=1.05, dx=1.5, dy=-1);
//   #MSL @TEXT("MSL", key="name", size=1.1, dx=1.5, dy=1);
//   &BL @WIRE {%j9 #MSL:1};
//   #MEQ2 @PLACE(52, -40) => @ORIENT("MX");
//   #MEQ2 @SET-SYMBOL $PMOS;
//   #MEQ2 @TEXT("ULVT 0.665u", key="model", size=1.05, dx=1.5, dy=-1);
//   #MEQ2 @TEXT("MEQ2", key="name", size=1.1, dx=1.5, dy=1);
//   &BL @WIRE {%j10 #MEQ2:1};
//   #MSHAREL @PLACE(66, -40) => @ORIENT("R0");
//   #MSHAREL @SET-SYMBOL $NMOS;
//   #MSHAREL @TEXT("ULVT 0.665u", key="model", size=1.05, dx=1.5, dy=-1);
//   #MSHAREL @TEXT("MSHAREL", key="name", size=1.1, dx=1.5, dy=1);
//   &BL @WIRE {%j11 #MSHAREL:1};
//   #MMIDNL @PLACE(126, -33) => @ORIENT("R0");
//   #MMIDNL @SET-SYMBOL $NMOS;
//   #MMIDNL @TEXT("ULVT 0.12u", key="model", size=1.05, dx=1.5, dy=-1);
//   #MMIDNL @TEXT("MMIDNL", key="name", size=1.1, dx=1.5, dy=1);
//   #MMIDPL @PLACE(142, -33) => @ORIENT("MX");
//   #MMIDPL @SET-SYMBOL $PMOS;
//   #MMIDPL @TEXT("SVT 0.12u", key="model", size=1.05, dx=1.5, dy=-1);
//   #MMIDPL @TEXT("MMIDPL", key="name", size=1.1, dx=1.5, dy=1);
//   &MIDL @WIRE {#MMIDNL:1 (126, -24) (142, -24) #MMIDPL:1};
//   (132, -23) @TEXT("MIDL", size=1.05);
//   (123, -20) @TEXT("MIDL sampling TG", size=1.05);
//   (-8, -12) @TEXT("Low bank", size=1.05);
//   &TOP @WIRE {%j7 %j1 %j14 %j8};
//   (116, -3) @TEXT("TOP", size=1.05);
//   (-8, -51) @TEXT("Cu = 1.00229 fF. Cp = 5% of every physical MOM, including series MID.", size=1.05);
//   (-8, -54) @TEXT("DH -> buffer; RL -> inverter. Control supply: DVDD / VREFN; body: VSS.", size=1.05);
//   (-8, -57) @TEXT("5% Cp is a user estimate, not extraction.", size=1.05);
//   &DH @WIRE {#XHCTL:1 (-6, 20)};
//   (-6.3, 20) @TEXT("DH", size=1.05, halign="end", valign="middle");
//   &EN @WIRE {#XDH:2 (9, 16)};
//   (8.7, 16) @TEXT("EN", size=1.05, halign="end", valign="middle");
//   &ENB @WIRE {#XDH:3 (9, 13)};
//   (8.7, 13) @TEXT("ENB", size=1.05, halign="end", valign="middle");
//   %t18 = $SUPPLY @ATTACH &VREFP => @PLACE(22, 29);
//   &VREFP @WIRE {#XDH:5 %t18:p};
//   %t19 = $GROUND @ATTACH &VREFN => @PLACE(22, 7);
//   &VREFN @WIRE {#XDH:6 %t19:p};
//   %t20 = $GROUND @ATTACH &VSS => @PLACE(16, 7);
//   &VSS @WIRE {#XDH:7 %t20:p};
//   %t21 = $SUPPLY @ATTACH &DVDD => @PLACE(16, 29);
//   &DVDD @WIRE {#XDH:8 %t21:p};
//   %t22 = $GROUND @ATTACH &VSS => @PLACE(94, 27);
//   &VSS @WIRE {#CPHA:2 %t22:p};
//   %t23 = $GROUND @ATTACH &VSS => @PLACE(98, 8);
//   &VSS @WIRE {#CPHB:2 %t23:p};
//   %t24 = $GROUND @ATTACH &VSS => @PLACE(84, 8);
//   &VSS @WIRE {#CPH:2 %t24:p};
//   &VG @WIRE {#MSH:2 (33, 7)};
//   (32.7, 10.2) @TEXT("VG", size=1.05, halign="end", valign="middle");
//   &VIN @WIRE {#MSH:3 (38, 3)};
//   (38, 2.4) @TEXT("VIN", size=1.05, halign="middle", valign="top");
//   &APGATE @WIRE {#MEQ1:2 (47, 7)};
//   (46.7, 10.2) @TEXT("APGATE", size=1.05, halign="end", valign="middle");
//   &VIN @WIRE {#MEQ1:3 (52, 3)};
//   (52, 2.4) @TEXT("VIN", size=1.05, halign="middle", valign="top");
//   &ENB @WIRE {#MSHAREH:2 (61, 7)};
//   (60.7, 10.2) @TEXT("ENB", size=1.05, halign="end", valign="middle");
//   &EQBUS @WIRE {#MSHAREH:3 (66, 3)};
//   (66, 2.4) @TEXT("EQBUS", size=1.05, halign="middle", valign="top");
//   &PHI_S @WIRE {#MMIDNH:2 (121, 14)};
//   (120.7, 17.2) @TEXT("PHI_S", size=1.05, halign="end", valign="middle");
//   &VIN @WIRE {#MMIDNH:3 (126, 10)};
//   (126, 9.4) @TEXT("VIN", size=1.05, halign="middle", valign="top");
//   &PHI_SB @WIRE {#MMIDPH:2 (137, 14)};
//   (136.7, 17.2) @TEXT("PHI_SB", size=1.05, halign="end", valign="middle");
//   &VIN @WIRE {#MMIDPH:3 (142, 10)};
//   (142, 9.4) @TEXT("VIN", size=1.05, halign="middle", valign="top");
//   &RL @WIRE {#XLCTL:1 (-6, -27)};
//   (-6.3, -27) @TEXT("RL", size=1.05, halign="end", valign="middle");
//   &EN @WIRE {#XDL:2 (9, -31)};
//   (8.7, -31) @TEXT("EN", size=1.05, halign="end", valign="middle");
//   &ENB @WIRE {#XDL:3 (9, -34)};
//   (8.7, -34) @TEXT("ENB", size=1.05, halign="end", valign="middle");
//   %t38 = $SUPPLY @ATTACH &VREFP => @PLACE(22, -18);
//   &VREFP @WIRE {#XDL:5 %t38:p};
//   %t39 = $GROUND @ATTACH &VREFN => @PLACE(22, -40);
//   &VREFN @WIRE {#XDL:6 %t39:p};
//   %t40 = $GROUND @ATTACH &VSS => @PLACE(16, -40);
//   &VSS @WIRE {#XDL:7 %t40:p};
//   %t41 = $SUPPLY @ATTACH &DVDD => @PLACE(16, -18);
//   &DVDD @WIRE {#XDL:8 %t41:p};
//   %t42 = $GROUND @ATTACH &VSS => @PLACE(94, -20);
//   &VSS @WIRE {#CPLA:2 %t42:p};
//   %t43 = $GROUND @ATTACH &VSS => @PLACE(98, -39);
//   &VSS @WIRE {#CPLB:2 %t43:p};
//   %t44 = $GROUND @ATTACH &VSS => @PLACE(84, -39);
//   &VSS @WIRE {#CPL:2 %t44:p};
//   &VG @WIRE {#MSL:2 (33, -40)};
//   (32.7, -36.8) @TEXT("VG", size=1.05, halign="end", valign="middle");
//   &VIN @WIRE {#MSL:3 (38, -44)};
//   (38, -44.6) @TEXT("VIN", size=1.05, halign="middle", valign="top");
//   &APGATE @WIRE {#MEQ2:2 (47, -40)};
//   (46.7, -36.8) @TEXT("APGATE", size=1.05, halign="end", valign="middle");
//   &VIN @WIRE {#MEQ2:3 (52, -44)};
//   (52, -44.6) @TEXT("VIN", size=1.05, halign="middle", valign="top");
//   &ENB @WIRE {#MSHAREL:2 (61, -40)};
//   (60.7, -36.8) @TEXT("ENB", size=1.05, halign="end", valign="middle");
//   &EQBUS @WIRE {#MSHAREL:3 (66, -44)};
//   (66, -44.6) @TEXT("EQBUS", size=1.05, halign="middle", valign="top");
//   &PHI_S @WIRE {#MMIDNL:2 (121, -33)};
//   (120.7, -29.8) @TEXT("PHI_S", size=1.05, halign="end", valign="middle");
//   &VIN @WIRE {#MMIDNL:3 (126, -37)};
//   (126, -37.6) @TEXT("VIN", size=1.05, halign="middle", valign="top");
//   &PHI_SB @WIRE {#MMIDPL:2 (137, -33)};
//   (136.7, -29.8) @TEXT("PHI_SB", size=1.05, halign="end", valign="middle");
//   &VIN @WIRE {#MMIDPL:3 (142, -37)};
//   (142, -37.6) @TEXT("VIN", size=1.05, halign="middle", valign="top");
//   $JUNCTION @ATTACH %j1;
//   $JUNCTION @ATTACH %j2;
//   $JUNCTION @ATTACH %j3;
//   $JUNCTION @ATTACH %j4;
//   $JUNCTION @ATTACH %j5;
//   $JUNCTION @ATTACH %j6;
//   $JUNCTION @ATTACH %j9;
//   $JUNCTION @ATTACH %j10;
//   $JUNCTION @ATTACH %j11;
//   $JUNCTION @ATTACH %j12;
//   $JUNCTION @ATTACH %j13;
//   $JUNCTION @ATTACH %j14;
//   (-8, 57) @TEXT("N4 formal candidate / WIP | weight 7: 57 | matched H/L banks | unit series tail", size=1.4, bold=true, textcolor="#17365d");
//   (-8, 54.6) @TEXT("Drawing only | N bulk = VSS; L = 30 nm. P bulk VREFP: MEQ1, MEQ2, MMIDPH, MMIDPL", size=1.05, textcolor="#52606d");
// }
ends mq_cdac_bit7

// Reference-rail output driver j=6
subckt mq_cdac_drv6 (HIB EN ENB BP VREFP VREFN VSS DVDD)
// DVDD prelogic: PCOND = NOR(ENB,HIB); NOFF = NAND(EN,HIB).
// Reference-powered final inverters restore GP and GN to VREFP/VREFN.
// Actual current overlap, settling and device stress require measurement.
MPA0 (AP ENB DVDD DVDD) pch_ulvt_mac w=2.6e-07 l=3e-08 nf=1
MPA1 (PCOND HIB AP DVDD) pch_ulvt_mac w=2.6e-07 l=3e-08 nf=1
MNA0 (PCOND ENB VREFN VSS) nch_ulvt_mac w=1.3e-07 l=3e-08 nf=1
MNA1 (PCOND HIB VREFN VSS) nch_ulvt_mac w=1.3e-07 l=3e-08 nf=1
MPB0 (NOFF EN DVDD DVDD) pch_ulvt_mac w=1.3e-07 l=3e-08 nf=1
MPB1 (NOFF HIB DVDD DVDD) pch_ulvt_mac w=1.3e-07 l=3e-08 nf=1
MNB0 (NOFF EN BN VSS) nch_ulvt_mac w=1.3e-07 l=3e-08 nf=1
MNB1 (BN HIB VREFN VSS) nch_ulvt_mac w=1.3e-07 l=3e-08 nf=1
MGPN (GP PCOND VREFN VSS) nch_mac w=2.6e-07 l=3e-08 nf=1
MGPP (GP PCOND VREFP VREFP) pch_mac w=3.9e-07 l=3e-08 nf=1
MGNN (GN NOFF VREFN VSS) nch_mac w=2.6e-07 l=3e-08 nf=1
MGNP (GN NOFF VREFP VREFP) pch_mac w=1.3e-07 l=3e-08 nf=1
MNOUT (BP GN VREFN VSS) nch_mac w=1.47e-06 l=3e-08 nf=3
MPOUT (BP GP VREFP VREFP) pch_mac w=2.94e-06 l=3e-08 nf=3
// @RNL {
//   {&HIB &EN &ENB &BP &VREFP &VREFN &VSS &DVDD} @REMOVE-FROM $PORT_FILL_SET;
//   &VSS @ADD-TO $GROUND_NET_SET;
//   &VREFN @ADD-TO $GROUND_NET_SET;
//   #MPA0 @PLACE(8, 32) => @ORIENT("R0");
//   #MPA0 @SET-SYMBOL $PMOS;
//   #MPA0 @TEXT("ULVT 0.26u", key="model", size=1.05, dx=1.5, dy=-1);
//   #MPA0 @TEXT("MPA0", key="name", size=1.1, dx=1.5, dy=1);
//   #MPA1 @PLACE(8, 24) => @ORIENT("R0");
//   #MPA1 @SET-SYMBOL $PMOS;
//   #MPA1 @TEXT("ULVT 0.26u", key="model", size=1.05, dx=1.5, dy=-1);
//   #MPA1 @TEXT("MPA1", key="name", size=1.1, dx=1.5, dy=1);
//   #MNA0 @PLACE(0, 8) => @ORIENT("R0");
//   #MNA0 @SET-SYMBOL $NMOS;
//   #MNA0 @TEXT("ULVT 0.13u", key="model", size=1.05, dx=1.5, dy=-1);
//   #MNA0 @TEXT("MNA0", key="name", size=1.1, dx=1.5, dy=1);
//   #MNA1 @PLACE(16, 8) => @ORIENT("R0");
//   #MNA1 @SET-SYMBOL $NMOS;
//   #MNA1 @TEXT("ULVT 0.13u", key="model", size=1.05, dx=1.5, dy=-1);
//   #MNA1 @TEXT("MNA1", key="name", size=1.1, dx=1.5, dy=1);
//   #MPB0 @PLACE(0, -8) => @ORIENT("R0");
//   #MPB0 @SET-SYMBOL $PMOS;
//   #MPB0 @TEXT("ULVT 0.13u", key="model", size=1.05, dx=1.5, dy=-1);
//   #MPB0 @TEXT("MPB0", key="name", size=1.1, dx=1.5, dy=1);
//   #MPB1 @PLACE(16, -8) => @ORIENT("R0");
//   #MPB1 @SET-SYMBOL $PMOS;
//   #MPB1 @TEXT("ULVT 0.13u", key="model", size=1.05, dx=1.5, dy=-1);
//   #MPB1 @TEXT("MPB1", key="name", size=1.1, dx=1.5, dy=1);
//   #MNB0 @PLACE(8, -24) => @ORIENT("R0");
//   #MNB0 @SET-SYMBOL $NMOS;
//   #MNB0 @TEXT("ULVT 0.13u", key="model", size=1.05, dx=1.5, dy=-1);
//   #MNB0 @TEXT("MNB0", key="name", size=1.1, dx=1.5, dy=1);
//   #MNB1 @PLACE(8, -32) => @ORIENT("R0");
//   #MNB1 @SET-SYMBOL $NMOS;
//   #MNB1 @TEXT("ULVT 0.13u", key="model", size=1.05, dx=1.5, dy=-1);
//   #MNB1 @TEXT("MNB1", key="name", size=1.1, dx=1.5, dy=1);
//   #MPOUT @PLACE(76, 18) => @ORIENT("R0");
//   #MPOUT @SET-SYMBOL $PMOS;
//   #MPOUT @TEXT("SVT 2.94u", key="model", size=1.05, dx=1.5, dy=-1);
//   #MPOUT @TEXT("MPOUT", key="name", size=1.1, dx=1.5, dy=1);
//   #MNOUT @PLACE(76, -18) => @ORIENT("R0");
//   #MNOUT @SET-SYMBOL $NMOS;
//   #MNOUT @TEXT("SVT 1.47u", key="model", size=1.05, dx=1.5, dy=-1);
//   #MNOUT @TEXT("MNOUT", key="name", size=1.1, dx=1.5, dy=1);
//   &AP @WIRE {#MPA0:1 #MPA1:3};
//   (10, 28) @TEXT("AP", size=1.05);
//   %j1 = (8, 16);
//   &PCOND @WIRE {#MNA0:1 (0, 16) %j1 (16, 16) #MNA1:1};
//   &PCOND @WIRE {#MPA1:1 %j1};
//   #MGPN @PLACE(43, 9) => @ORIENT("R0");
//   #MGPN @SET-SYMBOL $NMOS;
//   #MGPN @TEXT("SVT 0.26u", key="model", size=1.05, dx=1.5, dy=-1);
//   #MGPN @TEXT("MGPN", key="name", size=1.1, dx=1.5, dy=1);
//   #MGPP @PLACE(43, 23) => @ORIENT("R0");
//   #MGPP @SET-SYMBOL $PMOS;
//   #MGPP @TEXT("SVT 0.39u", key="model", size=1.05, dx=1.5, dy=-1);
//   #MGPP @TEXT("MGPP", key="name", size=1.1, dx=1.5, dy=1);
//   %j2 = (43, 16);
//   %j3 = (38, 16);
//   &GP @WIRE {#MGPN:1 %j2 #MGPP:1};
//   &PCOND @WIRE {#MGPN:2 (38, 9) %j3 (38, 23) #MGPP:2};
//   &PCOND @WIRE {%j1 %j3};
//   &GP @WIRE {%j2 (65, 16) (65, 18) #MPOUT:2};
//   %j4 = (8, -16);
//   &NOFF @WIRE {#MPB0:1 (0, -16) %j4 (16, -16) #MPB1:1};
//   &NOFF @WIRE {#MNB0:1 %j4};
//   &BN @WIRE {#MNB0:3 #MNB1:1};
//   (18, -14) @TEXT("NOFF", size=1.05);
//   #MGNN @PLACE(43, -23) => @ORIENT("R0");
//   #MGNN @SET-SYMBOL $NMOS;
//   #MGNN @TEXT("SVT 0.26u", key="model", size=1.05, dx=1.5, dy=-1);
//   #MGNN @TEXT("MGNN", key="name", size=1.1, dx=1.5, dy=1);
//   #MGNP @PLACE(43, -9) => @ORIENT("R0");
//   #MGNP @SET-SYMBOL $PMOS;
//   #MGNP @TEXT("SVT 0.13u", key="model", size=1.05, dx=1.5, dy=-1);
//   #MGNP @TEXT("MGNP", key="name", size=1.1, dx=1.5, dy=1);
//   %j5 = (43, -16);
//   %j6 = (38, -16);
//   &GN @WIRE {#MGNN:1 %j5 #MGNP:1};
//   &NOFF @WIRE {#MGNN:2 (38, -23) %j6 (38, -9) #MGNP:2};
//   &NOFF @WIRE {%j4 %j6};
//   &GN @WIRE {%j5 (65, -16) (65, -18) #MNOUT:2};
//   %j7 = (76, 0);
//   &BP @WIRE {#MPOUT:1 %j7 #MNOUT:1};
//   &BP @WIRE {%j7 (85, 0)};
//   (85, 1) @TEXT("BP", size=1.05);
//   (-5, 42) @TEXT("NOR: PCOND = ~(ENB | HIB)", size=1.05);
//   (-5, -42) @TEXT("NAND: NOFF = ~(EN & HIB)", size=1.05);
//   (31, 39) @TEXT("Reference gate drivers", size=1.05);
//   (67, 39) @TEXT("Output rail switch", size=1.05);
//   &ENB @WIRE {#MPA0:2 (3, 32)};
//   (2.7, 32) @TEXT("ENB", size=1.05, halign="end", valign="middle");
//   %t9 = $SUPPLY @ATTACH &DVDD => @PLACE(8, 36);
//   &DVDD @WIRE {#MPA0:3 %t9:p};
//   &HIB @WIRE {#MPA1:2 (3, 24)};
//   (2.7, 24) @TEXT("HIB", size=1.05, halign="end", valign="middle");
//   &ENB @WIRE {#MNA0:2 (-5, 8)};
//   (-5.3, 8) @TEXT("ENB", size=1.05, halign="end", valign="middle");
//   %t12 = $GROUND @ATTACH &VREFN => @PLACE(0, 4);
//   &VREFN @WIRE {#MNA0:3 %t12:p};
//   &HIB @WIRE {#MNA1:2 (11, 8)};
//   (10.7, 8) @TEXT("HIB", size=1.05, halign="end", valign="middle");
//   %t14 = $GROUND @ATTACH &VREFN => @PLACE(16, 4);
//   &VREFN @WIRE {#MNA1:3 %t14:p};
//   &EN @WIRE {#MPB0:2 (-5, -8)};
//   (-5.3, -8) @TEXT("EN", size=1.05, halign="end", valign="middle");
//   %t16 = $SUPPLY @ATTACH &DVDD => @PLACE(0, -4);
//   &DVDD @WIRE {#MPB0:3 %t16:p};
//   &HIB @WIRE {#MPB1:2 (11, -8)};
//   (10.7, -8) @TEXT("HIB", size=1.05, halign="end", valign="middle");
//   %t18 = $SUPPLY @ATTACH &DVDD => @PLACE(16, -4);
//   &DVDD @WIRE {#MPB1:3 %t18:p};
//   &EN @WIRE {#MNB0:2 (3, -24)};
//   (2.7, -24) @TEXT("EN", size=1.05, halign="end", valign="middle");
//   &HIB @WIRE {#MNB1:2 (3, -32)};
//   (2.7, -32) @TEXT("HIB", size=1.05, halign="end", valign="middle");
//   %t21 = $GROUND @ATTACH &VREFN => @PLACE(8, -36);
//   &VREFN @WIRE {#MNB1:3 %t21:p};
//   %t22 = $SUPPLY @ATTACH &VREFP => @PLACE(76, 22);
//   &VREFP @WIRE {#MPOUT:3 %t22:p};
//   %t23 = $GROUND @ATTACH &VREFN => @PLACE(76, -22);
//   &VREFN @WIRE {#MNOUT:3 %t23:p};
//   %t24 = $GROUND @ATTACH &VREFN => @PLACE(43, 5);
//   &VREFN @WIRE {#MGPN:3 %t24:p};
//   %t25 = $SUPPLY @ATTACH &VREFP => @PLACE(43, 27);
//   &VREFP @WIRE {#MGPP:3 %t25:p};
//   %t26 = $GROUND @ATTACH &VREFN => @PLACE(43, -27);
//   &VREFN @WIRE {#MGNN:3 %t26:p};
//   %t27 = $SUPPLY @ATTACH &VREFP => @PLACE(43, -5);
//   &VREFP @WIRE {#MGNP:3 %t27:p};
//   $JUNCTION @ATTACH %j1;
//   $JUNCTION @ATTACH %j2;
//   $JUNCTION @ATTACH %j3;
//   $JUNCTION @ATTACH %j4;
//   $JUNCTION @ATTACH %j5;
//   $JUNCTION @ATTACH %j6;
//   $JUNCTION @ATTACH %j7;
//   (-7, 51) @TEXT("N4 formal candidate / WIP | mq_cdac_drv6 | isolated DVDD logic / VREFP output", size=1.4, bold=true, textcolor="#17365d");
//   (-7, 48.6) @TEXT("Drawing only | N bulk = VSS; L = 30 nm. P bulk DVDD: MPA0, MPA1, MPB0, MPB1; VREFP: MGPP, MGNP, MPOUT", size=1.05, textcolor="#52606d");
// }
ends mq_cdac_drv6

// Matched half-capacitor pair j=6
subckt mq_cdac_bit6 (DH RL EN ENB TOP VREFP VREFN VSS DVDD)
// CP*: user-specified 5% bottom-plate estimate for every physical MOM unit, not extraction.
// Series tails retain one unit parasitic at MID and one at B.
XHCTL (DH HHIB DVDD VREFN VSS) mq_cdac_ctl_h
XLCTL (RL LHIB DVDD VREFN VSS) mq_cdac_ctl_l
XDH (HHIB EN ENB BH VREFP VREFN VSS DVDD) mq_cdac_drv6
CH (TOP BH) cfmom_2t w=5e-08 s=2.4e-07 nr=6 lr=1.69e-06 stm=2 spm=4 multi=16
CPH (BH VSS) capacitor c=8.018320e-16
XDL (LHIB EN ENB BL VREFP VREFN VSS DVDD) mq_cdac_drv6
CL (TOP BL) cfmom_2t w=5e-08 s=2.4e-07 nr=6 lr=1.69e-06 stm=2 spm=4 multi=16
CPL (BL VSS) capacitor c=8.018320e-16
// @RNL {
//   {&DH &RL &EN &ENB &TOP &VREFP &VREFN &VSS &DVDD} @REMOVE-FROM $PORT_FILL_SET;
//   &VSS @ADD-TO $GROUND_NET_SET;
//   &VREFN @ADD-TO $GROUND_NET_SET;
//   #XHCTL @PLACE(0, 20) => @ORIENT("R0");
//   #XDH @PLACE(19, 18) => @ORIENT("R0");
//   &HHIB @WIRE {#XHCTL:2 #XDH:1};
//   %j1 = (115, 20);
//   %j2 = (38, 20);
//   %j3 = (52, 20);
//   %j4 = (66, 20);
//   %j5 = (84, 20);
//   &BH @WIRE {#XDH:4 %j2 %j3 %j4 %j5};
//   #CH @PLACE(100, 20) => @ORIENT("R270");
//   #CH @TEXT("", key="value");
//   #CH @TEXT("", key="name");
//   (100, 22.2) @TEXT("CH", size=1.05);
//   (100, 16.8) @TEXT("16 Cu", size=1.05);
//   &BH @WIRE {%j5 #CH:2};
//   &TOP @WIRE {#CH:1 %j1};
//   #CPH @PLACE(84, 12) => @ORIENT("R0");
//   #CPH @TEXT("", key="value");
//   #CPH @TEXT("", key="name");
//   (86, 13) @TEXT("CPH", size=1.05);
//   (86, 11) @TEXT("0.8018 fF / 5%", size=1.05);
//   &BH @WIRE {%j5 #CPH:1};
//   (-8, 35) @TEXT("High bank", size=1.05);
//   #XLCTL @PLACE(0, -18) => @ORIENT("R0");
//   #XDL @PLACE(19, -20) => @ORIENT("R0");
//   &LHIB @WIRE {#XLCTL:2 #XDL:1};
//   %j6 = (115, -18);
//   %j7 = (38, -18);
//   %j8 = (52, -18);
//   %j9 = (66, -18);
//   %j10 = (84, -18);
//   &BL @WIRE {#XDL:4 %j7 %j8 %j9 %j10};
//   #CL @PLACE(100, -18) => @ORIENT("R270");
//   #CL @TEXT("", key="value");
//   #CL @TEXT("", key="name");
//   (100, -15.8) @TEXT("CL", size=1.05);
//   (100, -21.2) @TEXT("16 Cu", size=1.05);
//   &BL @WIRE {%j10 #CL:2};
//   &TOP @WIRE {#CL:1 %j6};
//   #CPL @PLACE(84, -26) => @ORIENT("R0");
//   #CPL @TEXT("", key="value");
//   #CPL @TEXT("", key="name");
//   (86, -25) @TEXT("CPL", size=1.05);
//   (86, -27) @TEXT("0.8018 fF / 5%", size=1.05);
//   &BL @WIRE {%j10 #CPL:1};
//   (-8, -3) @TEXT("Low bank", size=1.05);
//   &TOP @WIRE {%j1 %j6};
//   (116, -3) @TEXT("TOP", size=1.05);
//   (-8, -42) @TEXT("Cu = 1.00229 fF. Cp = 5% of every physical MOM, including series MID.", size=1.05);
//   (-8, -45) @TEXT("DH -> buffer; RL -> inverter. Control supply: DVDD / VREFN; body: VSS.", size=1.05);
//   (-8, -48) @TEXT("5% Cp is a user estimate, not extraction.", size=1.05);
//   &DH @WIRE {#XHCTL:1 (-6, 20)};
//   (-6.3, 20) @TEXT("DH", size=1.05, halign="end", valign="middle");
//   &EN @WIRE {#XDH:2 (9, 16)};
//   (8.7, 16) @TEXT("EN", size=1.05, halign="end", valign="middle");
//   &ENB @WIRE {#XDH:3 (9, 13)};
//   (8.7, 13) @TEXT("ENB", size=1.05, halign="end", valign="middle");
//   %t14 = $SUPPLY @ATTACH &VREFP => @PLACE(22, 29);
//   &VREFP @WIRE {#XDH:5 %t14:p};
//   %t15 = $GROUND @ATTACH &VREFN => @PLACE(22, 7);
//   &VREFN @WIRE {#XDH:6 %t15:p};
//   %t16 = $GROUND @ATTACH &VSS => @PLACE(16, 7);
//   &VSS @WIRE {#XDH:7 %t16:p};
//   %t17 = $SUPPLY @ATTACH &DVDD => @PLACE(16, 29);
//   &DVDD @WIRE {#XDH:8 %t17:p};
//   %t18 = $GROUND @ATTACH &VSS => @PLACE(84, 8);
//   &VSS @WIRE {#CPH:2 %t18:p};
//   &RL @WIRE {#XLCTL:1 (-6, -18)};
//   (-6.3, -18) @TEXT("RL", size=1.05, halign="end", valign="middle");
//   &EN @WIRE {#XDL:2 (9, -22)};
//   (8.7, -22) @TEXT("EN", size=1.05, halign="end", valign="middle");
//   &ENB @WIRE {#XDL:3 (9, -25)};
//   (8.7, -25) @TEXT("ENB", size=1.05, halign="end", valign="middle");
//   %t22 = $SUPPLY @ATTACH &VREFP => @PLACE(22, -9);
//   &VREFP @WIRE {#XDL:5 %t22:p};
//   %t23 = $GROUND @ATTACH &VREFN => @PLACE(22, -31);
//   &VREFN @WIRE {#XDL:6 %t23:p};
//   %t24 = $GROUND @ATTACH &VSS => @PLACE(16, -31);
//   &VSS @WIRE {#XDL:7 %t24:p};
//   %t25 = $SUPPLY @ATTACH &DVDD => @PLACE(16, -9);
//   &DVDD @WIRE {#XDL:8 %t25:p};
//   %t26 = $GROUND @ATTACH &VSS => @PLACE(84, -30);
//   &VSS @WIRE {#CPL:2 %t26:p};
//   $JUNCTION @ATTACH %j5;
//   $JUNCTION @ATTACH %j10;
//   (-8, 44) @TEXT("N4 formal candidate / WIP | weight 6: 32 | matched H/L banks", size=1.4, bold=true, textcolor="#17365d");
//   (-8, 41.6) @TEXT("Drawing only | N bulk = VSS; L = 30 nm. P bulk ", size=1.05, textcolor="#52606d");
// }
ends mq_cdac_bit6

// Reference-rail output driver j=5
subckt mq_cdac_drv5 (HIB EN ENB BP VREFP VREFN VSS DVDD)
// DVDD prelogic: PCOND = NOR(ENB,HIB); NOFF = NAND(EN,HIB).
// Reference-powered final inverters restore GP and GN to VREFP/VREFN.
// Actual current overlap, settling and device stress require measurement.
MPA0 (AP ENB DVDD DVDD) pch_ulvt_mac w=2.4e-07 l=3e-08 nf=1
MPA1 (PCOND HIB AP DVDD) pch_ulvt_mac w=2.4e-07 l=3e-08 nf=1
MNA0 (PCOND ENB VREFN VSS) nch_ulvt_mac w=1.2e-07 l=3e-08 nf=1
MNA1 (PCOND HIB VREFN VSS) nch_ulvt_mac w=1.2e-07 l=3e-08 nf=1
MPB0 (NOFF EN DVDD DVDD) pch_ulvt_mac w=1.2e-07 l=3e-08 nf=1
MPB1 (NOFF HIB DVDD DVDD) pch_ulvt_mac w=1.2e-07 l=3e-08 nf=1
MNB0 (NOFF EN BN VSS) nch_ulvt_mac w=1.2e-07 l=3e-08 nf=1
MNB1 (BN HIB VREFN VSS) nch_ulvt_mac w=1.2e-07 l=3e-08 nf=1
MGPN (GP PCOND VREFN VSS) nch_mac w=2.4e-07 l=3e-08 nf=1
MGPP (GP PCOND VREFP VREFP) pch_mac w=3.6e-07 l=3e-08 nf=1
MGNN (GN NOFF VREFN VSS) nch_mac w=2.4e-07 l=3e-08 nf=1
MGNP (GN NOFF VREFP VREFP) pch_mac w=1.2e-07 l=3e-08 nf=1
MNOUT (BP GN VREFN VSS) nch_mac w=4.5e-07 l=3e-08 nf=1
MPOUT (BP GP VREFP VREFP) pch_mac w=9e-07 l=3e-08 nf=1
// @RNL {
//   {&HIB &EN &ENB &BP &VREFP &VREFN &VSS &DVDD} @REMOVE-FROM $PORT_FILL_SET;
//   &VSS @ADD-TO $GROUND_NET_SET;
//   &VREFN @ADD-TO $GROUND_NET_SET;
//   #MPA0 @PLACE(8, 32) => @ORIENT("R0");
//   #MPA0 @SET-SYMBOL $PMOS;
//   #MPA0 @TEXT("ULVT 0.24u", key="model", size=1.05, dx=1.5, dy=-1);
//   #MPA0 @TEXT("MPA0", key="name", size=1.1, dx=1.5, dy=1);
//   #MPA1 @PLACE(8, 24) => @ORIENT("R0");
//   #MPA1 @SET-SYMBOL $PMOS;
//   #MPA1 @TEXT("ULVT 0.24u", key="model", size=1.05, dx=1.5, dy=-1);
//   #MPA1 @TEXT("MPA1", key="name", size=1.1, dx=1.5, dy=1);
//   #MNA0 @PLACE(0, 8) => @ORIENT("R0");
//   #MNA0 @SET-SYMBOL $NMOS;
//   #MNA0 @TEXT("ULVT 0.12u", key="model", size=1.05, dx=1.5, dy=-1);
//   #MNA0 @TEXT("MNA0", key="name", size=1.1, dx=1.5, dy=1);
//   #MNA1 @PLACE(16, 8) => @ORIENT("R0");
//   #MNA1 @SET-SYMBOL $NMOS;
//   #MNA1 @TEXT("ULVT 0.12u", key="model", size=1.05, dx=1.5, dy=-1);
//   #MNA1 @TEXT("MNA1", key="name", size=1.1, dx=1.5, dy=1);
//   #MPB0 @PLACE(0, -8) => @ORIENT("R0");
//   #MPB0 @SET-SYMBOL $PMOS;
//   #MPB0 @TEXT("ULVT 0.12u", key="model", size=1.05, dx=1.5, dy=-1);
//   #MPB0 @TEXT("MPB0", key="name", size=1.1, dx=1.5, dy=1);
//   #MPB1 @PLACE(16, -8) => @ORIENT("R0");
//   #MPB1 @SET-SYMBOL $PMOS;
//   #MPB1 @TEXT("ULVT 0.12u", key="model", size=1.05, dx=1.5, dy=-1);
//   #MPB1 @TEXT("MPB1", key="name", size=1.1, dx=1.5, dy=1);
//   #MNB0 @PLACE(8, -24) => @ORIENT("R0");
//   #MNB0 @SET-SYMBOL $NMOS;
//   #MNB0 @TEXT("ULVT 0.12u", key="model", size=1.05, dx=1.5, dy=-1);
//   #MNB0 @TEXT("MNB0", key="name", size=1.1, dx=1.5, dy=1);
//   #MNB1 @PLACE(8, -32) => @ORIENT("R0");
//   #MNB1 @SET-SYMBOL $NMOS;
//   #MNB1 @TEXT("ULVT 0.12u", key="model", size=1.05, dx=1.5, dy=-1);
//   #MNB1 @TEXT("MNB1", key="name", size=1.1, dx=1.5, dy=1);
//   #MPOUT @PLACE(76, 18) => @ORIENT("R0");
//   #MPOUT @SET-SYMBOL $PMOS;
//   #MPOUT @TEXT("SVT 0.9u", key="model", size=1.05, dx=1.5, dy=-1);
//   #MPOUT @TEXT("MPOUT", key="name", size=1.1, dx=1.5, dy=1);
//   #MNOUT @PLACE(76, -18) => @ORIENT("R0");
//   #MNOUT @SET-SYMBOL $NMOS;
//   #MNOUT @TEXT("SVT 0.45u", key="model", size=1.05, dx=1.5, dy=-1);
//   #MNOUT @TEXT("MNOUT", key="name", size=1.1, dx=1.5, dy=1);
//   &AP @WIRE {#MPA0:1 #MPA1:3};
//   (10, 28) @TEXT("AP", size=1.05);
//   %j1 = (8, 16);
//   &PCOND @WIRE {#MNA0:1 (0, 16) %j1 (16, 16) #MNA1:1};
//   &PCOND @WIRE {#MPA1:1 %j1};
//   #MGPN @PLACE(43, 9) => @ORIENT("R0");
//   #MGPN @SET-SYMBOL $NMOS;
//   #MGPN @TEXT("SVT 0.24u", key="model", size=1.05, dx=1.5, dy=-1);
//   #MGPN @TEXT("MGPN", key="name", size=1.1, dx=1.5, dy=1);
//   #MGPP @PLACE(43, 23) => @ORIENT("R0");
//   #MGPP @SET-SYMBOL $PMOS;
//   #MGPP @TEXT("SVT 0.36u", key="model", size=1.05, dx=1.5, dy=-1);
//   #MGPP @TEXT("MGPP", key="name", size=1.1, dx=1.5, dy=1);
//   %j2 = (43, 16);
//   %j3 = (38, 16);
//   &GP @WIRE {#MGPN:1 %j2 #MGPP:1};
//   &PCOND @WIRE {#MGPN:2 (38, 9) %j3 (38, 23) #MGPP:2};
//   &PCOND @WIRE {%j1 %j3};
//   &GP @WIRE {%j2 (65, 16) (65, 18) #MPOUT:2};
//   %j4 = (8, -16);
//   &NOFF @WIRE {#MPB0:1 (0, -16) %j4 (16, -16) #MPB1:1};
//   &NOFF @WIRE {#MNB0:1 %j4};
//   &BN @WIRE {#MNB0:3 #MNB1:1};
//   (18, -14) @TEXT("NOFF", size=1.05);
//   #MGNN @PLACE(43, -23) => @ORIENT("R0");
//   #MGNN @SET-SYMBOL $NMOS;
//   #MGNN @TEXT("SVT 0.24u", key="model", size=1.05, dx=1.5, dy=-1);
//   #MGNN @TEXT("MGNN", key="name", size=1.1, dx=1.5, dy=1);
//   #MGNP @PLACE(43, -9) => @ORIENT("R0");
//   #MGNP @SET-SYMBOL $PMOS;
//   #MGNP @TEXT("SVT 0.12u", key="model", size=1.05, dx=1.5, dy=-1);
//   #MGNP @TEXT("MGNP", key="name", size=1.1, dx=1.5, dy=1);
//   %j5 = (43, -16);
//   %j6 = (38, -16);
//   &GN @WIRE {#MGNN:1 %j5 #MGNP:1};
//   &NOFF @WIRE {#MGNN:2 (38, -23) %j6 (38, -9) #MGNP:2};
//   &NOFF @WIRE {%j4 %j6};
//   &GN @WIRE {%j5 (65, -16) (65, -18) #MNOUT:2};
//   %j7 = (76, 0);
//   &BP @WIRE {#MPOUT:1 %j7 #MNOUT:1};
//   &BP @WIRE {%j7 (85, 0)};
//   (85, 1) @TEXT("BP", size=1.05);
//   (-5, 42) @TEXT("NOR: PCOND = ~(ENB | HIB)", size=1.05);
//   (-5, -42) @TEXT("NAND: NOFF = ~(EN & HIB)", size=1.05);
//   (31, 39) @TEXT("Reference gate drivers", size=1.05);
//   (67, 39) @TEXT("Output rail switch", size=1.05);
//   &ENB @WIRE {#MPA0:2 (3, 32)};
//   (2.7, 32) @TEXT("ENB", size=1.05, halign="end", valign="middle");
//   %t9 = $SUPPLY @ATTACH &DVDD => @PLACE(8, 36);
//   &DVDD @WIRE {#MPA0:3 %t9:p};
//   &HIB @WIRE {#MPA1:2 (3, 24)};
//   (2.7, 24) @TEXT("HIB", size=1.05, halign="end", valign="middle");
//   &ENB @WIRE {#MNA0:2 (-5, 8)};
//   (-5.3, 8) @TEXT("ENB", size=1.05, halign="end", valign="middle");
//   %t12 = $GROUND @ATTACH &VREFN => @PLACE(0, 4);
//   &VREFN @WIRE {#MNA0:3 %t12:p};
//   &HIB @WIRE {#MNA1:2 (11, 8)};
//   (10.7, 8) @TEXT("HIB", size=1.05, halign="end", valign="middle");
//   %t14 = $GROUND @ATTACH &VREFN => @PLACE(16, 4);
//   &VREFN @WIRE {#MNA1:3 %t14:p};
//   &EN @WIRE {#MPB0:2 (-5, -8)};
//   (-5.3, -8) @TEXT("EN", size=1.05, halign="end", valign="middle");
//   %t16 = $SUPPLY @ATTACH &DVDD => @PLACE(0, -4);
//   &DVDD @WIRE {#MPB0:3 %t16:p};
//   &HIB @WIRE {#MPB1:2 (11, -8)};
//   (10.7, -8) @TEXT("HIB", size=1.05, halign="end", valign="middle");
//   %t18 = $SUPPLY @ATTACH &DVDD => @PLACE(16, -4);
//   &DVDD @WIRE {#MPB1:3 %t18:p};
//   &EN @WIRE {#MNB0:2 (3, -24)};
//   (2.7, -24) @TEXT("EN", size=1.05, halign="end", valign="middle");
//   &HIB @WIRE {#MNB1:2 (3, -32)};
//   (2.7, -32) @TEXT("HIB", size=1.05, halign="end", valign="middle");
//   %t21 = $GROUND @ATTACH &VREFN => @PLACE(8, -36);
//   &VREFN @WIRE {#MNB1:3 %t21:p};
//   %t22 = $SUPPLY @ATTACH &VREFP => @PLACE(76, 22);
//   &VREFP @WIRE {#MPOUT:3 %t22:p};
//   %t23 = $GROUND @ATTACH &VREFN => @PLACE(76, -22);
//   &VREFN @WIRE {#MNOUT:3 %t23:p};
//   %t24 = $GROUND @ATTACH &VREFN => @PLACE(43, 5);
//   &VREFN @WIRE {#MGPN:3 %t24:p};
//   %t25 = $SUPPLY @ATTACH &VREFP => @PLACE(43, 27);
//   &VREFP @WIRE {#MGPP:3 %t25:p};
//   %t26 = $GROUND @ATTACH &VREFN => @PLACE(43, -27);
//   &VREFN @WIRE {#MGNN:3 %t26:p};
//   %t27 = $SUPPLY @ATTACH &VREFP => @PLACE(43, -5);
//   &VREFP @WIRE {#MGNP:3 %t27:p};
//   $JUNCTION @ATTACH %j1;
//   $JUNCTION @ATTACH %j2;
//   $JUNCTION @ATTACH %j3;
//   $JUNCTION @ATTACH %j4;
//   $JUNCTION @ATTACH %j5;
//   $JUNCTION @ATTACH %j6;
//   $JUNCTION @ATTACH %j7;
//   (-7, 51) @TEXT("N4 formal candidate / WIP | mq_cdac_drv5 | isolated DVDD logic / VREFP output", size=1.4, bold=true, textcolor="#17365d");
//   (-7, 48.6) @TEXT("Drawing only | N bulk = VSS; L = 30 nm. P bulk DVDD: MPA0, MPA1, MPB0, MPB1; VREFP: MGPP, MGNP, MPOUT", size=1.05, textcolor="#52606d");
// }
ends mq_cdac_drv5

// Matched half-capacitor pair j=5
subckt mq_cdac_bit5 (VIN VG DH RL EN ENB TOP VREFP VREFN VSS DVDD EQBUS APGATE)
// CP*: user-specified 5% bottom-plate estimate for every physical MOM unit, not extraction.
// Series tails retain one unit parasitic at MID and one at B.
// APGATE PMOS assist connects each bottom plate to VIN.
// Additional ENB NMOS sharing retains a common EQBUS.
XHCTL (DH HHIB DVDD VREFN VSS) mq_cdac_ctl_h
XLCTL (RL LHIB DVDD VREFN VSS) mq_cdac_ctl_l
XDH (HHIB EN ENB BH VREFP VREFN VSS DVDD) mq_cdac_drv5
CH (TOP BH) cfmom_2t w=5e-08 s=2.4e-07 nr=6 lr=1.69e-06 stm=2 spm=4 multi=9
CPH (BH VSS) capacitor c=4.510305e-16
MSH (BH VG VIN VSS) nch_ulvt_mac w=2.1e-07 l=3e-08 nf=1
XDL (LHIB EN ENB BL VREFP VREFN VSS DVDD) mq_cdac_drv5
CL (TOP BL) cfmom_2t w=5e-08 s=2.4e-07 nr=6 lr=1.69e-06 stm=2 spm=4 multi=9
CPL (BL VSS) capacitor c=4.510305e-16
MSL (BL VG VIN VSS) nch_ulvt_mac w=2.1e-07 l=3e-08 nf=1
MEQ1 (BH APGATE VIN VREFP) pch_ulvt_mac w=2.1e-07 l=3e-08 nf=1
MEQ2 (BL APGATE VIN VREFP) pch_ulvt_mac w=2.1e-07 l=3e-08 nf=1
MSHAREH (BH ENB EQBUS VSS) nch_ulvt_mac w=2.1e-07 l=3e-08 nf=1
MSHAREL (BL ENB EQBUS VSS) nch_ulvt_mac w=2.1e-07 l=3e-08 nf=1
// @RNL {
//   {&VIN &VG &DH &RL &EN &ENB &TOP &VREFP &VREFN &VSS &DVDD &EQBUS &APGATE} @REMOVE-FROM $PORT_FILL_SET;
//   &VSS @ADD-TO $GROUND_NET_SET;
//   &VREFN @ADD-TO $GROUND_NET_SET;
//   #XHCTL @PLACE(0, 20) => @ORIENT("R0");
//   #XDH @PLACE(19, 18) => @ORIENT("R0");
//   &HHIB @WIRE {#XHCTL:2 #XDH:1};
//   %j1 = (115, 20);
//   %j2 = (38, 20);
//   %j3 = (52, 20);
//   %j4 = (66, 20);
//   %j5 = (84, 20);
//   &BH @WIRE {#XDH:4 %j2 %j3 %j4 %j5};
//   #CH @PLACE(100, 20) => @ORIENT("R270");
//   #CH @TEXT("", key="value");
//   #CH @TEXT("", key="name");
//   (100, 22.2) @TEXT("CH", size=1.05);
//   (100, 16.8) @TEXT("9 Cu", size=1.05);
//   &BH @WIRE {%j5 #CH:2};
//   &TOP @WIRE {#CH:1 %j1};
//   #CPH @PLACE(84, 12) => @ORIENT("R0");
//   #CPH @TEXT("", key="value");
//   #CPH @TEXT("", key="name");
//   (86, 13) @TEXT("CPH", size=1.05);
//   (86, 11) @TEXT("0.451 fF / 5%", size=1.05);
//   &BH @WIRE {%j5 #CPH:1};
//   #MSH @PLACE(38, 7) => @ORIENT("R0");
//   #MSH @SET-SYMBOL $NMOS;
//   #MSH @TEXT("ULVT 0.21u", key="model", size=1.05, dx=1.5, dy=-1);
//   #MSH @TEXT("MSH", key="name", size=1.1, dx=1.5, dy=1);
//   &BH @WIRE {%j2 #MSH:1};
//   #MEQ1 @PLACE(52, 7) => @ORIENT("MX");
//   #MEQ1 @SET-SYMBOL $PMOS;
//   #MEQ1 @TEXT("ULVT 0.21u", key="model", size=1.05, dx=1.5, dy=-1);
//   #MEQ1 @TEXT("MEQ1", key="name", size=1.1, dx=1.5, dy=1);
//   &BH @WIRE {%j3 #MEQ1:1};
//   #MSHAREH @PLACE(66, 7) => @ORIENT("R0");
//   #MSHAREH @SET-SYMBOL $NMOS;
//   #MSHAREH @TEXT("ULVT 0.21u", key="model", size=1.05, dx=1.5, dy=-1);
//   #MSHAREH @TEXT("MSHAREH", key="name", size=1.1, dx=1.5, dy=1);
//   &BH @WIRE {%j4 #MSHAREH:1};
//   (-8, 35) @TEXT("High bank", size=1.05);
//   #XLCTL @PLACE(0, -18) => @ORIENT("R0");
//   #XDL @PLACE(19, -20) => @ORIENT("R0");
//   &LHIB @WIRE {#XLCTL:2 #XDL:1};
//   %j6 = (115, -18);
//   %j7 = (38, -18);
//   %j8 = (52, -18);
//   %j9 = (66, -18);
//   %j10 = (84, -18);
//   &BL @WIRE {#XDL:4 %j7 %j8 %j9 %j10};
//   #CL @PLACE(100, -18) => @ORIENT("R270");
//   #CL @TEXT("", key="value");
//   #CL @TEXT("", key="name");
//   (100, -15.8) @TEXT("CL", size=1.05);
//   (100, -21.2) @TEXT("9 Cu", size=1.05);
//   &BL @WIRE {%j10 #CL:2};
//   &TOP @WIRE {#CL:1 %j6};
//   #CPL @PLACE(84, -26) => @ORIENT("R0");
//   #CPL @TEXT("", key="value");
//   #CPL @TEXT("", key="name");
//   (86, -25) @TEXT("CPL", size=1.05);
//   (86, -27) @TEXT("0.451 fF / 5%", size=1.05);
//   &BL @WIRE {%j10 #CPL:1};
//   #MSL @PLACE(38, -31) => @ORIENT("R0");
//   #MSL @SET-SYMBOL $NMOS;
//   #MSL @TEXT("ULVT 0.21u", key="model", size=1.05, dx=1.5, dy=-1);
//   #MSL @TEXT("MSL", key="name", size=1.1, dx=1.5, dy=1);
//   &BL @WIRE {%j7 #MSL:1};
//   #MEQ2 @PLACE(52, -31) => @ORIENT("MX");
//   #MEQ2 @SET-SYMBOL $PMOS;
//   #MEQ2 @TEXT("ULVT 0.21u", key="model", size=1.05, dx=1.5, dy=-1);
//   #MEQ2 @TEXT("MEQ2", key="name", size=1.1, dx=1.5, dy=1);
//   &BL @WIRE {%j8 #MEQ2:1};
//   #MSHAREL @PLACE(66, -31) => @ORIENT("R0");
//   #MSHAREL @SET-SYMBOL $NMOS;
//   #MSHAREL @TEXT("ULVT 0.21u", key="model", size=1.05, dx=1.5, dy=-1);
//   #MSHAREL @TEXT("MSHAREL", key="name", size=1.1, dx=1.5, dy=1);
//   &BL @WIRE {%j9 #MSHAREL:1};
//   (-8, -3) @TEXT("Low bank", size=1.05);
//   &TOP @WIRE {%j1 %j6};
//   (116, -3) @TEXT("TOP", size=1.05);
//   (-8, -42) @TEXT("Cu = 1.00229 fF. Cp = 5% of every physical MOM, including series MID.", size=1.05);
//   (-8, -45) @TEXT("DH -> buffer; RL -> inverter. Control supply: DVDD / VREFN; body: VSS.", size=1.05);
//   (-8, -48) @TEXT("5% Cp is a user estimate, not extraction.", size=1.05);
//   &DH @WIRE {#XHCTL:1 (-6, 20)};
//   (-6.3, 20) @TEXT("DH", size=1.05, halign="end", valign="middle");
//   &EN @WIRE {#XDH:2 (9, 16)};
//   (8.7, 16) @TEXT("EN", size=1.05, halign="end", valign="middle");
//   &ENB @WIRE {#XDH:3 (9, 13)};
//   (8.7, 13) @TEXT("ENB", size=1.05, halign="end", valign="middle");
//   %t14 = $SUPPLY @ATTACH &VREFP => @PLACE(22, 29);
//   &VREFP @WIRE {#XDH:5 %t14:p};
//   %t15 = $GROUND @ATTACH &VREFN => @PLACE(22, 7);
//   &VREFN @WIRE {#XDH:6 %t15:p};
//   %t16 = $GROUND @ATTACH &VSS => @PLACE(16, 7);
//   &VSS @WIRE {#XDH:7 %t16:p};
//   %t17 = $SUPPLY @ATTACH &DVDD => @PLACE(16, 29);
//   &DVDD @WIRE {#XDH:8 %t17:p};
//   %t18 = $GROUND @ATTACH &VSS => @PLACE(84, 8);
//   &VSS @WIRE {#CPH:2 %t18:p};
//   &VG @WIRE {#MSH:2 (33, 7)};
//   (32.7, 10.2) @TEXT("VG", size=1.05, halign="end", valign="middle");
//   &VIN @WIRE {#MSH:3 (38, 3)};
//   (38, 2.4) @TEXT("VIN", size=1.05, halign="middle", valign="top");
//   &APGATE @WIRE {#MEQ1:2 (47, 7)};
//   (46.7, 10.2) @TEXT("APGATE", size=1.05, halign="end", valign="middle");
//   &VIN @WIRE {#MEQ1:3 (52, 3)};
//   (52, 2.4) @TEXT("VIN", size=1.05, halign="middle", valign="top");
//   &ENB @WIRE {#MSHAREH:2 (61, 7)};
//   (60.7, 10.2) @TEXT("ENB", size=1.05, halign="end", valign="middle");
//   &EQBUS @WIRE {#MSHAREH:3 (66, 3)};
//   (66, 2.4) @TEXT("EQBUS", size=1.05, halign="middle", valign="top");
//   &RL @WIRE {#XLCTL:1 (-6, -18)};
//   (-6.3, -18) @TEXT("RL", size=1.05, halign="end", valign="middle");
//   &EN @WIRE {#XDL:2 (9, -22)};
//   (8.7, -22) @TEXT("EN", size=1.05, halign="end", valign="middle");
//   &ENB @WIRE {#XDL:3 (9, -25)};
//   (8.7, -25) @TEXT("ENB", size=1.05, halign="end", valign="middle");
//   %t28 = $SUPPLY @ATTACH &VREFP => @PLACE(22, -9);
//   &VREFP @WIRE {#XDL:5 %t28:p};
//   %t29 = $GROUND @ATTACH &VREFN => @PLACE(22, -31);
//   &VREFN @WIRE {#XDL:6 %t29:p};
//   %t30 = $GROUND @ATTACH &VSS => @PLACE(16, -31);
//   &VSS @WIRE {#XDL:7 %t30:p};
//   %t31 = $SUPPLY @ATTACH &DVDD => @PLACE(16, -9);
//   &DVDD @WIRE {#XDL:8 %t31:p};
//   %t32 = $GROUND @ATTACH &VSS => @PLACE(84, -30);
//   &VSS @WIRE {#CPL:2 %t32:p};
//   &VG @WIRE {#MSL:2 (33, -31)};
//   (32.7, -27.8) @TEXT("VG", size=1.05, halign="end", valign="middle");
//   &VIN @WIRE {#MSL:3 (38, -35)};
//   (38, -35.6) @TEXT("VIN", size=1.05, halign="middle", valign="top");
//   &APGATE @WIRE {#MEQ2:2 (47, -31)};
//   (46.7, -27.8) @TEXT("APGATE", size=1.05, halign="end", valign="middle");
//   &VIN @WIRE {#MEQ2:3 (52, -35)};
//   (52, -35.6) @TEXT("VIN", size=1.05, halign="middle", valign="top");
//   &ENB @WIRE {#MSHAREL:2 (61, -31)};
//   (60.7, -27.8) @TEXT("ENB", size=1.05, halign="end", valign="middle");
//   &EQBUS @WIRE {#MSHAREL:3 (66, -35)};
//   (66, -35.6) @TEXT("EQBUS", size=1.05, halign="middle", valign="top");
//   $JUNCTION @ATTACH %j2;
//   $JUNCTION @ATTACH %j3;
//   $JUNCTION @ATTACH %j4;
//   $JUNCTION @ATTACH %j5;
//   $JUNCTION @ATTACH %j7;
//   $JUNCTION @ATTACH %j8;
//   $JUNCTION @ATTACH %j9;
//   $JUNCTION @ATTACH %j10;
//   (-8, 44) @TEXT("N4 formal candidate / WIP | weight 5: 18 | matched H/L banks", size=1.4, bold=true, textcolor="#17365d");
//   (-8, 41.6) @TEXT("Drawing only | N bulk = VSS; L = 30 nm. P bulk VREFP: MEQ1, MEQ2", size=1.05, textcolor="#52606d");
// }
ends mq_cdac_bit5

// Reference-rail output driver j=4
subckt mq_cdac_drv4 (HIB EN ENB BP VREFP VREFN VSS DVDD)
// DVDD prelogic: PCOND = NOR(ENB,HIB); NOFF = NAND(EN,HIB).
// Reference-powered final inverters restore GP and GN to VREFP/VREFN.
// Actual current overlap, settling and device stress require measurement.
MPA0 (AP ENB DVDD DVDD) pch_ulvt_mac w=2.4e-07 l=3e-08 nf=1
MPA1 (PCOND HIB AP DVDD) pch_ulvt_mac w=2.4e-07 l=3e-08 nf=1
MNA0 (PCOND ENB VREFN VSS) nch_ulvt_mac w=1.2e-07 l=3e-08 nf=1
MNA1 (PCOND HIB VREFN VSS) nch_ulvt_mac w=1.2e-07 l=3e-08 nf=1
MPB0 (NOFF EN DVDD DVDD) pch_ulvt_mac w=1.2e-07 l=3e-08 nf=1
MPB1 (NOFF HIB DVDD DVDD) pch_ulvt_mac w=1.2e-07 l=3e-08 nf=1
MNB0 (NOFF EN BN VSS) nch_ulvt_mac w=1.2e-07 l=3e-08 nf=1
MNB1 (BN HIB VREFN VSS) nch_ulvt_mac w=1.2e-07 l=3e-08 nf=1
MGPN (GP PCOND VREFN VSS) nch_mac w=2.4e-07 l=3e-08 nf=1
MGPP (GP PCOND VREFP VREFP) pch_mac w=3.6e-07 l=3e-08 nf=1
MGNN (GN NOFF VREFN VSS) nch_mac w=2.4e-07 l=3e-08 nf=1
MGNP (GN NOFF VREFP VREFP) pch_mac w=1.2e-07 l=3e-08 nf=1
MNOUT (BP GN VREFN VSS) nch_mac w=4.5e-07 l=3e-08 nf=1
MPOUT (BP GP VREFP VREFP) pch_mac w=9e-07 l=3e-08 nf=1
// @RNL {
//   {&HIB &EN &ENB &BP &VREFP &VREFN &VSS &DVDD} @REMOVE-FROM $PORT_FILL_SET;
//   &VSS @ADD-TO $GROUND_NET_SET;
//   &VREFN @ADD-TO $GROUND_NET_SET;
//   #MPA0 @PLACE(8, 32) => @ORIENT("R0");
//   #MPA0 @SET-SYMBOL $PMOS;
//   #MPA0 @TEXT("ULVT 0.24u", key="model", size=1.05, dx=1.5, dy=-1);
//   #MPA0 @TEXT("MPA0", key="name", size=1.1, dx=1.5, dy=1);
//   #MPA1 @PLACE(8, 24) => @ORIENT("R0");
//   #MPA1 @SET-SYMBOL $PMOS;
//   #MPA1 @TEXT("ULVT 0.24u", key="model", size=1.05, dx=1.5, dy=-1);
//   #MPA1 @TEXT("MPA1", key="name", size=1.1, dx=1.5, dy=1);
//   #MNA0 @PLACE(0, 8) => @ORIENT("R0");
//   #MNA0 @SET-SYMBOL $NMOS;
//   #MNA0 @TEXT("ULVT 0.12u", key="model", size=1.05, dx=1.5, dy=-1);
//   #MNA0 @TEXT("MNA0", key="name", size=1.1, dx=1.5, dy=1);
//   #MNA1 @PLACE(16, 8) => @ORIENT("R0");
//   #MNA1 @SET-SYMBOL $NMOS;
//   #MNA1 @TEXT("ULVT 0.12u", key="model", size=1.05, dx=1.5, dy=-1);
//   #MNA1 @TEXT("MNA1", key="name", size=1.1, dx=1.5, dy=1);
//   #MPB0 @PLACE(0, -8) => @ORIENT("R0");
//   #MPB0 @SET-SYMBOL $PMOS;
//   #MPB0 @TEXT("ULVT 0.12u", key="model", size=1.05, dx=1.5, dy=-1);
//   #MPB0 @TEXT("MPB0", key="name", size=1.1, dx=1.5, dy=1);
//   #MPB1 @PLACE(16, -8) => @ORIENT("R0");
//   #MPB1 @SET-SYMBOL $PMOS;
//   #MPB1 @TEXT("ULVT 0.12u", key="model", size=1.05, dx=1.5, dy=-1);
//   #MPB1 @TEXT("MPB1", key="name", size=1.1, dx=1.5, dy=1);
//   #MNB0 @PLACE(8, -24) => @ORIENT("R0");
//   #MNB0 @SET-SYMBOL $NMOS;
//   #MNB0 @TEXT("ULVT 0.12u", key="model", size=1.05, dx=1.5, dy=-1);
//   #MNB0 @TEXT("MNB0", key="name", size=1.1, dx=1.5, dy=1);
//   #MNB1 @PLACE(8, -32) => @ORIENT("R0");
//   #MNB1 @SET-SYMBOL $NMOS;
//   #MNB1 @TEXT("ULVT 0.12u", key="model", size=1.05, dx=1.5, dy=-1);
//   #MNB1 @TEXT("MNB1", key="name", size=1.1, dx=1.5, dy=1);
//   #MPOUT @PLACE(76, 18) => @ORIENT("R0");
//   #MPOUT @SET-SYMBOL $PMOS;
//   #MPOUT @TEXT("SVT 0.9u", key="model", size=1.05, dx=1.5, dy=-1);
//   #MPOUT @TEXT("MPOUT", key="name", size=1.1, dx=1.5, dy=1);
//   #MNOUT @PLACE(76, -18) => @ORIENT("R0");
//   #MNOUT @SET-SYMBOL $NMOS;
//   #MNOUT @TEXT("SVT 0.45u", key="model", size=1.05, dx=1.5, dy=-1);
//   #MNOUT @TEXT("MNOUT", key="name", size=1.1, dx=1.5, dy=1);
//   &AP @WIRE {#MPA0:1 #MPA1:3};
//   (10, 28) @TEXT("AP", size=1.05);
//   %j1 = (8, 16);
//   &PCOND @WIRE {#MNA0:1 (0, 16) %j1 (16, 16) #MNA1:1};
//   &PCOND @WIRE {#MPA1:1 %j1};
//   #MGPN @PLACE(43, 9) => @ORIENT("R0");
//   #MGPN @SET-SYMBOL $NMOS;
//   #MGPN @TEXT("SVT 0.24u", key="model", size=1.05, dx=1.5, dy=-1);
//   #MGPN @TEXT("MGPN", key="name", size=1.1, dx=1.5, dy=1);
//   #MGPP @PLACE(43, 23) => @ORIENT("R0");
//   #MGPP @SET-SYMBOL $PMOS;
//   #MGPP @TEXT("SVT 0.36u", key="model", size=1.05, dx=1.5, dy=-1);
//   #MGPP @TEXT("MGPP", key="name", size=1.1, dx=1.5, dy=1);
//   %j2 = (43, 16);
//   %j3 = (38, 16);
//   &GP @WIRE {#MGPN:1 %j2 #MGPP:1};
//   &PCOND @WIRE {#MGPN:2 (38, 9) %j3 (38, 23) #MGPP:2};
//   &PCOND @WIRE {%j1 %j3};
//   &GP @WIRE {%j2 (65, 16) (65, 18) #MPOUT:2};
//   %j4 = (8, -16);
//   &NOFF @WIRE {#MPB0:1 (0, -16) %j4 (16, -16) #MPB1:1};
//   &NOFF @WIRE {#MNB0:1 %j4};
//   &BN @WIRE {#MNB0:3 #MNB1:1};
//   (18, -14) @TEXT("NOFF", size=1.05);
//   #MGNN @PLACE(43, -23) => @ORIENT("R0");
//   #MGNN @SET-SYMBOL $NMOS;
//   #MGNN @TEXT("SVT 0.24u", key="model", size=1.05, dx=1.5, dy=-1);
//   #MGNN @TEXT("MGNN", key="name", size=1.1, dx=1.5, dy=1);
//   #MGNP @PLACE(43, -9) => @ORIENT("R0");
//   #MGNP @SET-SYMBOL $PMOS;
//   #MGNP @TEXT("SVT 0.12u", key="model", size=1.05, dx=1.5, dy=-1);
//   #MGNP @TEXT("MGNP", key="name", size=1.1, dx=1.5, dy=1);
//   %j5 = (43, -16);
//   %j6 = (38, -16);
//   &GN @WIRE {#MGNN:1 %j5 #MGNP:1};
//   &NOFF @WIRE {#MGNN:2 (38, -23) %j6 (38, -9) #MGNP:2};
//   &NOFF @WIRE {%j4 %j6};
//   &GN @WIRE {%j5 (65, -16) (65, -18) #MNOUT:2};
//   %j7 = (76, 0);
//   &BP @WIRE {#MPOUT:1 %j7 #MNOUT:1};
//   &BP @WIRE {%j7 (85, 0)};
//   (85, 1) @TEXT("BP", size=1.05);
//   (-5, 42) @TEXT("NOR: PCOND = ~(ENB | HIB)", size=1.05);
//   (-5, -42) @TEXT("NAND: NOFF = ~(EN & HIB)", size=1.05);
//   (31, 39) @TEXT("Reference gate drivers", size=1.05);
//   (67, 39) @TEXT("Output rail switch", size=1.05);
//   &ENB @WIRE {#MPA0:2 (3, 32)};
//   (2.7, 32) @TEXT("ENB", size=1.05, halign="end", valign="middle");
//   %t9 = $SUPPLY @ATTACH &DVDD => @PLACE(8, 36);
//   &DVDD @WIRE {#MPA0:3 %t9:p};
//   &HIB @WIRE {#MPA1:2 (3, 24)};
//   (2.7, 24) @TEXT("HIB", size=1.05, halign="end", valign="middle");
//   &ENB @WIRE {#MNA0:2 (-5, 8)};
//   (-5.3, 8) @TEXT("ENB", size=1.05, halign="end", valign="middle");
//   %t12 = $GROUND @ATTACH &VREFN => @PLACE(0, 4);
//   &VREFN @WIRE {#MNA0:3 %t12:p};
//   &HIB @WIRE {#MNA1:2 (11, 8)};
//   (10.7, 8) @TEXT("HIB", size=1.05, halign="end", valign="middle");
//   %t14 = $GROUND @ATTACH &VREFN => @PLACE(16, 4);
//   &VREFN @WIRE {#MNA1:3 %t14:p};
//   &EN @WIRE {#MPB0:2 (-5, -8)};
//   (-5.3, -8) @TEXT("EN", size=1.05, halign="end", valign="middle");
//   %t16 = $SUPPLY @ATTACH &DVDD => @PLACE(0, -4);
//   &DVDD @WIRE {#MPB0:3 %t16:p};
//   &HIB @WIRE {#MPB1:2 (11, -8)};
//   (10.7, -8) @TEXT("HIB", size=1.05, halign="end", valign="middle");
//   %t18 = $SUPPLY @ATTACH &DVDD => @PLACE(16, -4);
//   &DVDD @WIRE {#MPB1:3 %t18:p};
//   &EN @WIRE {#MNB0:2 (3, -24)};
//   (2.7, -24) @TEXT("EN", size=1.05, halign="end", valign="middle");
//   &HIB @WIRE {#MNB1:2 (3, -32)};
//   (2.7, -32) @TEXT("HIB", size=1.05, halign="end", valign="middle");
//   %t21 = $GROUND @ATTACH &VREFN => @PLACE(8, -36);
//   &VREFN @WIRE {#MNB1:3 %t21:p};
//   %t22 = $SUPPLY @ATTACH &VREFP => @PLACE(76, 22);
//   &VREFP @WIRE {#MPOUT:3 %t22:p};
//   %t23 = $GROUND @ATTACH &VREFN => @PLACE(76, -22);
//   &VREFN @WIRE {#MNOUT:3 %t23:p};
//   %t24 = $GROUND @ATTACH &VREFN => @PLACE(43, 5);
//   &VREFN @WIRE {#MGPN:3 %t24:p};
//   %t25 = $SUPPLY @ATTACH &VREFP => @PLACE(43, 27);
//   &VREFP @WIRE {#MGPP:3 %t25:p};
//   %t26 = $GROUND @ATTACH &VREFN => @PLACE(43, -27);
//   &VREFN @WIRE {#MGNN:3 %t26:p};
//   %t27 = $SUPPLY @ATTACH &VREFP => @PLACE(43, -5);
//   &VREFP @WIRE {#MGNP:3 %t27:p};
//   $JUNCTION @ATTACH %j1;
//   $JUNCTION @ATTACH %j2;
//   $JUNCTION @ATTACH %j3;
//   $JUNCTION @ATTACH %j4;
//   $JUNCTION @ATTACH %j5;
//   $JUNCTION @ATTACH %j6;
//   $JUNCTION @ATTACH %j7;
//   (-7, 51) @TEXT("N4 formal candidate / WIP | mq_cdac_drv4 | isolated DVDD logic / VREFP output", size=1.4, bold=true, textcolor="#17365d");
//   (-7, 48.6) @TEXT("Drawing only | N bulk = VSS; L = 30 nm. P bulk DVDD: MPA0, MPA1, MPB0, MPB1; VREFP: MGPP, MGNP, MPOUT", size=1.05, textcolor="#52606d");
// }
ends mq_cdac_drv4

// Matched half-capacitor pair j=4
subckt mq_cdac_bit4 (VIN VG DH RL EN ENB TOP VREFP VREFN VSS DVDD EQBUS APGATE)
// CP*: user-specified 5% bottom-plate estimate for every physical MOM unit, not extraction.
// Series tails retain one unit parasitic at MID and one at B.
// APGATE PMOS assist connects each bottom plate to VIN.
// Additional ENB NMOS sharing retains a common EQBUS.
XHCTL (DH HHIB DVDD VREFN VSS) mq_cdac_ctl_h
XLCTL (RL LHIB DVDD VREFN VSS) mq_cdac_ctl_l
XDH (HHIB EN ENB BH VREFP VREFN VSS DVDD) mq_cdac_drv4
CH (TOP BH) cfmom_2t w=5e-08 s=2.4e-07 nr=6 lr=1.69e-06 stm=2 spm=4 multi=5
CPH (BH VSS) capacitor c=2.505725e-16
MSH (BH VG VIN VSS) nch_ulvt_mac w=1.2e-07 l=3e-08 nf=1
XDL (LHIB EN ENB BL VREFP VREFN VSS DVDD) mq_cdac_drv4
CL (TOP BL) cfmom_2t w=5e-08 s=2.4e-07 nr=6 lr=1.69e-06 stm=2 spm=4 multi=5
CPL (BL VSS) capacitor c=2.505725e-16
MSL (BL VG VIN VSS) nch_ulvt_mac w=1.2e-07 l=3e-08 nf=1
MEQ1 (BH APGATE VIN VREFP) pch_ulvt_mac w=1.2e-07 l=3e-08 nf=1
MEQ2 (BL APGATE VIN VREFP) pch_ulvt_mac w=1.2e-07 l=3e-08 nf=1
MSHAREH (BH ENB EQBUS VSS) nch_ulvt_mac w=1.2e-07 l=3e-08 nf=1
MSHAREL (BL ENB EQBUS VSS) nch_ulvt_mac w=1.2e-07 l=3e-08 nf=1
// @RNL {
//   {&VIN &VG &DH &RL &EN &ENB &TOP &VREFP &VREFN &VSS &DVDD &EQBUS &APGATE} @REMOVE-FROM $PORT_FILL_SET;
//   &VSS @ADD-TO $GROUND_NET_SET;
//   &VREFN @ADD-TO $GROUND_NET_SET;
//   #XHCTL @PLACE(0, 20) => @ORIENT("R0");
//   #XDH @PLACE(19, 18) => @ORIENT("R0");
//   &HHIB @WIRE {#XHCTL:2 #XDH:1};
//   %j1 = (115, 20);
//   %j2 = (38, 20);
//   %j3 = (52, 20);
//   %j4 = (66, 20);
//   %j5 = (84, 20);
//   &BH @WIRE {#XDH:4 %j2 %j3 %j4 %j5};
//   #CH @PLACE(100, 20) => @ORIENT("R270");
//   #CH @TEXT("", key="value");
//   #CH @TEXT("", key="name");
//   (100, 22.2) @TEXT("CH", size=1.05);
//   (100, 16.8) @TEXT("5 Cu", size=1.05);
//   &BH @WIRE {%j5 #CH:2};
//   &TOP @WIRE {#CH:1 %j1};
//   #CPH @PLACE(84, 12) => @ORIENT("R0");
//   #CPH @TEXT("", key="value");
//   #CPH @TEXT("", key="name");
//   (86, 13) @TEXT("CPH", size=1.05);
//   (86, 11) @TEXT("0.2506 fF / 5%", size=1.05);
//   &BH @WIRE {%j5 #CPH:1};
//   #MSH @PLACE(38, 7) => @ORIENT("R0");
//   #MSH @SET-SYMBOL $NMOS;
//   #MSH @TEXT("ULVT 0.12u", key="model", size=1.05, dx=1.5, dy=-1);
//   #MSH @TEXT("MSH", key="name", size=1.1, dx=1.5, dy=1);
//   &BH @WIRE {%j2 #MSH:1};
//   #MEQ1 @PLACE(52, 7) => @ORIENT("MX");
//   #MEQ1 @SET-SYMBOL $PMOS;
//   #MEQ1 @TEXT("ULVT 0.12u", key="model", size=1.05, dx=1.5, dy=-1);
//   #MEQ1 @TEXT("MEQ1", key="name", size=1.1, dx=1.5, dy=1);
//   &BH @WIRE {%j3 #MEQ1:1};
//   #MSHAREH @PLACE(66, 7) => @ORIENT("R0");
//   #MSHAREH @SET-SYMBOL $NMOS;
//   #MSHAREH @TEXT("ULVT 0.12u", key="model", size=1.05, dx=1.5, dy=-1);
//   #MSHAREH @TEXT("MSHAREH", key="name", size=1.1, dx=1.5, dy=1);
//   &BH @WIRE {%j4 #MSHAREH:1};
//   (-8, 35) @TEXT("High bank", size=1.05);
//   #XLCTL @PLACE(0, -18) => @ORIENT("R0");
//   #XDL @PLACE(19, -20) => @ORIENT("R0");
//   &LHIB @WIRE {#XLCTL:2 #XDL:1};
//   %j6 = (115, -18);
//   %j7 = (38, -18);
//   %j8 = (52, -18);
//   %j9 = (66, -18);
//   %j10 = (84, -18);
//   &BL @WIRE {#XDL:4 %j7 %j8 %j9 %j10};
//   #CL @PLACE(100, -18) => @ORIENT("R270");
//   #CL @TEXT("", key="value");
//   #CL @TEXT("", key="name");
//   (100, -15.8) @TEXT("CL", size=1.05);
//   (100, -21.2) @TEXT("5 Cu", size=1.05);
//   &BL @WIRE {%j10 #CL:2};
//   &TOP @WIRE {#CL:1 %j6};
//   #CPL @PLACE(84, -26) => @ORIENT("R0");
//   #CPL @TEXT("", key="value");
//   #CPL @TEXT("", key="name");
//   (86, -25) @TEXT("CPL", size=1.05);
//   (86, -27) @TEXT("0.2506 fF / 5%", size=1.05);
//   &BL @WIRE {%j10 #CPL:1};
//   #MSL @PLACE(38, -31) => @ORIENT("R0");
//   #MSL @SET-SYMBOL $NMOS;
//   #MSL @TEXT("ULVT 0.12u", key="model", size=1.05, dx=1.5, dy=-1);
//   #MSL @TEXT("MSL", key="name", size=1.1, dx=1.5, dy=1);
//   &BL @WIRE {%j7 #MSL:1};
//   #MEQ2 @PLACE(52, -31) => @ORIENT("MX");
//   #MEQ2 @SET-SYMBOL $PMOS;
//   #MEQ2 @TEXT("ULVT 0.12u", key="model", size=1.05, dx=1.5, dy=-1);
//   #MEQ2 @TEXT("MEQ2", key="name", size=1.1, dx=1.5, dy=1);
//   &BL @WIRE {%j8 #MEQ2:1};
//   #MSHAREL @PLACE(66, -31) => @ORIENT("R0");
//   #MSHAREL @SET-SYMBOL $NMOS;
//   #MSHAREL @TEXT("ULVT 0.12u", key="model", size=1.05, dx=1.5, dy=-1);
//   #MSHAREL @TEXT("MSHAREL", key="name", size=1.1, dx=1.5, dy=1);
//   &BL @WIRE {%j9 #MSHAREL:1};
//   (-8, -3) @TEXT("Low bank", size=1.05);
//   &TOP @WIRE {%j1 %j6};
//   (116, -3) @TEXT("TOP", size=1.05);
//   (-8, -42) @TEXT("Cu = 1.00229 fF. Cp = 5% of every physical MOM, including series MID.", size=1.05);
//   (-8, -45) @TEXT("DH -> buffer; RL -> inverter. Control supply: DVDD / VREFN; body: VSS.", size=1.05);
//   (-8, -48) @TEXT("5% Cp is a user estimate, not extraction.", size=1.05);
//   &DH @WIRE {#XHCTL:1 (-6, 20)};
//   (-6.3, 20) @TEXT("DH", size=1.05, halign="end", valign="middle");
//   &EN @WIRE {#XDH:2 (9, 16)};
//   (8.7, 16) @TEXT("EN", size=1.05, halign="end", valign="middle");
//   &ENB @WIRE {#XDH:3 (9, 13)};
//   (8.7, 13) @TEXT("ENB", size=1.05, halign="end", valign="middle");
//   %t14 = $SUPPLY @ATTACH &VREFP => @PLACE(22, 29);
//   &VREFP @WIRE {#XDH:5 %t14:p};
//   %t15 = $GROUND @ATTACH &VREFN => @PLACE(22, 7);
//   &VREFN @WIRE {#XDH:6 %t15:p};
//   %t16 = $GROUND @ATTACH &VSS => @PLACE(16, 7);
//   &VSS @WIRE {#XDH:7 %t16:p};
//   %t17 = $SUPPLY @ATTACH &DVDD => @PLACE(16, 29);
//   &DVDD @WIRE {#XDH:8 %t17:p};
//   %t18 = $GROUND @ATTACH &VSS => @PLACE(84, 8);
//   &VSS @WIRE {#CPH:2 %t18:p};
//   &VG @WIRE {#MSH:2 (33, 7)};
//   (32.7, 10.2) @TEXT("VG", size=1.05, halign="end", valign="middle");
//   &VIN @WIRE {#MSH:3 (38, 3)};
//   (38, 2.4) @TEXT("VIN", size=1.05, halign="middle", valign="top");
//   &APGATE @WIRE {#MEQ1:2 (47, 7)};
//   (46.7, 10.2) @TEXT("APGATE", size=1.05, halign="end", valign="middle");
//   &VIN @WIRE {#MEQ1:3 (52, 3)};
//   (52, 2.4) @TEXT("VIN", size=1.05, halign="middle", valign="top");
//   &ENB @WIRE {#MSHAREH:2 (61, 7)};
//   (60.7, 10.2) @TEXT("ENB", size=1.05, halign="end", valign="middle");
//   &EQBUS @WIRE {#MSHAREH:3 (66, 3)};
//   (66, 2.4) @TEXT("EQBUS", size=1.05, halign="middle", valign="top");
//   &RL @WIRE {#XLCTL:1 (-6, -18)};
//   (-6.3, -18) @TEXT("RL", size=1.05, halign="end", valign="middle");
//   &EN @WIRE {#XDL:2 (9, -22)};
//   (8.7, -22) @TEXT("EN", size=1.05, halign="end", valign="middle");
//   &ENB @WIRE {#XDL:3 (9, -25)};
//   (8.7, -25) @TEXT("ENB", size=1.05, halign="end", valign="middle");
//   %t28 = $SUPPLY @ATTACH &VREFP => @PLACE(22, -9);
//   &VREFP @WIRE {#XDL:5 %t28:p};
//   %t29 = $GROUND @ATTACH &VREFN => @PLACE(22, -31);
//   &VREFN @WIRE {#XDL:6 %t29:p};
//   %t30 = $GROUND @ATTACH &VSS => @PLACE(16, -31);
//   &VSS @WIRE {#XDL:7 %t30:p};
//   %t31 = $SUPPLY @ATTACH &DVDD => @PLACE(16, -9);
//   &DVDD @WIRE {#XDL:8 %t31:p};
//   %t32 = $GROUND @ATTACH &VSS => @PLACE(84, -30);
//   &VSS @WIRE {#CPL:2 %t32:p};
//   &VG @WIRE {#MSL:2 (33, -31)};
//   (32.7, -27.8) @TEXT("VG", size=1.05, halign="end", valign="middle");
//   &VIN @WIRE {#MSL:3 (38, -35)};
//   (38, -35.6) @TEXT("VIN", size=1.05, halign="middle", valign="top");
//   &APGATE @WIRE {#MEQ2:2 (47, -31)};
//   (46.7, -27.8) @TEXT("APGATE", size=1.05, halign="end", valign="middle");
//   &VIN @WIRE {#MEQ2:3 (52, -35)};
//   (52, -35.6) @TEXT("VIN", size=1.05, halign="middle", valign="top");
//   &ENB @WIRE {#MSHAREL:2 (61, -31)};
//   (60.7, -27.8) @TEXT("ENB", size=1.05, halign="end", valign="middle");
//   &EQBUS @WIRE {#MSHAREL:3 (66, -35)};
//   (66, -35.6) @TEXT("EQBUS", size=1.05, halign="middle", valign="top");
//   $JUNCTION @ATTACH %j2;
//   $JUNCTION @ATTACH %j3;
//   $JUNCTION @ATTACH %j4;
//   $JUNCTION @ATTACH %j5;
//   $JUNCTION @ATTACH %j7;
//   $JUNCTION @ATTACH %j8;
//   $JUNCTION @ATTACH %j9;
//   $JUNCTION @ATTACH %j10;
//   (-8, 44) @TEXT("N4 formal candidate / WIP | weight 4: 10 | matched H/L banks", size=1.4, bold=true, textcolor="#17365d");
//   (-8, 41.6) @TEXT("Drawing only | N bulk = VSS; L = 30 nm. P bulk VREFP: MEQ1, MEQ2", size=1.05, textcolor="#52606d");
// }
ends mq_cdac_bit4

// Reference-rail output driver j=3
subckt mq_cdac_drv3 (HIB EN ENB BP VREFP VREFN VSS DVDD)
// DVDD prelogic: PCOND = NOR(ENB,HIB); NOFF = NAND(EN,HIB).
// Reference-powered final inverters restore GP and GN to VREFP/VREFN.
// Actual current overlap, settling and device stress require measurement.
MPA0 (AP ENB DVDD DVDD) pch_ulvt_mac w=2.4e-07 l=3e-08 nf=1
MPA1 (PCOND HIB AP DVDD) pch_ulvt_mac w=2.4e-07 l=3e-08 nf=1
MNA0 (PCOND ENB VREFN VSS) nch_ulvt_mac w=1.2e-07 l=3e-08 nf=1
MNA1 (PCOND HIB VREFN VSS) nch_ulvt_mac w=1.2e-07 l=3e-08 nf=1
MPB0 (NOFF EN DVDD DVDD) pch_ulvt_mac w=1.2e-07 l=3e-08 nf=1
MPB1 (NOFF HIB DVDD DVDD) pch_ulvt_mac w=1.2e-07 l=3e-08 nf=1
MNB0 (NOFF EN BN VSS) nch_ulvt_mac w=1.2e-07 l=3e-08 nf=1
MNB1 (BN HIB VREFN VSS) nch_ulvt_mac w=1.2e-07 l=3e-08 nf=1
MGPN (GP PCOND VREFN VSS) nch_mac w=2.4e-07 l=3e-08 nf=1
MGPP (GP PCOND VREFP VREFP) pch_mac w=3.6e-07 l=3e-08 nf=1
MGNN (GN NOFF VREFN VSS) nch_mac w=2.4e-07 l=3e-08 nf=1
MGNP (GN NOFF VREFP VREFP) pch_mac w=1.2e-07 l=3e-08 nf=1
MNOUT (BP GN VREFN VSS) nch_mac w=4.5e-07 l=3e-08 nf=1
MPOUT (BP GP VREFP VREFP) pch_mac w=9e-07 l=3e-08 nf=1
// @RNL {
//   {&HIB &EN &ENB &BP &VREFP &VREFN &VSS &DVDD} @REMOVE-FROM $PORT_FILL_SET;
//   &VSS @ADD-TO $GROUND_NET_SET;
//   &VREFN @ADD-TO $GROUND_NET_SET;
//   #MPA0 @PLACE(8, 32) => @ORIENT("R0");
//   #MPA0 @SET-SYMBOL $PMOS;
//   #MPA0 @TEXT("ULVT 0.24u", key="model", size=1.05, dx=1.5, dy=-1);
//   #MPA0 @TEXT("MPA0", key="name", size=1.1, dx=1.5, dy=1);
//   #MPA1 @PLACE(8, 24) => @ORIENT("R0");
//   #MPA1 @SET-SYMBOL $PMOS;
//   #MPA1 @TEXT("ULVT 0.24u", key="model", size=1.05, dx=1.5, dy=-1);
//   #MPA1 @TEXT("MPA1", key="name", size=1.1, dx=1.5, dy=1);
//   #MNA0 @PLACE(0, 8) => @ORIENT("R0");
//   #MNA0 @SET-SYMBOL $NMOS;
//   #MNA0 @TEXT("ULVT 0.12u", key="model", size=1.05, dx=1.5, dy=-1);
//   #MNA0 @TEXT("MNA0", key="name", size=1.1, dx=1.5, dy=1);
//   #MNA1 @PLACE(16, 8) => @ORIENT("R0");
//   #MNA1 @SET-SYMBOL $NMOS;
//   #MNA1 @TEXT("ULVT 0.12u", key="model", size=1.05, dx=1.5, dy=-1);
//   #MNA1 @TEXT("MNA1", key="name", size=1.1, dx=1.5, dy=1);
//   #MPB0 @PLACE(0, -8) => @ORIENT("R0");
//   #MPB0 @SET-SYMBOL $PMOS;
//   #MPB0 @TEXT("ULVT 0.12u", key="model", size=1.05, dx=1.5, dy=-1);
//   #MPB0 @TEXT("MPB0", key="name", size=1.1, dx=1.5, dy=1);
//   #MPB1 @PLACE(16, -8) => @ORIENT("R0");
//   #MPB1 @SET-SYMBOL $PMOS;
//   #MPB1 @TEXT("ULVT 0.12u", key="model", size=1.05, dx=1.5, dy=-1);
//   #MPB1 @TEXT("MPB1", key="name", size=1.1, dx=1.5, dy=1);
//   #MNB0 @PLACE(8, -24) => @ORIENT("R0");
//   #MNB0 @SET-SYMBOL $NMOS;
//   #MNB0 @TEXT("ULVT 0.12u", key="model", size=1.05, dx=1.5, dy=-1);
//   #MNB0 @TEXT("MNB0", key="name", size=1.1, dx=1.5, dy=1);
//   #MNB1 @PLACE(8, -32) => @ORIENT("R0");
//   #MNB1 @SET-SYMBOL $NMOS;
//   #MNB1 @TEXT("ULVT 0.12u", key="model", size=1.05, dx=1.5, dy=-1);
//   #MNB1 @TEXT("MNB1", key="name", size=1.1, dx=1.5, dy=1);
//   #MPOUT @PLACE(76, 18) => @ORIENT("R0");
//   #MPOUT @SET-SYMBOL $PMOS;
//   #MPOUT @TEXT("SVT 0.9u", key="model", size=1.05, dx=1.5, dy=-1);
//   #MPOUT @TEXT("MPOUT", key="name", size=1.1, dx=1.5, dy=1);
//   #MNOUT @PLACE(76, -18) => @ORIENT("R0");
//   #MNOUT @SET-SYMBOL $NMOS;
//   #MNOUT @TEXT("SVT 0.45u", key="model", size=1.05, dx=1.5, dy=-1);
//   #MNOUT @TEXT("MNOUT", key="name", size=1.1, dx=1.5, dy=1);
//   &AP @WIRE {#MPA0:1 #MPA1:3};
//   (10, 28) @TEXT("AP", size=1.05);
//   %j1 = (8, 16);
//   &PCOND @WIRE {#MNA0:1 (0, 16) %j1 (16, 16) #MNA1:1};
//   &PCOND @WIRE {#MPA1:1 %j1};
//   #MGPN @PLACE(43, 9) => @ORIENT("R0");
//   #MGPN @SET-SYMBOL $NMOS;
//   #MGPN @TEXT("SVT 0.24u", key="model", size=1.05, dx=1.5, dy=-1);
//   #MGPN @TEXT("MGPN", key="name", size=1.1, dx=1.5, dy=1);
//   #MGPP @PLACE(43, 23) => @ORIENT("R0");
//   #MGPP @SET-SYMBOL $PMOS;
//   #MGPP @TEXT("SVT 0.36u", key="model", size=1.05, dx=1.5, dy=-1);
//   #MGPP @TEXT("MGPP", key="name", size=1.1, dx=1.5, dy=1);
//   %j2 = (43, 16);
//   %j3 = (38, 16);
//   &GP @WIRE {#MGPN:1 %j2 #MGPP:1};
//   &PCOND @WIRE {#MGPN:2 (38, 9) %j3 (38, 23) #MGPP:2};
//   &PCOND @WIRE {%j1 %j3};
//   &GP @WIRE {%j2 (65, 16) (65, 18) #MPOUT:2};
//   %j4 = (8, -16);
//   &NOFF @WIRE {#MPB0:1 (0, -16) %j4 (16, -16) #MPB1:1};
//   &NOFF @WIRE {#MNB0:1 %j4};
//   &BN @WIRE {#MNB0:3 #MNB1:1};
//   (18, -14) @TEXT("NOFF", size=1.05);
//   #MGNN @PLACE(43, -23) => @ORIENT("R0");
//   #MGNN @SET-SYMBOL $NMOS;
//   #MGNN @TEXT("SVT 0.24u", key="model", size=1.05, dx=1.5, dy=-1);
//   #MGNN @TEXT("MGNN", key="name", size=1.1, dx=1.5, dy=1);
//   #MGNP @PLACE(43, -9) => @ORIENT("R0");
//   #MGNP @SET-SYMBOL $PMOS;
//   #MGNP @TEXT("SVT 0.12u", key="model", size=1.05, dx=1.5, dy=-1);
//   #MGNP @TEXT("MGNP", key="name", size=1.1, dx=1.5, dy=1);
//   %j5 = (43, -16);
//   %j6 = (38, -16);
//   &GN @WIRE {#MGNN:1 %j5 #MGNP:1};
//   &NOFF @WIRE {#MGNN:2 (38, -23) %j6 (38, -9) #MGNP:2};
//   &NOFF @WIRE {%j4 %j6};
//   &GN @WIRE {%j5 (65, -16) (65, -18) #MNOUT:2};
//   %j7 = (76, 0);
//   &BP @WIRE {#MPOUT:1 %j7 #MNOUT:1};
//   &BP @WIRE {%j7 (85, 0)};
//   (85, 1) @TEXT("BP", size=1.05);
//   (-5, 42) @TEXT("NOR: PCOND = ~(ENB | HIB)", size=1.05);
//   (-5, -42) @TEXT("NAND: NOFF = ~(EN & HIB)", size=1.05);
//   (31, 39) @TEXT("Reference gate drivers", size=1.05);
//   (67, 39) @TEXT("Output rail switch", size=1.05);
//   &ENB @WIRE {#MPA0:2 (3, 32)};
//   (2.7, 32) @TEXT("ENB", size=1.05, halign="end", valign="middle");
//   %t9 = $SUPPLY @ATTACH &DVDD => @PLACE(8, 36);
//   &DVDD @WIRE {#MPA0:3 %t9:p};
//   &HIB @WIRE {#MPA1:2 (3, 24)};
//   (2.7, 24) @TEXT("HIB", size=1.05, halign="end", valign="middle");
//   &ENB @WIRE {#MNA0:2 (-5, 8)};
//   (-5.3, 8) @TEXT("ENB", size=1.05, halign="end", valign="middle");
//   %t12 = $GROUND @ATTACH &VREFN => @PLACE(0, 4);
//   &VREFN @WIRE {#MNA0:3 %t12:p};
//   &HIB @WIRE {#MNA1:2 (11, 8)};
//   (10.7, 8) @TEXT("HIB", size=1.05, halign="end", valign="middle");
//   %t14 = $GROUND @ATTACH &VREFN => @PLACE(16, 4);
//   &VREFN @WIRE {#MNA1:3 %t14:p};
//   &EN @WIRE {#MPB0:2 (-5, -8)};
//   (-5.3, -8) @TEXT("EN", size=1.05, halign="end", valign="middle");
//   %t16 = $SUPPLY @ATTACH &DVDD => @PLACE(0, -4);
//   &DVDD @WIRE {#MPB0:3 %t16:p};
//   &HIB @WIRE {#MPB1:2 (11, -8)};
//   (10.7, -8) @TEXT("HIB", size=1.05, halign="end", valign="middle");
//   %t18 = $SUPPLY @ATTACH &DVDD => @PLACE(16, -4);
//   &DVDD @WIRE {#MPB1:3 %t18:p};
//   &EN @WIRE {#MNB0:2 (3, -24)};
//   (2.7, -24) @TEXT("EN", size=1.05, halign="end", valign="middle");
//   &HIB @WIRE {#MNB1:2 (3, -32)};
//   (2.7, -32) @TEXT("HIB", size=1.05, halign="end", valign="middle");
//   %t21 = $GROUND @ATTACH &VREFN => @PLACE(8, -36);
//   &VREFN @WIRE {#MNB1:3 %t21:p};
//   %t22 = $SUPPLY @ATTACH &VREFP => @PLACE(76, 22);
//   &VREFP @WIRE {#MPOUT:3 %t22:p};
//   %t23 = $GROUND @ATTACH &VREFN => @PLACE(76, -22);
//   &VREFN @WIRE {#MNOUT:3 %t23:p};
//   %t24 = $GROUND @ATTACH &VREFN => @PLACE(43, 5);
//   &VREFN @WIRE {#MGPN:3 %t24:p};
//   %t25 = $SUPPLY @ATTACH &VREFP => @PLACE(43, 27);
//   &VREFP @WIRE {#MGPP:3 %t25:p};
//   %t26 = $GROUND @ATTACH &VREFN => @PLACE(43, -27);
//   &VREFN @WIRE {#MGNN:3 %t26:p};
//   %t27 = $SUPPLY @ATTACH &VREFP => @PLACE(43, -5);
//   &VREFP @WIRE {#MGNP:3 %t27:p};
//   $JUNCTION @ATTACH %j1;
//   $JUNCTION @ATTACH %j2;
//   $JUNCTION @ATTACH %j3;
//   $JUNCTION @ATTACH %j4;
//   $JUNCTION @ATTACH %j5;
//   $JUNCTION @ATTACH %j6;
//   $JUNCTION @ATTACH %j7;
//   (-7, 51) @TEXT("N4 formal candidate / WIP | mq_cdac_drv3 | isolated DVDD logic / VREFP output", size=1.4, bold=true, textcolor="#17365d");
//   (-7, 48.6) @TEXT("Drawing only | N bulk = VSS; L = 30 nm. P bulk DVDD: MPA0, MPA1, MPB0, MPB1; VREFP: MGPP, MGNP, MPOUT", size=1.05, textcolor="#52606d");
// }
ends mq_cdac_drv3

// Matched half-capacitor pair j=3
subckt mq_cdac_bit3 (VIN VG DH RL EN ENB TOP VREFP VREFN VSS DVDD EQBUS APGATE)
// CP*: user-specified 5% bottom-plate estimate for every physical MOM unit, not extraction.
// Series tails retain one unit parasitic at MID and one at B.
// APGATE PMOS assist connects each bottom plate to VIN.
// Additional ENB NMOS sharing retains a common EQBUS.
XHCTL (DH HHIB DVDD VREFN VSS) mq_cdac_ctl_h
XLCTL (RL LHIB DVDD VREFN VSS) mq_cdac_ctl_l
XDH (HHIB EN ENB BH VREFP VREFN VSS DVDD) mq_cdac_drv3
CH (TOP BH) cfmom_2t w=5e-08 s=2.4e-07 nr=6 lr=1.69e-06 stm=2 spm=4 multi=3
CPH (BH VSS) capacitor c=1.503435e-16
MSH (BH VG VIN VSS) nch_ulvt_mac w=1.2e-07 l=3e-08 nf=1
XDL (LHIB EN ENB BL VREFP VREFN VSS DVDD) mq_cdac_drv3
CL (TOP BL) cfmom_2t w=5e-08 s=2.4e-07 nr=6 lr=1.69e-06 stm=2 spm=4 multi=3
CPL (BL VSS) capacitor c=1.503435e-16
MSL (BL VG VIN VSS) nch_ulvt_mac w=1.2e-07 l=3e-08 nf=1
MEQ1 (BH APGATE VIN VREFP) pch_ulvt_mac w=1.2e-07 l=3e-08 nf=1
MEQ2 (BL APGATE VIN VREFP) pch_ulvt_mac w=1.2e-07 l=3e-08 nf=1
MSHAREH (BH ENB EQBUS VSS) nch_ulvt_mac w=1.2e-07 l=3e-08 nf=1
MSHAREL (BL ENB EQBUS VSS) nch_ulvt_mac w=1.2e-07 l=3e-08 nf=1
// @RNL {
//   {&VIN &VG &DH &RL &EN &ENB &TOP &VREFP &VREFN &VSS &DVDD &EQBUS &APGATE} @REMOVE-FROM $PORT_FILL_SET;
//   &VSS @ADD-TO $GROUND_NET_SET;
//   &VREFN @ADD-TO $GROUND_NET_SET;
//   #XHCTL @PLACE(0, 20) => @ORIENT("R0");
//   #XDH @PLACE(19, 18) => @ORIENT("R0");
//   &HHIB @WIRE {#XHCTL:2 #XDH:1};
//   %j1 = (115, 20);
//   %j2 = (38, 20);
//   %j3 = (52, 20);
//   %j4 = (66, 20);
//   %j5 = (84, 20);
//   &BH @WIRE {#XDH:4 %j2 %j3 %j4 %j5};
//   #CH @PLACE(100, 20) => @ORIENT("R270");
//   #CH @TEXT("", key="value");
//   #CH @TEXT("", key="name");
//   (100, 22.2) @TEXT("CH", size=1.05);
//   (100, 16.8) @TEXT("3 Cu", size=1.05);
//   &BH @WIRE {%j5 #CH:2};
//   &TOP @WIRE {#CH:1 %j1};
//   #CPH @PLACE(84, 12) => @ORIENT("R0");
//   #CPH @TEXT("", key="value");
//   #CPH @TEXT("", key="name");
//   (86, 13) @TEXT("CPH", size=1.05);
//   (86, 11) @TEXT("0.1503 fF / 5%", size=1.05);
//   &BH @WIRE {%j5 #CPH:1};
//   #MSH @PLACE(38, 7) => @ORIENT("R0");
//   #MSH @SET-SYMBOL $NMOS;
//   #MSH @TEXT("ULVT 0.12u", key="model", size=1.05, dx=1.5, dy=-1);
//   #MSH @TEXT("MSH", key="name", size=1.1, dx=1.5, dy=1);
//   &BH @WIRE {%j2 #MSH:1};
//   #MEQ1 @PLACE(52, 7) => @ORIENT("MX");
//   #MEQ1 @SET-SYMBOL $PMOS;
//   #MEQ1 @TEXT("ULVT 0.12u", key="model", size=1.05, dx=1.5, dy=-1);
//   #MEQ1 @TEXT("MEQ1", key="name", size=1.1, dx=1.5, dy=1);
//   &BH @WIRE {%j3 #MEQ1:1};
//   #MSHAREH @PLACE(66, 7) => @ORIENT("R0");
//   #MSHAREH @SET-SYMBOL $NMOS;
//   #MSHAREH @TEXT("ULVT 0.12u", key="model", size=1.05, dx=1.5, dy=-1);
//   #MSHAREH @TEXT("MSHAREH", key="name", size=1.1, dx=1.5, dy=1);
//   &BH @WIRE {%j4 #MSHAREH:1};
//   (-8, 35) @TEXT("High bank", size=1.05);
//   #XLCTL @PLACE(0, -18) => @ORIENT("R0");
//   #XDL @PLACE(19, -20) => @ORIENT("R0");
//   &LHIB @WIRE {#XLCTL:2 #XDL:1};
//   %j6 = (115, -18);
//   %j7 = (38, -18);
//   %j8 = (52, -18);
//   %j9 = (66, -18);
//   %j10 = (84, -18);
//   &BL @WIRE {#XDL:4 %j7 %j8 %j9 %j10};
//   #CL @PLACE(100, -18) => @ORIENT("R270");
//   #CL @TEXT("", key="value");
//   #CL @TEXT("", key="name");
//   (100, -15.8) @TEXT("CL", size=1.05);
//   (100, -21.2) @TEXT("3 Cu", size=1.05);
//   &BL @WIRE {%j10 #CL:2};
//   &TOP @WIRE {#CL:1 %j6};
//   #CPL @PLACE(84, -26) => @ORIENT("R0");
//   #CPL @TEXT("", key="value");
//   #CPL @TEXT("", key="name");
//   (86, -25) @TEXT("CPL", size=1.05);
//   (86, -27) @TEXT("0.1503 fF / 5%", size=1.05);
//   &BL @WIRE {%j10 #CPL:1};
//   #MSL @PLACE(38, -31) => @ORIENT("R0");
//   #MSL @SET-SYMBOL $NMOS;
//   #MSL @TEXT("ULVT 0.12u", key="model", size=1.05, dx=1.5, dy=-1);
//   #MSL @TEXT("MSL", key="name", size=1.1, dx=1.5, dy=1);
//   &BL @WIRE {%j7 #MSL:1};
//   #MEQ2 @PLACE(52, -31) => @ORIENT("MX");
//   #MEQ2 @SET-SYMBOL $PMOS;
//   #MEQ2 @TEXT("ULVT 0.12u", key="model", size=1.05, dx=1.5, dy=-1);
//   #MEQ2 @TEXT("MEQ2", key="name", size=1.1, dx=1.5, dy=1);
//   &BL @WIRE {%j8 #MEQ2:1};
//   #MSHAREL @PLACE(66, -31) => @ORIENT("R0");
//   #MSHAREL @SET-SYMBOL $NMOS;
//   #MSHAREL @TEXT("ULVT 0.12u", key="model", size=1.05, dx=1.5, dy=-1);
//   #MSHAREL @TEXT("MSHAREL", key="name", size=1.1, dx=1.5, dy=1);
//   &BL @WIRE {%j9 #MSHAREL:1};
//   (-8, -3) @TEXT("Low bank", size=1.05);
//   &TOP @WIRE {%j1 %j6};
//   (116, -3) @TEXT("TOP", size=1.05);
//   (-8, -42) @TEXT("Cu = 1.00229 fF. Cp = 5% of every physical MOM, including series MID.", size=1.05);
//   (-8, -45) @TEXT("DH -> buffer; RL -> inverter. Control supply: DVDD / VREFN; body: VSS.", size=1.05);
//   (-8, -48) @TEXT("5% Cp is a user estimate, not extraction.", size=1.05);
//   &DH @WIRE {#XHCTL:1 (-6, 20)};
//   (-6.3, 20) @TEXT("DH", size=1.05, halign="end", valign="middle");
//   &EN @WIRE {#XDH:2 (9, 16)};
//   (8.7, 16) @TEXT("EN", size=1.05, halign="end", valign="middle");
//   &ENB @WIRE {#XDH:3 (9, 13)};
//   (8.7, 13) @TEXT("ENB", size=1.05, halign="end", valign="middle");
//   %t14 = $SUPPLY @ATTACH &VREFP => @PLACE(22, 29);
//   &VREFP @WIRE {#XDH:5 %t14:p};
//   %t15 = $GROUND @ATTACH &VREFN => @PLACE(22, 7);
//   &VREFN @WIRE {#XDH:6 %t15:p};
//   %t16 = $GROUND @ATTACH &VSS => @PLACE(16, 7);
//   &VSS @WIRE {#XDH:7 %t16:p};
//   %t17 = $SUPPLY @ATTACH &DVDD => @PLACE(16, 29);
//   &DVDD @WIRE {#XDH:8 %t17:p};
//   %t18 = $GROUND @ATTACH &VSS => @PLACE(84, 8);
//   &VSS @WIRE {#CPH:2 %t18:p};
//   &VG @WIRE {#MSH:2 (33, 7)};
//   (32.7, 10.2) @TEXT("VG", size=1.05, halign="end", valign="middle");
//   &VIN @WIRE {#MSH:3 (38, 3)};
//   (38, 2.4) @TEXT("VIN", size=1.05, halign="middle", valign="top");
//   &APGATE @WIRE {#MEQ1:2 (47, 7)};
//   (46.7, 10.2) @TEXT("APGATE", size=1.05, halign="end", valign="middle");
//   &VIN @WIRE {#MEQ1:3 (52, 3)};
//   (52, 2.4) @TEXT("VIN", size=1.05, halign="middle", valign="top");
//   &ENB @WIRE {#MSHAREH:2 (61, 7)};
//   (60.7, 10.2) @TEXT("ENB", size=1.05, halign="end", valign="middle");
//   &EQBUS @WIRE {#MSHAREH:3 (66, 3)};
//   (66, 2.4) @TEXT("EQBUS", size=1.05, halign="middle", valign="top");
//   &RL @WIRE {#XLCTL:1 (-6, -18)};
//   (-6.3, -18) @TEXT("RL", size=1.05, halign="end", valign="middle");
//   &EN @WIRE {#XDL:2 (9, -22)};
//   (8.7, -22) @TEXT("EN", size=1.05, halign="end", valign="middle");
//   &ENB @WIRE {#XDL:3 (9, -25)};
//   (8.7, -25) @TEXT("ENB", size=1.05, halign="end", valign="middle");
//   %t28 = $SUPPLY @ATTACH &VREFP => @PLACE(22, -9);
//   &VREFP @WIRE {#XDL:5 %t28:p};
//   %t29 = $GROUND @ATTACH &VREFN => @PLACE(22, -31);
//   &VREFN @WIRE {#XDL:6 %t29:p};
//   %t30 = $GROUND @ATTACH &VSS => @PLACE(16, -31);
//   &VSS @WIRE {#XDL:7 %t30:p};
//   %t31 = $SUPPLY @ATTACH &DVDD => @PLACE(16, -9);
//   &DVDD @WIRE {#XDL:8 %t31:p};
//   %t32 = $GROUND @ATTACH &VSS => @PLACE(84, -30);
//   &VSS @WIRE {#CPL:2 %t32:p};
//   &VG @WIRE {#MSL:2 (33, -31)};
//   (32.7, -27.8) @TEXT("VG", size=1.05, halign="end", valign="middle");
//   &VIN @WIRE {#MSL:3 (38, -35)};
//   (38, -35.6) @TEXT("VIN", size=1.05, halign="middle", valign="top");
//   &APGATE @WIRE {#MEQ2:2 (47, -31)};
//   (46.7, -27.8) @TEXT("APGATE", size=1.05, halign="end", valign="middle");
//   &VIN @WIRE {#MEQ2:3 (52, -35)};
//   (52, -35.6) @TEXT("VIN", size=1.05, halign="middle", valign="top");
//   &ENB @WIRE {#MSHAREL:2 (61, -31)};
//   (60.7, -27.8) @TEXT("ENB", size=1.05, halign="end", valign="middle");
//   &EQBUS @WIRE {#MSHAREL:3 (66, -35)};
//   (66, -35.6) @TEXT("EQBUS", size=1.05, halign="middle", valign="top");
//   $JUNCTION @ATTACH %j2;
//   $JUNCTION @ATTACH %j3;
//   $JUNCTION @ATTACH %j4;
//   $JUNCTION @ATTACH %j5;
//   $JUNCTION @ATTACH %j7;
//   $JUNCTION @ATTACH %j8;
//   $JUNCTION @ATTACH %j9;
//   $JUNCTION @ATTACH %j10;
//   (-8, 44) @TEXT("N4 formal candidate / WIP | weight 3: 6 | matched H/L banks", size=1.4, bold=true, textcolor="#17365d");
//   (-8, 41.6) @TEXT("Drawing only | N bulk = VSS; L = 30 nm. P bulk VREFP: MEQ1, MEQ2", size=1.05, textcolor="#52606d");
// }
ends mq_cdac_bit3

// Reference-rail output driver j=2
subckt mq_cdac_drv2 (HIB EN ENB BP VREFP VREFN VSS DVDD)
// DVDD prelogic: PCOND = NOR(ENB,HIB); NOFF = NAND(EN,HIB).
// Reference-powered final inverters restore GP and GN to VREFP/VREFN.
// Actual current overlap, settling and device stress require measurement.
MPA0 (AP ENB DVDD DVDD) pch_ulvt_mac w=2.4e-07 l=3e-08 nf=1
MPA1 (PCOND HIB AP DVDD) pch_ulvt_mac w=2.4e-07 l=3e-08 nf=1
MNA0 (PCOND ENB VREFN VSS) nch_ulvt_mac w=1.2e-07 l=3e-08 nf=1
MNA1 (PCOND HIB VREFN VSS) nch_ulvt_mac w=1.2e-07 l=3e-08 nf=1
MPB0 (NOFF EN DVDD DVDD) pch_ulvt_mac w=1.2e-07 l=3e-08 nf=1
MPB1 (NOFF HIB DVDD DVDD) pch_ulvt_mac w=1.2e-07 l=3e-08 nf=1
MNB0 (NOFF EN BN VSS) nch_ulvt_mac w=1.2e-07 l=3e-08 nf=1
MNB1 (BN HIB VREFN VSS) nch_ulvt_mac w=1.2e-07 l=3e-08 nf=1
MGPN (GP PCOND VREFN VSS) nch_mac w=2.4e-07 l=3e-08 nf=1
MGPP (GP PCOND VREFP VREFP) pch_mac w=3.6e-07 l=3e-08 nf=1
MGNN (GN NOFF VREFN VSS) nch_mac w=2.4e-07 l=3e-08 nf=1
MGNP (GN NOFF VREFP VREFP) pch_mac w=1.2e-07 l=3e-08 nf=1
MNOUT (BP GN VREFN VSS) nch_mac w=4.5e-07 l=3e-08 nf=1
MPOUT (BP GP VREFP VREFP) pch_mac w=9e-07 l=3e-08 nf=1
// @RNL {
//   {&HIB &EN &ENB &BP &VREFP &VREFN &VSS &DVDD} @REMOVE-FROM $PORT_FILL_SET;
//   &VSS @ADD-TO $GROUND_NET_SET;
//   &VREFN @ADD-TO $GROUND_NET_SET;
//   #MPA0 @PLACE(8, 32) => @ORIENT("R0");
//   #MPA0 @SET-SYMBOL $PMOS;
//   #MPA0 @TEXT("ULVT 0.24u", key="model", size=1.05, dx=1.5, dy=-1);
//   #MPA0 @TEXT("MPA0", key="name", size=1.1, dx=1.5, dy=1);
//   #MPA1 @PLACE(8, 24) => @ORIENT("R0");
//   #MPA1 @SET-SYMBOL $PMOS;
//   #MPA1 @TEXT("ULVT 0.24u", key="model", size=1.05, dx=1.5, dy=-1);
//   #MPA1 @TEXT("MPA1", key="name", size=1.1, dx=1.5, dy=1);
//   #MNA0 @PLACE(0, 8) => @ORIENT("R0");
//   #MNA0 @SET-SYMBOL $NMOS;
//   #MNA0 @TEXT("ULVT 0.12u", key="model", size=1.05, dx=1.5, dy=-1);
//   #MNA0 @TEXT("MNA0", key="name", size=1.1, dx=1.5, dy=1);
//   #MNA1 @PLACE(16, 8) => @ORIENT("R0");
//   #MNA1 @SET-SYMBOL $NMOS;
//   #MNA1 @TEXT("ULVT 0.12u", key="model", size=1.05, dx=1.5, dy=-1);
//   #MNA1 @TEXT("MNA1", key="name", size=1.1, dx=1.5, dy=1);
//   #MPB0 @PLACE(0, -8) => @ORIENT("R0");
//   #MPB0 @SET-SYMBOL $PMOS;
//   #MPB0 @TEXT("ULVT 0.12u", key="model", size=1.05, dx=1.5, dy=-1);
//   #MPB0 @TEXT("MPB0", key="name", size=1.1, dx=1.5, dy=1);
//   #MPB1 @PLACE(16, -8) => @ORIENT("R0");
//   #MPB1 @SET-SYMBOL $PMOS;
//   #MPB1 @TEXT("ULVT 0.12u", key="model", size=1.05, dx=1.5, dy=-1);
//   #MPB1 @TEXT("MPB1", key="name", size=1.1, dx=1.5, dy=1);
//   #MNB0 @PLACE(8, -24) => @ORIENT("R0");
//   #MNB0 @SET-SYMBOL $NMOS;
//   #MNB0 @TEXT("ULVT 0.12u", key="model", size=1.05, dx=1.5, dy=-1);
//   #MNB0 @TEXT("MNB0", key="name", size=1.1, dx=1.5, dy=1);
//   #MNB1 @PLACE(8, -32) => @ORIENT("R0");
//   #MNB1 @SET-SYMBOL $NMOS;
//   #MNB1 @TEXT("ULVT 0.12u", key="model", size=1.05, dx=1.5, dy=-1);
//   #MNB1 @TEXT("MNB1", key="name", size=1.1, dx=1.5, dy=1);
//   #MPOUT @PLACE(76, 18) => @ORIENT("R0");
//   #MPOUT @SET-SYMBOL $PMOS;
//   #MPOUT @TEXT("SVT 0.9u", key="model", size=1.05, dx=1.5, dy=-1);
//   #MPOUT @TEXT("MPOUT", key="name", size=1.1, dx=1.5, dy=1);
//   #MNOUT @PLACE(76, -18) => @ORIENT("R0");
//   #MNOUT @SET-SYMBOL $NMOS;
//   #MNOUT @TEXT("SVT 0.45u", key="model", size=1.05, dx=1.5, dy=-1);
//   #MNOUT @TEXT("MNOUT", key="name", size=1.1, dx=1.5, dy=1);
//   &AP @WIRE {#MPA0:1 #MPA1:3};
//   (10, 28) @TEXT("AP", size=1.05);
//   %j1 = (8, 16);
//   &PCOND @WIRE {#MNA0:1 (0, 16) %j1 (16, 16) #MNA1:1};
//   &PCOND @WIRE {#MPA1:1 %j1};
//   #MGPN @PLACE(43, 9) => @ORIENT("R0");
//   #MGPN @SET-SYMBOL $NMOS;
//   #MGPN @TEXT("SVT 0.24u", key="model", size=1.05, dx=1.5, dy=-1);
//   #MGPN @TEXT("MGPN", key="name", size=1.1, dx=1.5, dy=1);
//   #MGPP @PLACE(43, 23) => @ORIENT("R0");
//   #MGPP @SET-SYMBOL $PMOS;
//   #MGPP @TEXT("SVT 0.36u", key="model", size=1.05, dx=1.5, dy=-1);
//   #MGPP @TEXT("MGPP", key="name", size=1.1, dx=1.5, dy=1);
//   %j2 = (43, 16);
//   %j3 = (38, 16);
//   &GP @WIRE {#MGPN:1 %j2 #MGPP:1};
//   &PCOND @WIRE {#MGPN:2 (38, 9) %j3 (38, 23) #MGPP:2};
//   &PCOND @WIRE {%j1 %j3};
//   &GP @WIRE {%j2 (65, 16) (65, 18) #MPOUT:2};
//   %j4 = (8, -16);
//   &NOFF @WIRE {#MPB0:1 (0, -16) %j4 (16, -16) #MPB1:1};
//   &NOFF @WIRE {#MNB0:1 %j4};
//   &BN @WIRE {#MNB0:3 #MNB1:1};
//   (18, -14) @TEXT("NOFF", size=1.05);
//   #MGNN @PLACE(43, -23) => @ORIENT("R0");
//   #MGNN @SET-SYMBOL $NMOS;
//   #MGNN @TEXT("SVT 0.24u", key="model", size=1.05, dx=1.5, dy=-1);
//   #MGNN @TEXT("MGNN", key="name", size=1.1, dx=1.5, dy=1);
//   #MGNP @PLACE(43, -9) => @ORIENT("R0");
//   #MGNP @SET-SYMBOL $PMOS;
//   #MGNP @TEXT("SVT 0.12u", key="model", size=1.05, dx=1.5, dy=-1);
//   #MGNP @TEXT("MGNP", key="name", size=1.1, dx=1.5, dy=1);
//   %j5 = (43, -16);
//   %j6 = (38, -16);
//   &GN @WIRE {#MGNN:1 %j5 #MGNP:1};
//   &NOFF @WIRE {#MGNN:2 (38, -23) %j6 (38, -9) #MGNP:2};
//   &NOFF @WIRE {%j4 %j6};
//   &GN @WIRE {%j5 (65, -16) (65, -18) #MNOUT:2};
//   %j7 = (76, 0);
//   &BP @WIRE {#MPOUT:1 %j7 #MNOUT:1};
//   &BP @WIRE {%j7 (85, 0)};
//   (85, 1) @TEXT("BP", size=1.05);
//   (-5, 42) @TEXT("NOR: PCOND = ~(ENB | HIB)", size=1.05);
//   (-5, -42) @TEXT("NAND: NOFF = ~(EN & HIB)", size=1.05);
//   (31, 39) @TEXT("Reference gate drivers", size=1.05);
//   (67, 39) @TEXT("Output rail switch", size=1.05);
//   &ENB @WIRE {#MPA0:2 (3, 32)};
//   (2.7, 32) @TEXT("ENB", size=1.05, halign="end", valign="middle");
//   %t9 = $SUPPLY @ATTACH &DVDD => @PLACE(8, 36);
//   &DVDD @WIRE {#MPA0:3 %t9:p};
//   &HIB @WIRE {#MPA1:2 (3, 24)};
//   (2.7, 24) @TEXT("HIB", size=1.05, halign="end", valign="middle");
//   &ENB @WIRE {#MNA0:2 (-5, 8)};
//   (-5.3, 8) @TEXT("ENB", size=1.05, halign="end", valign="middle");
//   %t12 = $GROUND @ATTACH &VREFN => @PLACE(0, 4);
//   &VREFN @WIRE {#MNA0:3 %t12:p};
//   &HIB @WIRE {#MNA1:2 (11, 8)};
//   (10.7, 8) @TEXT("HIB", size=1.05, halign="end", valign="middle");
//   %t14 = $GROUND @ATTACH &VREFN => @PLACE(16, 4);
//   &VREFN @WIRE {#MNA1:3 %t14:p};
//   &EN @WIRE {#MPB0:2 (-5, -8)};
//   (-5.3, -8) @TEXT("EN", size=1.05, halign="end", valign="middle");
//   %t16 = $SUPPLY @ATTACH &DVDD => @PLACE(0, -4);
//   &DVDD @WIRE {#MPB0:3 %t16:p};
//   &HIB @WIRE {#MPB1:2 (11, -8)};
//   (10.7, -8) @TEXT("HIB", size=1.05, halign="end", valign="middle");
//   %t18 = $SUPPLY @ATTACH &DVDD => @PLACE(16, -4);
//   &DVDD @WIRE {#MPB1:3 %t18:p};
//   &EN @WIRE {#MNB0:2 (3, -24)};
//   (2.7, -24) @TEXT("EN", size=1.05, halign="end", valign="middle");
//   &HIB @WIRE {#MNB1:2 (3, -32)};
//   (2.7, -32) @TEXT("HIB", size=1.05, halign="end", valign="middle");
//   %t21 = $GROUND @ATTACH &VREFN => @PLACE(8, -36);
//   &VREFN @WIRE {#MNB1:3 %t21:p};
//   %t22 = $SUPPLY @ATTACH &VREFP => @PLACE(76, 22);
//   &VREFP @WIRE {#MPOUT:3 %t22:p};
//   %t23 = $GROUND @ATTACH &VREFN => @PLACE(76, -22);
//   &VREFN @WIRE {#MNOUT:3 %t23:p};
//   %t24 = $GROUND @ATTACH &VREFN => @PLACE(43, 5);
//   &VREFN @WIRE {#MGPN:3 %t24:p};
//   %t25 = $SUPPLY @ATTACH &VREFP => @PLACE(43, 27);
//   &VREFP @WIRE {#MGPP:3 %t25:p};
//   %t26 = $GROUND @ATTACH &VREFN => @PLACE(43, -27);
//   &VREFN @WIRE {#MGNN:3 %t26:p};
//   %t27 = $SUPPLY @ATTACH &VREFP => @PLACE(43, -5);
//   &VREFP @WIRE {#MGNP:3 %t27:p};
//   $JUNCTION @ATTACH %j1;
//   $JUNCTION @ATTACH %j2;
//   $JUNCTION @ATTACH %j3;
//   $JUNCTION @ATTACH %j4;
//   $JUNCTION @ATTACH %j5;
//   $JUNCTION @ATTACH %j6;
//   $JUNCTION @ATTACH %j7;
//   (-7, 51) @TEXT("N4 formal candidate / WIP | mq_cdac_drv2 | isolated DVDD logic / VREFP output", size=1.4, bold=true, textcolor="#17365d");
//   (-7, 48.6) @TEXT("Drawing only | N bulk = VSS; L = 30 nm. P bulk DVDD: MPA0, MPA1, MPB0, MPB1; VREFP: MGPP, MGNP, MPOUT", size=1.05, textcolor="#52606d");
// }
ends mq_cdac_drv2

// Matched half-capacitor pair j=2
subckt mq_cdac_bit2 (VIN VG DH RL EN ENB TOP VREFP VREFN VSS PHI_S DVDD PHI_SB EQBUS APGATE)
// CP*: user-specified 5% bottom-plate estimate for every physical MOM unit, not extraction.
// Series tails retain one unit parasitic at MID and one at B.
// APGATE PMOS assist connects each bottom plate to VIN.
// MID-to-VIN transmission gates provide physical initialization during PHI_S.
// Additional ENB NMOS sharing retains a common EQBUS.
XHCTL (DH HHIB DVDD VREFN VSS) mq_cdac_ctl_h
XLCTL (RL LHIB DVDD VREFN VSS) mq_cdac_ctl_l
XDH (HHIB EN ENB BH VREFP VREFN VSS DVDD) mq_cdac_drv2
CH (TOP BH) cfmom_2t w=5e-08 s=2.4e-07 nr=6 lr=1.69e-06 stm=2 spm=4 multi=1
CPH (BH VSS) capacitor c=5.01145e-17
CHA (TOP MIDH) cfmom_2t w=5e-08 s=2.4e-07 nr=6 lr=1.69e-06 stm=2 spm=4 multi=1
CPHA (MIDH VSS) capacitor c=5.01145e-17
CHB (MIDH BH) cfmom_2t w=5e-08 s=2.4e-07 nr=6 lr=1.69e-06 stm=2 spm=4 multi=1
CPHB (BH VSS) capacitor c=5.01145e-17
MSH (BH VG VIN VSS) nch_ulvt_mac w=1.2e-07 l=3e-08 nf=1
XDL (LHIB EN ENB BL VREFP VREFN VSS DVDD) mq_cdac_drv2
CL (TOP BL) cfmom_2t w=5e-08 s=2.4e-07 nr=6 lr=1.69e-06 stm=2 spm=4 multi=1
CPL (BL VSS) capacitor c=5.01145e-17
CLA (TOP MIDL) cfmom_2t w=5e-08 s=2.4e-07 nr=6 lr=1.69e-06 stm=2 spm=4 multi=1
CPLA (MIDL VSS) capacitor c=5.01145e-17
CLB (MIDL BL) cfmom_2t w=5e-08 s=2.4e-07 nr=6 lr=1.69e-06 stm=2 spm=4 multi=1
CPLB (BL VSS) capacitor c=5.01145e-17
MSL (BL VG VIN VSS) nch_ulvt_mac w=1.2e-07 l=3e-08 nf=1
MEQ1 (BH APGATE VIN VREFP) pch_ulvt_mac w=1.2e-07 l=3e-08 nf=1
MEQ2 (BL APGATE VIN VREFP) pch_ulvt_mac w=1.2e-07 l=3e-08 nf=1
MMIDNH (MIDH PHI_S VIN VSS) nch_ulvt_mac w=1.2e-07 l=3e-08 nf=1
MMIDPH (MIDH PHI_SB VIN VREFP) pch_mac w=1.2e-07 l=3e-08 nf=1
MMIDNL (MIDL PHI_S VIN VSS) nch_ulvt_mac w=1.2e-07 l=3e-08 nf=1
MMIDPL (MIDL PHI_SB VIN VREFP) pch_mac w=1.2e-07 l=3e-08 nf=1
MSHAREH (BH ENB EQBUS VSS) nch_ulvt_mac w=1.2e-07 l=3e-08 nf=1
MSHAREL (BL ENB EQBUS VSS) nch_ulvt_mac w=1.2e-07 l=3e-08 nf=1
// @RNL {
//   {&VIN &VG &DH &RL &EN &ENB &TOP &VREFP &VREFN &VSS &PHI_S &DVDD &PHI_SB &EQBUS &APGATE} @REMOVE-FROM $PORT_FILL_SET;
//   &VSS @ADD-TO $GROUND_NET_SET;
//   &VREFN @ADD-TO $GROUND_NET_SET;
//   #XHCTL @PLACE(0, 20) => @ORIENT("R0");
//   #XDH @PLACE(19, 18) => @ORIENT("R0");
//   &HHIB @WIRE {#XHCTL:2 #XDH:1};
//   %j1 = (115, 20);
//   %j2 = (38, 20);
//   %j3 = (52, 20);
//   %j4 = (66, 20);
//   %j5 = (84, 20);
//   &BH @WIRE {#XDH:4 %j2 %j3 %j4 %j5};
//   #CH @PLACE(100, 20) => @ORIENT("R270");
//   #CH @TEXT("", key="value");
//   #CH @TEXT("", key="name");
//   (100, 22.2) @TEXT("CH", size=1.05);
//   (100, 16.8) @TEXT("1 Cu", size=1.05);
//   &BH @WIRE {%j5 #CH:2};
//   &TOP @WIRE {#CH:1 %j1};
//   #CHA @PLACE(106, 40) => @ORIENT("R270");
//   #CHA @TEXT("", key="value");
//   #CHA @TEXT("", key="name");
//   (106, 42.2) @TEXT("CHA", size=1.05);
//   (106, 36.8) @TEXT("1 Cu", size=1.05);
//   #CHB @PLACE(84, 40) => @ORIENT("R270");
//   #CHB @TEXT("", key="value");
//   #CHB @TEXT("", key="name");
//   (84, 42.2) @TEXT("CHB", size=1.05);
//   (84, 36.8) @TEXT("1 Cu", size=1.05);
//   &BH @WIRE {%j5 (76, 20) (76, 40) #CHB:2};
//   %j6 = (94, 40);
//   &MIDH @WIRE {#CHB:1 %j6 #CHA:2};
//   (94, 42) @TEXT("MIDH", size=1.05);
//   %j7 = (115, 40);
//   &TOP @WIRE {#CHA:1 %j7};
//   #CPHA @PLACE(94, 31) => @ORIENT("R0");
//   #CPHA @TEXT("", key="value");
//   #CPHA @TEXT("", key="name");
//   (96, 32) @TEXT("CPHA", size=1.05);
//   (96, 30) @TEXT("0.05011 fF / 5%", size=1.05);
//   &MIDH @WIRE {%j6 #CPHA:1};
//   #CPHB @PLACE(98, 12) => @ORIENT("R0");
//   #CPHB @TEXT("", key="value");
//   #CPHB @TEXT("", key="name");
//   (100, 13) @TEXT("CPHB", size=1.05);
//   (100, 11) @TEXT("0.05011 fF / 5%", size=1.05);
//   &BH @WIRE {%j5 (98, 20) #CPHB:1};
//   #CPH @PLACE(84, 12) => @ORIENT("R0");
//   #CPH @TEXT("", key="value");
//   #CPH @TEXT("", key="name");
//   (86, 13) @TEXT("CPH", size=1.05);
//   (86, 11) @TEXT("0.05011 fF / 5%", size=1.05);
//   &BH @WIRE {%j5 #CPH:1};
//   #MSH @PLACE(38, 7) => @ORIENT("R0");
//   #MSH @SET-SYMBOL $NMOS;
//   #MSH @TEXT("ULVT 0.12u", key="model", size=1.05, dx=1.5, dy=-1);
//   #MSH @TEXT("MSH", key="name", size=1.1, dx=1.5, dy=1);
//   &BH @WIRE {%j2 #MSH:1};
//   #MEQ1 @PLACE(52, 7) => @ORIENT("MX");
//   #MEQ1 @SET-SYMBOL $PMOS;
//   #MEQ1 @TEXT("ULVT 0.12u", key="model", size=1.05, dx=1.5, dy=-1);
//   #MEQ1 @TEXT("MEQ1", key="name", size=1.1, dx=1.5, dy=1);
//   &BH @WIRE {%j3 #MEQ1:1};
//   #MSHAREH @PLACE(66, 7) => @ORIENT("R0");
//   #MSHAREH @SET-SYMBOL $NMOS;
//   #MSHAREH @TEXT("ULVT 0.12u", key="model", size=1.05, dx=1.5, dy=-1);
//   #MSHAREH @TEXT("MSHAREH", key="name", size=1.1, dx=1.5, dy=1);
//   &BH @WIRE {%j4 #MSHAREH:1};
//   #MMIDNH @PLACE(126, 14) => @ORIENT("R0");
//   #MMIDNH @SET-SYMBOL $NMOS;
//   #MMIDNH @TEXT("ULVT 0.12u", key="model", size=1.05, dx=1.5, dy=-1);
//   #MMIDNH @TEXT("MMIDNH", key="name", size=1.1, dx=1.5, dy=1);
//   #MMIDPH @PLACE(142, 14) => @ORIENT("MX");
//   #MMIDPH @SET-SYMBOL $PMOS;
//   #MMIDPH @TEXT("SVT 0.12u", key="model", size=1.05, dx=1.5, dy=-1);
//   #MMIDPH @TEXT("MMIDPH", key="name", size=1.1, dx=1.5, dy=1);
//   &MIDH @WIRE {#MMIDNH:1 (126, 23) (142, 23) #MMIDPH:1};
//   (132, 24) @TEXT("MIDH", size=1.05);
//   (123, 27) @TEXT("MIDH sampling TG", size=1.05);
//   (-8, 35) @TEXT("High bank", size=1.05);
//   #XLCTL @PLACE(0, -27) => @ORIENT("R0");
//   #XDL @PLACE(19, -29) => @ORIENT("R0");
//   &LHIB @WIRE {#XLCTL:2 #XDL:1};
//   %j8 = (115, -27);
//   %j9 = (38, -27);
//   %j10 = (52, -27);
//   %j11 = (66, -27);
//   %j12 = (84, -27);
//   &BL @WIRE {#XDL:4 %j9 %j10 %j11 %j12};
//   #CL @PLACE(100, -27) => @ORIENT("R270");
//   #CL @TEXT("", key="value");
//   #CL @TEXT("", key="name");
//   (100, -24.8) @TEXT("CL", size=1.05);
//   (100, -30.2) @TEXT("1 Cu", size=1.05);
//   &BL @WIRE {%j12 #CL:2};
//   &TOP @WIRE {#CL:1 %j8};
//   #CLA @PLACE(106, -7) => @ORIENT("R270");
//   #CLA @TEXT("", key="value");
//   #CLA @TEXT("", key="name");
//   (106, -4.8) @TEXT("CLA", size=1.05);
//   (106, -10.2) @TEXT("1 Cu", size=1.05);
//   #CLB @PLACE(84, -7) => @ORIENT("R270");
//   #CLB @TEXT("", key="value");
//   #CLB @TEXT("", key="name");
//   (84, -4.8) @TEXT("CLB", size=1.05);
//   (84, -10.2) @TEXT("1 Cu", size=1.05);
//   &BL @WIRE {%j12 (76, -27) (76, -7) #CLB:2};
//   %j13 = (94, -7);
//   &MIDL @WIRE {#CLB:1 %j13 #CLA:2};
//   (94, -5) @TEXT("MIDL", size=1.05);
//   %j14 = (115, -7);
//   &TOP @WIRE {#CLA:1 %j14};
//   #CPLA @PLACE(94, -16) => @ORIENT("R0");
//   #CPLA @TEXT("", key="value");
//   #CPLA @TEXT("", key="name");
//   (96, -15) @TEXT("CPLA", size=1.05);
//   (96, -17) @TEXT("0.05011 fF / 5%", size=1.05);
//   &MIDL @WIRE {%j13 #CPLA:1};
//   #CPLB @PLACE(98, -35) => @ORIENT("R0");
//   #CPLB @TEXT("", key="value");
//   #CPLB @TEXT("", key="name");
//   (100, -34) @TEXT("CPLB", size=1.05);
//   (100, -36) @TEXT("0.05011 fF / 5%", size=1.05);
//   &BL @WIRE {%j12 (98, -27) #CPLB:1};
//   #CPL @PLACE(84, -35) => @ORIENT("R0");
//   #CPL @TEXT("", key="value");
//   #CPL @TEXT("", key="name");
//   (86, -34) @TEXT("CPL", size=1.05);
//   (86, -36) @TEXT("0.05011 fF / 5%", size=1.05);
//   &BL @WIRE {%j12 #CPL:1};
//   #MSL @PLACE(38, -40) => @ORIENT("R0");
//   #MSL @SET-SYMBOL $NMOS;
//   #MSL @TEXT("ULVT 0.12u", key="model", size=1.05, dx=1.5, dy=-1);
//   #MSL @TEXT("MSL", key="name", size=1.1, dx=1.5, dy=1);
//   &BL @WIRE {%j9 #MSL:1};
//   #MEQ2 @PLACE(52, -40) => @ORIENT("MX");
//   #MEQ2 @SET-SYMBOL $PMOS;
//   #MEQ2 @TEXT("ULVT 0.12u", key="model", size=1.05, dx=1.5, dy=-1);
//   #MEQ2 @TEXT("MEQ2", key="name", size=1.1, dx=1.5, dy=1);
//   &BL @WIRE {%j10 #MEQ2:1};
//   #MSHAREL @PLACE(66, -40) => @ORIENT("R0");
//   #MSHAREL @SET-SYMBOL $NMOS;
//   #MSHAREL @TEXT("ULVT 0.12u", key="model", size=1.05, dx=1.5, dy=-1);
//   #MSHAREL @TEXT("MSHAREL", key="name", size=1.1, dx=1.5, dy=1);
//   &BL @WIRE {%j11 #MSHAREL:1};
//   #MMIDNL @PLACE(126, -33) => @ORIENT("R0");
//   #MMIDNL @SET-SYMBOL $NMOS;
//   #MMIDNL @TEXT("ULVT 0.12u", key="model", size=1.05, dx=1.5, dy=-1);
//   #MMIDNL @TEXT("MMIDNL", key="name", size=1.1, dx=1.5, dy=1);
//   #MMIDPL @PLACE(142, -33) => @ORIENT("MX");
//   #MMIDPL @SET-SYMBOL $PMOS;
//   #MMIDPL @TEXT("SVT 0.12u", key="model", size=1.05, dx=1.5, dy=-1);
//   #MMIDPL @TEXT("MMIDPL", key="name", size=1.1, dx=1.5, dy=1);
//   &MIDL @WIRE {#MMIDNL:1 (126, -24) (142, -24) #MMIDPL:1};
//   (132, -23) @TEXT("MIDL", size=1.05);
//   (123, -20) @TEXT("MIDL sampling TG", size=1.05);
//   (-8, -12) @TEXT("Low bank", size=1.05);
//   &TOP @WIRE {%j7 %j1 %j14 %j8};
//   (116, -3) @TEXT("TOP", size=1.05);
//   (-8, -51) @TEXT("Cu = 1.00229 fF. Cp = 5% of every physical MOM, including series MID.", size=1.05);
//   (-8, -54) @TEXT("DH -> buffer; RL -> inverter. Control supply: DVDD / VREFN; body: VSS.", size=1.05);
//   (-8, -57) @TEXT("5% Cp is a user estimate, not extraction.", size=1.05);
//   &DH @WIRE {#XHCTL:1 (-6, 20)};
//   (-6.3, 20) @TEXT("DH", size=1.05, halign="end", valign="middle");
//   &EN @WIRE {#XDH:2 (9, 16)};
//   (8.7, 16) @TEXT("EN", size=1.05, halign="end", valign="middle");
//   &ENB @WIRE {#XDH:3 (9, 13)};
//   (8.7, 13) @TEXT("ENB", size=1.05, halign="end", valign="middle");
//   %t18 = $SUPPLY @ATTACH &VREFP => @PLACE(22, 29);
//   &VREFP @WIRE {#XDH:5 %t18:p};
//   %t19 = $GROUND @ATTACH &VREFN => @PLACE(22, 7);
//   &VREFN @WIRE {#XDH:6 %t19:p};
//   %t20 = $GROUND @ATTACH &VSS => @PLACE(16, 7);
//   &VSS @WIRE {#XDH:7 %t20:p};
//   %t21 = $SUPPLY @ATTACH &DVDD => @PLACE(16, 29);
//   &DVDD @WIRE {#XDH:8 %t21:p};
//   %t22 = $GROUND @ATTACH &VSS => @PLACE(94, 27);
//   &VSS @WIRE {#CPHA:2 %t22:p};
//   %t23 = $GROUND @ATTACH &VSS => @PLACE(98, 8);
//   &VSS @WIRE {#CPHB:2 %t23:p};
//   %t24 = $GROUND @ATTACH &VSS => @PLACE(84, 8);
//   &VSS @WIRE {#CPH:2 %t24:p};
//   &VG @WIRE {#MSH:2 (33, 7)};
//   (32.7, 10.2) @TEXT("VG", size=1.05, halign="end", valign="middle");
//   &VIN @WIRE {#MSH:3 (38, 3)};
//   (38, 2.4) @TEXT("VIN", size=1.05, halign="middle", valign="top");
//   &APGATE @WIRE {#MEQ1:2 (47, 7)};
//   (46.7, 10.2) @TEXT("APGATE", size=1.05, halign="end", valign="middle");
//   &VIN @WIRE {#MEQ1:3 (52, 3)};
//   (52, 2.4) @TEXT("VIN", size=1.05, halign="middle", valign="top");
//   &ENB @WIRE {#MSHAREH:2 (61, 7)};
//   (60.7, 10.2) @TEXT("ENB", size=1.05, halign="end", valign="middle");
//   &EQBUS @WIRE {#MSHAREH:3 (66, 3)};
//   (66, 2.4) @TEXT("EQBUS", size=1.05, halign="middle", valign="top");
//   &PHI_S @WIRE {#MMIDNH:2 (121, 14)};
//   (120.7, 17.2) @TEXT("PHI_S", size=1.05, halign="end", valign="middle");
//   &VIN @WIRE {#MMIDNH:3 (126, 10)};
//   (126, 9.4) @TEXT("VIN", size=1.05, halign="middle", valign="top");
//   &PHI_SB @WIRE {#MMIDPH:2 (137, 14)};
//   (136.7, 17.2) @TEXT("PHI_SB", size=1.05, halign="end", valign="middle");
//   &VIN @WIRE {#MMIDPH:3 (142, 10)};
//   (142, 9.4) @TEXT("VIN", size=1.05, halign="middle", valign="top");
//   &RL @WIRE {#XLCTL:1 (-6, -27)};
//   (-6.3, -27) @TEXT("RL", size=1.05, halign="end", valign="middle");
//   &EN @WIRE {#XDL:2 (9, -31)};
//   (8.7, -31) @TEXT("EN", size=1.05, halign="end", valign="middle");
//   &ENB @WIRE {#XDL:3 (9, -34)};
//   (8.7, -34) @TEXT("ENB", size=1.05, halign="end", valign="middle");
//   %t38 = $SUPPLY @ATTACH &VREFP => @PLACE(22, -18);
//   &VREFP @WIRE {#XDL:5 %t38:p};
//   %t39 = $GROUND @ATTACH &VREFN => @PLACE(22, -40);
//   &VREFN @WIRE {#XDL:6 %t39:p};
//   %t40 = $GROUND @ATTACH &VSS => @PLACE(16, -40);
//   &VSS @WIRE {#XDL:7 %t40:p};
//   %t41 = $SUPPLY @ATTACH &DVDD => @PLACE(16, -18);
//   &DVDD @WIRE {#XDL:8 %t41:p};
//   %t42 = $GROUND @ATTACH &VSS => @PLACE(94, -20);
//   &VSS @WIRE {#CPLA:2 %t42:p};
//   %t43 = $GROUND @ATTACH &VSS => @PLACE(98, -39);
//   &VSS @WIRE {#CPLB:2 %t43:p};
//   %t44 = $GROUND @ATTACH &VSS => @PLACE(84, -39);
//   &VSS @WIRE {#CPL:2 %t44:p};
//   &VG @WIRE {#MSL:2 (33, -40)};
//   (32.7, -36.8) @TEXT("VG", size=1.05, halign="end", valign="middle");
//   &VIN @WIRE {#MSL:3 (38, -44)};
//   (38, -44.6) @TEXT("VIN", size=1.05, halign="middle", valign="top");
//   &APGATE @WIRE {#MEQ2:2 (47, -40)};
//   (46.7, -36.8) @TEXT("APGATE", size=1.05, halign="end", valign="middle");
//   &VIN @WIRE {#MEQ2:3 (52, -44)};
//   (52, -44.6) @TEXT("VIN", size=1.05, halign="middle", valign="top");
//   &ENB @WIRE {#MSHAREL:2 (61, -40)};
//   (60.7, -36.8) @TEXT("ENB", size=1.05, halign="end", valign="middle");
//   &EQBUS @WIRE {#MSHAREL:3 (66, -44)};
//   (66, -44.6) @TEXT("EQBUS", size=1.05, halign="middle", valign="top");
//   &PHI_S @WIRE {#MMIDNL:2 (121, -33)};
//   (120.7, -29.8) @TEXT("PHI_S", size=1.05, halign="end", valign="middle");
//   &VIN @WIRE {#MMIDNL:3 (126, -37)};
//   (126, -37.6) @TEXT("VIN", size=1.05, halign="middle", valign="top");
//   &PHI_SB @WIRE {#MMIDPL:2 (137, -33)};
//   (136.7, -29.8) @TEXT("PHI_SB", size=1.05, halign="end", valign="middle");
//   &VIN @WIRE {#MMIDPL:3 (142, -37)};
//   (142, -37.6) @TEXT("VIN", size=1.05, halign="middle", valign="top");
//   $JUNCTION @ATTACH %j1;
//   $JUNCTION @ATTACH %j2;
//   $JUNCTION @ATTACH %j3;
//   $JUNCTION @ATTACH %j4;
//   $JUNCTION @ATTACH %j5;
//   $JUNCTION @ATTACH %j6;
//   $JUNCTION @ATTACH %j9;
//   $JUNCTION @ATTACH %j10;
//   $JUNCTION @ATTACH %j11;
//   $JUNCTION @ATTACH %j12;
//   $JUNCTION @ATTACH %j13;
//   $JUNCTION @ATTACH %j14;
//   (-8, 57) @TEXT("N4 formal candidate / WIP | weight 2: 3 | matched H/L banks | unit series tail", size=1.4, bold=true, textcolor="#17365d");
//   (-8, 54.6) @TEXT("Drawing only | N bulk = VSS; L = 30 nm. P bulk VREFP: MEQ1, MEQ2, MMIDPH, MMIDPL", size=1.05, textcolor="#52606d");
// }
ends mq_cdac_bit2

// Reference-rail output driver j=1
subckt mq_cdac_drv1 (HIB EN ENB BP VREFP VREFN VSS DVDD)
// DVDD prelogic: PCOND = NOR(ENB,HIB); NOFF = NAND(EN,HIB).
// Reference-powered final inverters restore GP and GN to VREFP/VREFN.
// Actual current overlap, settling and device stress require measurement.
MPA0 (AP ENB DVDD DVDD) pch_ulvt_mac w=2.4e-07 l=3e-08 nf=1
MPA1 (PCOND HIB AP DVDD) pch_ulvt_mac w=2.4e-07 l=3e-08 nf=1
MNA0 (PCOND ENB VREFN VSS) nch_ulvt_mac w=1.2e-07 l=3e-08 nf=1
MNA1 (PCOND HIB VREFN VSS) nch_ulvt_mac w=1.2e-07 l=3e-08 nf=1
MPB0 (NOFF EN DVDD DVDD) pch_ulvt_mac w=1.2e-07 l=3e-08 nf=1
MPB1 (NOFF HIB DVDD DVDD) pch_ulvt_mac w=1.2e-07 l=3e-08 nf=1
MNB0 (NOFF EN BN VSS) nch_ulvt_mac w=1.2e-07 l=3e-08 nf=1
MNB1 (BN HIB VREFN VSS) nch_ulvt_mac w=1.2e-07 l=3e-08 nf=1
MGPN (GP PCOND VREFN VSS) nch_mac w=2.4e-07 l=3e-08 nf=1
MGPP (GP PCOND VREFP VREFP) pch_mac w=3.6e-07 l=3e-08 nf=1
MGNN (GN NOFF VREFN VSS) nch_mac w=2.4e-07 l=3e-08 nf=1
MGNP (GN NOFF VREFP VREFP) pch_mac w=1.2e-07 l=3e-08 nf=1
MNOUT (BP GN VREFN VSS) nch_mac w=1.2e-07 l=3e-08 nf=1
MPOUT (BP GP VREFP VREFP) pch_mac w=2.4e-07 l=3e-08 nf=1
// @RNL {
//   {&HIB &EN &ENB &BP &VREFP &VREFN &VSS &DVDD} @REMOVE-FROM $PORT_FILL_SET;
//   &VSS @ADD-TO $GROUND_NET_SET;
//   &VREFN @ADD-TO $GROUND_NET_SET;
//   #MPA0 @PLACE(8, 32) => @ORIENT("R0");
//   #MPA0 @SET-SYMBOL $PMOS;
//   #MPA0 @TEXT("ULVT 0.24u", key="model", size=1.05, dx=1.5, dy=-1);
//   #MPA0 @TEXT("MPA0", key="name", size=1.1, dx=1.5, dy=1);
//   #MPA1 @PLACE(8, 24) => @ORIENT("R0");
//   #MPA1 @SET-SYMBOL $PMOS;
//   #MPA1 @TEXT("ULVT 0.24u", key="model", size=1.05, dx=1.5, dy=-1);
//   #MPA1 @TEXT("MPA1", key="name", size=1.1, dx=1.5, dy=1);
//   #MNA0 @PLACE(0, 8) => @ORIENT("R0");
//   #MNA0 @SET-SYMBOL $NMOS;
//   #MNA0 @TEXT("ULVT 0.12u", key="model", size=1.05, dx=1.5, dy=-1);
//   #MNA0 @TEXT("MNA0", key="name", size=1.1, dx=1.5, dy=1);
//   #MNA1 @PLACE(16, 8) => @ORIENT("R0");
//   #MNA1 @SET-SYMBOL $NMOS;
//   #MNA1 @TEXT("ULVT 0.12u", key="model", size=1.05, dx=1.5, dy=-1);
//   #MNA1 @TEXT("MNA1", key="name", size=1.1, dx=1.5, dy=1);
//   #MPB0 @PLACE(0, -8) => @ORIENT("R0");
//   #MPB0 @SET-SYMBOL $PMOS;
//   #MPB0 @TEXT("ULVT 0.12u", key="model", size=1.05, dx=1.5, dy=-1);
//   #MPB0 @TEXT("MPB0", key="name", size=1.1, dx=1.5, dy=1);
//   #MPB1 @PLACE(16, -8) => @ORIENT("R0");
//   #MPB1 @SET-SYMBOL $PMOS;
//   #MPB1 @TEXT("ULVT 0.12u", key="model", size=1.05, dx=1.5, dy=-1);
//   #MPB1 @TEXT("MPB1", key="name", size=1.1, dx=1.5, dy=1);
//   #MNB0 @PLACE(8, -24) => @ORIENT("R0");
//   #MNB0 @SET-SYMBOL $NMOS;
//   #MNB0 @TEXT("ULVT 0.12u", key="model", size=1.05, dx=1.5, dy=-1);
//   #MNB0 @TEXT("MNB0", key="name", size=1.1, dx=1.5, dy=1);
//   #MNB1 @PLACE(8, -32) => @ORIENT("R0");
//   #MNB1 @SET-SYMBOL $NMOS;
//   #MNB1 @TEXT("ULVT 0.12u", key="model", size=1.05, dx=1.5, dy=-1);
//   #MNB1 @TEXT("MNB1", key="name", size=1.1, dx=1.5, dy=1);
//   #MPOUT @PLACE(76, 18) => @ORIENT("R0");
//   #MPOUT @SET-SYMBOL $PMOS;
//   #MPOUT @TEXT("SVT 0.24u", key="model", size=1.05, dx=1.5, dy=-1);
//   #MPOUT @TEXT("MPOUT", key="name", size=1.1, dx=1.5, dy=1);
//   #MNOUT @PLACE(76, -18) => @ORIENT("R0");
//   #MNOUT @SET-SYMBOL $NMOS;
//   #MNOUT @TEXT("SVT 0.12u", key="model", size=1.05, dx=1.5, dy=-1);
//   #MNOUT @TEXT("MNOUT", key="name", size=1.1, dx=1.5, dy=1);
//   &AP @WIRE {#MPA0:1 #MPA1:3};
//   (10, 28) @TEXT("AP", size=1.05);
//   %j1 = (8, 16);
//   &PCOND @WIRE {#MNA0:1 (0, 16) %j1 (16, 16) #MNA1:1};
//   &PCOND @WIRE {#MPA1:1 %j1};
//   #MGPN @PLACE(43, 9) => @ORIENT("R0");
//   #MGPN @SET-SYMBOL $NMOS;
//   #MGPN @TEXT("SVT 0.24u", key="model", size=1.05, dx=1.5, dy=-1);
//   #MGPN @TEXT("MGPN", key="name", size=1.1, dx=1.5, dy=1);
//   #MGPP @PLACE(43, 23) => @ORIENT("R0");
//   #MGPP @SET-SYMBOL $PMOS;
//   #MGPP @TEXT("SVT 0.36u", key="model", size=1.05, dx=1.5, dy=-1);
//   #MGPP @TEXT("MGPP", key="name", size=1.1, dx=1.5, dy=1);
//   %j2 = (43, 16);
//   %j3 = (38, 16);
//   &GP @WIRE {#MGPN:1 %j2 #MGPP:1};
//   &PCOND @WIRE {#MGPN:2 (38, 9) %j3 (38, 23) #MGPP:2};
//   &PCOND @WIRE {%j1 %j3};
//   &GP @WIRE {%j2 (65, 16) (65, 18) #MPOUT:2};
//   %j4 = (8, -16);
//   &NOFF @WIRE {#MPB0:1 (0, -16) %j4 (16, -16) #MPB1:1};
//   &NOFF @WIRE {#MNB0:1 %j4};
//   &BN @WIRE {#MNB0:3 #MNB1:1};
//   (18, -14) @TEXT("NOFF", size=1.05);
//   #MGNN @PLACE(43, -23) => @ORIENT("R0");
//   #MGNN @SET-SYMBOL $NMOS;
//   #MGNN @TEXT("SVT 0.24u", key="model", size=1.05, dx=1.5, dy=-1);
//   #MGNN @TEXT("MGNN", key="name", size=1.1, dx=1.5, dy=1);
//   #MGNP @PLACE(43, -9) => @ORIENT("R0");
//   #MGNP @SET-SYMBOL $PMOS;
//   #MGNP @TEXT("SVT 0.12u", key="model", size=1.05, dx=1.5, dy=-1);
//   #MGNP @TEXT("MGNP", key="name", size=1.1, dx=1.5, dy=1);
//   %j5 = (43, -16);
//   %j6 = (38, -16);
//   &GN @WIRE {#MGNN:1 %j5 #MGNP:1};
//   &NOFF @WIRE {#MGNN:2 (38, -23) %j6 (38, -9) #MGNP:2};
//   &NOFF @WIRE {%j4 %j6};
//   &GN @WIRE {%j5 (65, -16) (65, -18) #MNOUT:2};
//   %j7 = (76, 0);
//   &BP @WIRE {#MPOUT:1 %j7 #MNOUT:1};
//   &BP @WIRE {%j7 (85, 0)};
//   (85, 1) @TEXT("BP", size=1.05);
//   (-5, 42) @TEXT("NOR: PCOND = ~(ENB | HIB)", size=1.05);
//   (-5, -42) @TEXT("NAND: NOFF = ~(EN & HIB)", size=1.05);
//   (31, 39) @TEXT("Reference gate drivers", size=1.05);
//   (67, 39) @TEXT("Output rail switch", size=1.05);
//   &ENB @WIRE {#MPA0:2 (3, 32)};
//   (2.7, 32) @TEXT("ENB", size=1.05, halign="end", valign="middle");
//   %t9 = $SUPPLY @ATTACH &DVDD => @PLACE(8, 36);
//   &DVDD @WIRE {#MPA0:3 %t9:p};
//   &HIB @WIRE {#MPA1:2 (3, 24)};
//   (2.7, 24) @TEXT("HIB", size=1.05, halign="end", valign="middle");
//   &ENB @WIRE {#MNA0:2 (-5, 8)};
//   (-5.3, 8) @TEXT("ENB", size=1.05, halign="end", valign="middle");
//   %t12 = $GROUND @ATTACH &VREFN => @PLACE(0, 4);
//   &VREFN @WIRE {#MNA0:3 %t12:p};
//   &HIB @WIRE {#MNA1:2 (11, 8)};
//   (10.7, 8) @TEXT("HIB", size=1.05, halign="end", valign="middle");
//   %t14 = $GROUND @ATTACH &VREFN => @PLACE(16, 4);
//   &VREFN @WIRE {#MNA1:3 %t14:p};
//   &EN @WIRE {#MPB0:2 (-5, -8)};
//   (-5.3, -8) @TEXT("EN", size=1.05, halign="end", valign="middle");
//   %t16 = $SUPPLY @ATTACH &DVDD => @PLACE(0, -4);
//   &DVDD @WIRE {#MPB0:3 %t16:p};
//   &HIB @WIRE {#MPB1:2 (11, -8)};
//   (10.7, -8) @TEXT("HIB", size=1.05, halign="end", valign="middle");
//   %t18 = $SUPPLY @ATTACH &DVDD => @PLACE(16, -4);
//   &DVDD @WIRE {#MPB1:3 %t18:p};
//   &EN @WIRE {#MNB0:2 (3, -24)};
//   (2.7, -24) @TEXT("EN", size=1.05, halign="end", valign="middle");
//   &HIB @WIRE {#MNB1:2 (3, -32)};
//   (2.7, -32) @TEXT("HIB", size=1.05, halign="end", valign="middle");
//   %t21 = $GROUND @ATTACH &VREFN => @PLACE(8, -36);
//   &VREFN @WIRE {#MNB1:3 %t21:p};
//   %t22 = $SUPPLY @ATTACH &VREFP => @PLACE(76, 22);
//   &VREFP @WIRE {#MPOUT:3 %t22:p};
//   %t23 = $GROUND @ATTACH &VREFN => @PLACE(76, -22);
//   &VREFN @WIRE {#MNOUT:3 %t23:p};
//   %t24 = $GROUND @ATTACH &VREFN => @PLACE(43, 5);
//   &VREFN @WIRE {#MGPN:3 %t24:p};
//   %t25 = $SUPPLY @ATTACH &VREFP => @PLACE(43, 27);
//   &VREFP @WIRE {#MGPP:3 %t25:p};
//   %t26 = $GROUND @ATTACH &VREFN => @PLACE(43, -27);
//   &VREFN @WIRE {#MGNN:3 %t26:p};
//   %t27 = $SUPPLY @ATTACH &VREFP => @PLACE(43, -5);
//   &VREFP @WIRE {#MGNP:3 %t27:p};
//   $JUNCTION @ATTACH %j1;
//   $JUNCTION @ATTACH %j2;
//   $JUNCTION @ATTACH %j3;
//   $JUNCTION @ATTACH %j4;
//   $JUNCTION @ATTACH %j5;
//   $JUNCTION @ATTACH %j6;
//   $JUNCTION @ATTACH %j7;
//   (-7, 51) @TEXT("N4 formal candidate / WIP | mq_cdac_drv1 | isolated DVDD logic / VREFP output", size=1.4, bold=true, textcolor="#17365d");
//   (-7, 48.6) @TEXT("Drawing only | N bulk = VSS; L = 30 nm. P bulk DVDD: MPA0, MPA1, MPB0, MPB1; VREFP: MGPP, MGNP, MPOUT", size=1.05, textcolor="#52606d");
// }
ends mq_cdac_drv1

// Matched half-capacitor pair j=1
subckt mq_cdac_bit1 (VIN VG DH RL EN ENB TOP VREFP VREFN VSS DVDD EQBUS APGATE)
// CP*: user-specified 5% bottom-plate estimate for every physical MOM unit, not extraction.
// Series tails retain one unit parasitic at MID and one at B.
// APGATE PMOS assist connects each bottom plate to VIN.
// Additional ENB NMOS sharing retains a common EQBUS.
XHCTL (DH HHIB DVDD VREFN VSS) mq_cdac_ctl_h
XLCTL (RL LHIB DVDD VREFN VSS) mq_cdac_ctl_l
XDH (HHIB EN ENB BH VREFP VREFN VSS DVDD) mq_cdac_drv1
CH (TOP BH) cfmom_2t w=5e-08 s=2.4e-07 nr=6 lr=1.69e-06 stm=2 spm=4 multi=1
CPH (BH VSS) capacitor c=5.01145e-17
MSH (BH VG VIN VSS) nch_ulvt_mac w=1.2e-07 l=3e-08 nf=1
XDL (LHIB EN ENB BL VREFP VREFN VSS DVDD) mq_cdac_drv1
CL (TOP BL) cfmom_2t w=5e-08 s=2.4e-07 nr=6 lr=1.69e-06 stm=2 spm=4 multi=1
CPL (BL VSS) capacitor c=5.01145e-17
MSL (BL VG VIN VSS) nch_ulvt_mac w=1.2e-07 l=3e-08 nf=1
MEQ1 (BH APGATE VIN VREFP) pch_ulvt_mac w=1.2e-07 l=3e-08 nf=1
MEQ2 (BL APGATE VIN VREFP) pch_ulvt_mac w=1.2e-07 l=3e-08 nf=1
MSHAREH (BH ENB EQBUS VSS) nch_ulvt_mac w=1.2e-07 l=3e-08 nf=1
MSHAREL (BL ENB EQBUS VSS) nch_ulvt_mac w=1.2e-07 l=3e-08 nf=1
// @RNL {
//   {&VIN &VG &DH &RL &EN &ENB &TOP &VREFP &VREFN &VSS &DVDD &EQBUS &APGATE} @REMOVE-FROM $PORT_FILL_SET;
//   &VSS @ADD-TO $GROUND_NET_SET;
//   &VREFN @ADD-TO $GROUND_NET_SET;
//   #XHCTL @PLACE(0, 20) => @ORIENT("R0");
//   #XDH @PLACE(19, 18) => @ORIENT("R0");
//   &HHIB @WIRE {#XHCTL:2 #XDH:1};
//   %j1 = (115, 20);
//   %j2 = (38, 20);
//   %j3 = (52, 20);
//   %j4 = (66, 20);
//   %j5 = (84, 20);
//   &BH @WIRE {#XDH:4 %j2 %j3 %j4 %j5};
//   #CH @PLACE(100, 20) => @ORIENT("R270");
//   #CH @TEXT("", key="value");
//   #CH @TEXT("", key="name");
//   (100, 22.2) @TEXT("CH", size=1.05);
//   (100, 16.8) @TEXT("1 Cu", size=1.05);
//   &BH @WIRE {%j5 #CH:2};
//   &TOP @WIRE {#CH:1 %j1};
//   #CPH @PLACE(84, 12) => @ORIENT("R0");
//   #CPH @TEXT("", key="value");
//   #CPH @TEXT("", key="name");
//   (86, 13) @TEXT("CPH", size=1.05);
//   (86, 11) @TEXT("0.05011 fF / 5%", size=1.05);
//   &BH @WIRE {%j5 #CPH:1};
//   #MSH @PLACE(38, 7) => @ORIENT("R0");
//   #MSH @SET-SYMBOL $NMOS;
//   #MSH @TEXT("ULVT 0.12u", key="model", size=1.05, dx=1.5, dy=-1);
//   #MSH @TEXT("MSH", key="name", size=1.1, dx=1.5, dy=1);
//   &BH @WIRE {%j2 #MSH:1};
//   #MEQ1 @PLACE(52, 7) => @ORIENT("MX");
//   #MEQ1 @SET-SYMBOL $PMOS;
//   #MEQ1 @TEXT("ULVT 0.12u", key="model", size=1.05, dx=1.5, dy=-1);
//   #MEQ1 @TEXT("MEQ1", key="name", size=1.1, dx=1.5, dy=1);
//   &BH @WIRE {%j3 #MEQ1:1};
//   #MSHAREH @PLACE(66, 7) => @ORIENT("R0");
//   #MSHAREH @SET-SYMBOL $NMOS;
//   #MSHAREH @TEXT("ULVT 0.12u", key="model", size=1.05, dx=1.5, dy=-1);
//   #MSHAREH @TEXT("MSHAREH", key="name", size=1.1, dx=1.5, dy=1);
//   &BH @WIRE {%j4 #MSHAREH:1};
//   (-8, 35) @TEXT("High bank", size=1.05);
//   #XLCTL @PLACE(0, -18) => @ORIENT("R0");
//   #XDL @PLACE(19, -20) => @ORIENT("R0");
//   &LHIB @WIRE {#XLCTL:2 #XDL:1};
//   %j6 = (115, -18);
//   %j7 = (38, -18);
//   %j8 = (52, -18);
//   %j9 = (66, -18);
//   %j10 = (84, -18);
//   &BL @WIRE {#XDL:4 %j7 %j8 %j9 %j10};
//   #CL @PLACE(100, -18) => @ORIENT("R270");
//   #CL @TEXT("", key="value");
//   #CL @TEXT("", key="name");
//   (100, -15.8) @TEXT("CL", size=1.05);
//   (100, -21.2) @TEXT("1 Cu", size=1.05);
//   &BL @WIRE {%j10 #CL:2};
//   &TOP @WIRE {#CL:1 %j6};
//   #CPL @PLACE(84, -26) => @ORIENT("R0");
//   #CPL @TEXT("", key="value");
//   #CPL @TEXT("", key="name");
//   (86, -25) @TEXT("CPL", size=1.05);
//   (86, -27) @TEXT("0.05011 fF / 5%", size=1.05);
//   &BL @WIRE {%j10 #CPL:1};
//   #MSL @PLACE(38, -31) => @ORIENT("R0");
//   #MSL @SET-SYMBOL $NMOS;
//   #MSL @TEXT("ULVT 0.12u", key="model", size=1.05, dx=1.5, dy=-1);
//   #MSL @TEXT("MSL", key="name", size=1.1, dx=1.5, dy=1);
//   &BL @WIRE {%j7 #MSL:1};
//   #MEQ2 @PLACE(52, -31) => @ORIENT("MX");
//   #MEQ2 @SET-SYMBOL $PMOS;
//   #MEQ2 @TEXT("ULVT 0.12u", key="model", size=1.05, dx=1.5, dy=-1);
//   #MEQ2 @TEXT("MEQ2", key="name", size=1.1, dx=1.5, dy=1);
//   &BL @WIRE {%j8 #MEQ2:1};
//   #MSHAREL @PLACE(66, -31) => @ORIENT("R0");
//   #MSHAREL @SET-SYMBOL $NMOS;
//   #MSHAREL @TEXT("ULVT 0.12u", key="model", size=1.05, dx=1.5, dy=-1);
//   #MSHAREL @TEXT("MSHAREL", key="name", size=1.1, dx=1.5, dy=1);
//   &BL @WIRE {%j9 #MSHAREL:1};
//   (-8, -3) @TEXT("Low bank", size=1.05);
//   &TOP @WIRE {%j1 %j6};
//   (116, -3) @TEXT("TOP", size=1.05);
//   (-8, -42) @TEXT("Cu = 1.00229 fF. Cp = 5% of every physical MOM, including series MID.", size=1.05);
//   (-8, -45) @TEXT("DH -> buffer; RL -> inverter. Control supply: DVDD / VREFN; body: VSS.", size=1.05);
//   (-8, -48) @TEXT("5% Cp is a user estimate, not extraction.", size=1.05);
//   &DH @WIRE {#XHCTL:1 (-6, 20)};
//   (-6.3, 20) @TEXT("DH", size=1.05, halign="end", valign="middle");
//   &EN @WIRE {#XDH:2 (9, 16)};
//   (8.7, 16) @TEXT("EN", size=1.05, halign="end", valign="middle");
//   &ENB @WIRE {#XDH:3 (9, 13)};
//   (8.7, 13) @TEXT("ENB", size=1.05, halign="end", valign="middle");
//   %t14 = $SUPPLY @ATTACH &VREFP => @PLACE(22, 29);
//   &VREFP @WIRE {#XDH:5 %t14:p};
//   %t15 = $GROUND @ATTACH &VREFN => @PLACE(22, 7);
//   &VREFN @WIRE {#XDH:6 %t15:p};
//   %t16 = $GROUND @ATTACH &VSS => @PLACE(16, 7);
//   &VSS @WIRE {#XDH:7 %t16:p};
//   %t17 = $SUPPLY @ATTACH &DVDD => @PLACE(16, 29);
//   &DVDD @WIRE {#XDH:8 %t17:p};
//   %t18 = $GROUND @ATTACH &VSS => @PLACE(84, 8);
//   &VSS @WIRE {#CPH:2 %t18:p};
//   &VG @WIRE {#MSH:2 (33, 7)};
//   (32.7, 10.2) @TEXT("VG", size=1.05, halign="end", valign="middle");
//   &VIN @WIRE {#MSH:3 (38, 3)};
//   (38, 2.4) @TEXT("VIN", size=1.05, halign="middle", valign="top");
//   &APGATE @WIRE {#MEQ1:2 (47, 7)};
//   (46.7, 10.2) @TEXT("APGATE", size=1.05, halign="end", valign="middle");
//   &VIN @WIRE {#MEQ1:3 (52, 3)};
//   (52, 2.4) @TEXT("VIN", size=1.05, halign="middle", valign="top");
//   &ENB @WIRE {#MSHAREH:2 (61, 7)};
//   (60.7, 10.2) @TEXT("ENB", size=1.05, halign="end", valign="middle");
//   &EQBUS @WIRE {#MSHAREH:3 (66, 3)};
//   (66, 2.4) @TEXT("EQBUS", size=1.05, halign="middle", valign="top");
//   &RL @WIRE {#XLCTL:1 (-6, -18)};
//   (-6.3, -18) @TEXT("RL", size=1.05, halign="end", valign="middle");
//   &EN @WIRE {#XDL:2 (9, -22)};
//   (8.7, -22) @TEXT("EN", size=1.05, halign="end", valign="middle");
//   &ENB @WIRE {#XDL:3 (9, -25)};
//   (8.7, -25) @TEXT("ENB", size=1.05, halign="end", valign="middle");
//   %t28 = $SUPPLY @ATTACH &VREFP => @PLACE(22, -9);
//   &VREFP @WIRE {#XDL:5 %t28:p};
//   %t29 = $GROUND @ATTACH &VREFN => @PLACE(22, -31);
//   &VREFN @WIRE {#XDL:6 %t29:p};
//   %t30 = $GROUND @ATTACH &VSS => @PLACE(16, -31);
//   &VSS @WIRE {#XDL:7 %t30:p};
//   %t31 = $SUPPLY @ATTACH &DVDD => @PLACE(16, -9);
//   &DVDD @WIRE {#XDL:8 %t31:p};
//   %t32 = $GROUND @ATTACH &VSS => @PLACE(84, -30);
//   &VSS @WIRE {#CPL:2 %t32:p};
//   &VG @WIRE {#MSL:2 (33, -31)};
//   (32.7, -27.8) @TEXT("VG", size=1.05, halign="end", valign="middle");
//   &VIN @WIRE {#MSL:3 (38, -35)};
//   (38, -35.6) @TEXT("VIN", size=1.05, halign="middle", valign="top");
//   &APGATE @WIRE {#MEQ2:2 (47, -31)};
//   (46.7, -27.8) @TEXT("APGATE", size=1.05, halign="end", valign="middle");
//   &VIN @WIRE {#MEQ2:3 (52, -35)};
//   (52, -35.6) @TEXT("VIN", size=1.05, halign="middle", valign="top");
//   &ENB @WIRE {#MSHAREL:2 (61, -31)};
//   (60.7, -27.8) @TEXT("ENB", size=1.05, halign="end", valign="middle");
//   &EQBUS @WIRE {#MSHAREL:3 (66, -35)};
//   (66, -35.6) @TEXT("EQBUS", size=1.05, halign="middle", valign="top");
//   $JUNCTION @ATTACH %j2;
//   $JUNCTION @ATTACH %j3;
//   $JUNCTION @ATTACH %j4;
//   $JUNCTION @ATTACH %j5;
//   $JUNCTION @ATTACH %j7;
//   $JUNCTION @ATTACH %j8;
//   $JUNCTION @ATTACH %j9;
//   $JUNCTION @ATTACH %j10;
//   (-8, 44) @TEXT("N4 formal candidate / WIP | weight 1: 2 | matched H/L banks", size=1.4, bold=true, textcolor="#17365d");
//   (-8, 41.6) @TEXT("Drawing only | N bulk = VSS; L = 30 nm. P bulk VREFP: MEQ1, MEQ2", size=1.05, textcolor="#52606d");
// }
ends mq_cdac_bit1

// Reference-rail output driver j=0
subckt mq_cdac_drv0 (HIB EN ENB BP VREFP VREFN VSS DVDD)
// DVDD prelogic: PCOND = NOR(ENB,HIB); NOFF = NAND(EN,HIB).
// Reference-powered final inverters restore GP and GN to VREFP/VREFN.
// Actual current overlap, settling and device stress require measurement.
MPA0 (AP ENB DVDD DVDD) pch_ulvt_mac w=2.4e-07 l=3e-08 nf=1
MPA1 (PCOND HIB AP DVDD) pch_ulvt_mac w=2.4e-07 l=3e-08 nf=1
MNA0 (PCOND ENB VREFN VSS) nch_ulvt_mac w=1.2e-07 l=3e-08 nf=1
MNA1 (PCOND HIB VREFN VSS) nch_ulvt_mac w=1.2e-07 l=3e-08 nf=1
MPB0 (NOFF EN DVDD DVDD) pch_ulvt_mac w=1.2e-07 l=3e-08 nf=1
MPB1 (NOFF HIB DVDD DVDD) pch_ulvt_mac w=1.2e-07 l=3e-08 nf=1
MNB0 (NOFF EN BN VSS) nch_ulvt_mac w=1.2e-07 l=3e-08 nf=1
MNB1 (BN HIB VREFN VSS) nch_ulvt_mac w=1.2e-07 l=3e-08 nf=1
MGPN (GP PCOND VREFN VSS) nch_mac w=2.4e-07 l=3e-08 nf=1
MGPP (GP PCOND VREFP VREFP) pch_mac w=3.6e-07 l=3e-08 nf=1
MGNN (GN NOFF VREFN VSS) nch_mac w=2.4e-07 l=3e-08 nf=1
MGNP (GN NOFF VREFP VREFP) pch_mac w=1.2e-07 l=3e-08 nf=1
MNOUT (BP GN VREFN VSS) nch_mac w=1.2e-07 l=3e-08 nf=1
MPOUT (BP GP VREFP VREFP) pch_mac w=2.4e-07 l=3e-08 nf=1
// @RNL {
//   {&HIB &EN &ENB &BP &VREFP &VREFN &VSS &DVDD} @REMOVE-FROM $PORT_FILL_SET;
//   &VSS @ADD-TO $GROUND_NET_SET;
//   &VREFN @ADD-TO $GROUND_NET_SET;
//   #MPA0 @PLACE(8, 32) => @ORIENT("R0");
//   #MPA0 @SET-SYMBOL $PMOS;
//   #MPA0 @TEXT("ULVT 0.24u", key="model", size=1.05, dx=1.5, dy=-1);
//   #MPA0 @TEXT("MPA0", key="name", size=1.1, dx=1.5, dy=1);
//   #MPA1 @PLACE(8, 24) => @ORIENT("R0");
//   #MPA1 @SET-SYMBOL $PMOS;
//   #MPA1 @TEXT("ULVT 0.24u", key="model", size=1.05, dx=1.5, dy=-1);
//   #MPA1 @TEXT("MPA1", key="name", size=1.1, dx=1.5, dy=1);
//   #MNA0 @PLACE(0, 8) => @ORIENT("R0");
//   #MNA0 @SET-SYMBOL $NMOS;
//   #MNA0 @TEXT("ULVT 0.12u", key="model", size=1.05, dx=1.5, dy=-1);
//   #MNA0 @TEXT("MNA0", key="name", size=1.1, dx=1.5, dy=1);
//   #MNA1 @PLACE(16, 8) => @ORIENT("R0");
//   #MNA1 @SET-SYMBOL $NMOS;
//   #MNA1 @TEXT("ULVT 0.12u", key="model", size=1.05, dx=1.5, dy=-1);
//   #MNA1 @TEXT("MNA1", key="name", size=1.1, dx=1.5, dy=1);
//   #MPB0 @PLACE(0, -8) => @ORIENT("R0");
//   #MPB0 @SET-SYMBOL $PMOS;
//   #MPB0 @TEXT("ULVT 0.12u", key="model", size=1.05, dx=1.5, dy=-1);
//   #MPB0 @TEXT("MPB0", key="name", size=1.1, dx=1.5, dy=1);
//   #MPB1 @PLACE(16, -8) => @ORIENT("R0");
//   #MPB1 @SET-SYMBOL $PMOS;
//   #MPB1 @TEXT("ULVT 0.12u", key="model", size=1.05, dx=1.5, dy=-1);
//   #MPB1 @TEXT("MPB1", key="name", size=1.1, dx=1.5, dy=1);
//   #MNB0 @PLACE(8, -24) => @ORIENT("R0");
//   #MNB0 @SET-SYMBOL $NMOS;
//   #MNB0 @TEXT("ULVT 0.12u", key="model", size=1.05, dx=1.5, dy=-1);
//   #MNB0 @TEXT("MNB0", key="name", size=1.1, dx=1.5, dy=1);
//   #MNB1 @PLACE(8, -32) => @ORIENT("R0");
//   #MNB1 @SET-SYMBOL $NMOS;
//   #MNB1 @TEXT("ULVT 0.12u", key="model", size=1.05, dx=1.5, dy=-1);
//   #MNB1 @TEXT("MNB1", key="name", size=1.1, dx=1.5, dy=1);
//   #MPOUT @PLACE(76, 18) => @ORIENT("R0");
//   #MPOUT @SET-SYMBOL $PMOS;
//   #MPOUT @TEXT("SVT 0.24u", key="model", size=1.05, dx=1.5, dy=-1);
//   #MPOUT @TEXT("MPOUT", key="name", size=1.1, dx=1.5, dy=1);
//   #MNOUT @PLACE(76, -18) => @ORIENT("R0");
//   #MNOUT @SET-SYMBOL $NMOS;
//   #MNOUT @TEXT("SVT 0.12u", key="model", size=1.05, dx=1.5, dy=-1);
//   #MNOUT @TEXT("MNOUT", key="name", size=1.1, dx=1.5, dy=1);
//   &AP @WIRE {#MPA0:1 #MPA1:3};
//   (10, 28) @TEXT("AP", size=1.05);
//   %j1 = (8, 16);
//   &PCOND @WIRE {#MNA0:1 (0, 16) %j1 (16, 16) #MNA1:1};
//   &PCOND @WIRE {#MPA1:1 %j1};
//   #MGPN @PLACE(43, 9) => @ORIENT("R0");
//   #MGPN @SET-SYMBOL $NMOS;
//   #MGPN @TEXT("SVT 0.24u", key="model", size=1.05, dx=1.5, dy=-1);
//   #MGPN @TEXT("MGPN", key="name", size=1.1, dx=1.5, dy=1);
//   #MGPP @PLACE(43, 23) => @ORIENT("R0");
//   #MGPP @SET-SYMBOL $PMOS;
//   #MGPP @TEXT("SVT 0.36u", key="model", size=1.05, dx=1.5, dy=-1);
//   #MGPP @TEXT("MGPP", key="name", size=1.1, dx=1.5, dy=1);
//   %j2 = (43, 16);
//   %j3 = (38, 16);
//   &GP @WIRE {#MGPN:1 %j2 #MGPP:1};
//   &PCOND @WIRE {#MGPN:2 (38, 9) %j3 (38, 23) #MGPP:2};
//   &PCOND @WIRE {%j1 %j3};
//   &GP @WIRE {%j2 (65, 16) (65, 18) #MPOUT:2};
//   %j4 = (8, -16);
//   &NOFF @WIRE {#MPB0:1 (0, -16) %j4 (16, -16) #MPB1:1};
//   &NOFF @WIRE {#MNB0:1 %j4};
//   &BN @WIRE {#MNB0:3 #MNB1:1};
//   (18, -14) @TEXT("NOFF", size=1.05);
//   #MGNN @PLACE(43, -23) => @ORIENT("R0");
//   #MGNN @SET-SYMBOL $NMOS;
//   #MGNN @TEXT("SVT 0.24u", key="model", size=1.05, dx=1.5, dy=-1);
//   #MGNN @TEXT("MGNN", key="name", size=1.1, dx=1.5, dy=1);
//   #MGNP @PLACE(43, -9) => @ORIENT("R0");
//   #MGNP @SET-SYMBOL $PMOS;
//   #MGNP @TEXT("SVT 0.12u", key="model", size=1.05, dx=1.5, dy=-1);
//   #MGNP @TEXT("MGNP", key="name", size=1.1, dx=1.5, dy=1);
//   %j5 = (43, -16);
//   %j6 = (38, -16);
//   &GN @WIRE {#MGNN:1 %j5 #MGNP:1};
//   &NOFF @WIRE {#MGNN:2 (38, -23) %j6 (38, -9) #MGNP:2};
//   &NOFF @WIRE {%j4 %j6};
//   &GN @WIRE {%j5 (65, -16) (65, -18) #MNOUT:2};
//   %j7 = (76, 0);
//   &BP @WIRE {#MPOUT:1 %j7 #MNOUT:1};
//   &BP @WIRE {%j7 (85, 0)};
//   (85, 1) @TEXT("BP", size=1.05);
//   (-5, 42) @TEXT("NOR: PCOND = ~(ENB | HIB)", size=1.05);
//   (-5, -42) @TEXT("NAND: NOFF = ~(EN & HIB)", size=1.05);
//   (31, 39) @TEXT("Reference gate drivers", size=1.05);
//   (67, 39) @TEXT("Output rail switch", size=1.05);
//   &ENB @WIRE {#MPA0:2 (3, 32)};
//   (2.7, 32) @TEXT("ENB", size=1.05, halign="end", valign="middle");
//   %t9 = $SUPPLY @ATTACH &DVDD => @PLACE(8, 36);
//   &DVDD @WIRE {#MPA0:3 %t9:p};
//   &HIB @WIRE {#MPA1:2 (3, 24)};
//   (2.7, 24) @TEXT("HIB", size=1.05, halign="end", valign="middle");
//   &ENB @WIRE {#MNA0:2 (-5, 8)};
//   (-5.3, 8) @TEXT("ENB", size=1.05, halign="end", valign="middle");
//   %t12 = $GROUND @ATTACH &VREFN => @PLACE(0, 4);
//   &VREFN @WIRE {#MNA0:3 %t12:p};
//   &HIB @WIRE {#MNA1:2 (11, 8)};
//   (10.7, 8) @TEXT("HIB", size=1.05, halign="end", valign="middle");
//   %t14 = $GROUND @ATTACH &VREFN => @PLACE(16, 4);
//   &VREFN @WIRE {#MNA1:3 %t14:p};
//   &EN @WIRE {#MPB0:2 (-5, -8)};
//   (-5.3, -8) @TEXT("EN", size=1.05, halign="end", valign="middle");
//   %t16 = $SUPPLY @ATTACH &DVDD => @PLACE(0, -4);
//   &DVDD @WIRE {#MPB0:3 %t16:p};
//   &HIB @WIRE {#MPB1:2 (11, -8)};
//   (10.7, -8) @TEXT("HIB", size=1.05, halign="end", valign="middle");
//   %t18 = $SUPPLY @ATTACH &DVDD => @PLACE(16, -4);
//   &DVDD @WIRE {#MPB1:3 %t18:p};
//   &EN @WIRE {#MNB0:2 (3, -24)};
//   (2.7, -24) @TEXT("EN", size=1.05, halign="end", valign="middle");
//   &HIB @WIRE {#MNB1:2 (3, -32)};
//   (2.7, -32) @TEXT("HIB", size=1.05, halign="end", valign="middle");
//   %t21 = $GROUND @ATTACH &VREFN => @PLACE(8, -36);
//   &VREFN @WIRE {#MNB1:3 %t21:p};
//   %t22 = $SUPPLY @ATTACH &VREFP => @PLACE(76, 22);
//   &VREFP @WIRE {#MPOUT:3 %t22:p};
//   %t23 = $GROUND @ATTACH &VREFN => @PLACE(76, -22);
//   &VREFN @WIRE {#MNOUT:3 %t23:p};
//   %t24 = $GROUND @ATTACH &VREFN => @PLACE(43, 5);
//   &VREFN @WIRE {#MGPN:3 %t24:p};
//   %t25 = $SUPPLY @ATTACH &VREFP => @PLACE(43, 27);
//   &VREFP @WIRE {#MGPP:3 %t25:p};
//   %t26 = $GROUND @ATTACH &VREFN => @PLACE(43, -27);
//   &VREFN @WIRE {#MGNN:3 %t26:p};
//   %t27 = $SUPPLY @ATTACH &VREFP => @PLACE(43, -5);
//   &VREFP @WIRE {#MGNP:3 %t27:p};
//   $JUNCTION @ATTACH %j1;
//   $JUNCTION @ATTACH %j2;
//   $JUNCTION @ATTACH %j3;
//   $JUNCTION @ATTACH %j4;
//   $JUNCTION @ATTACH %j5;
//   $JUNCTION @ATTACH %j6;
//   $JUNCTION @ATTACH %j7;
//   (-7, 51) @TEXT("N4 formal candidate / WIP | mq_cdac_drv0 | isolated DVDD logic / VREFP output", size=1.4, bold=true, textcolor="#17365d");
//   (-7, 48.6) @TEXT("Drawing only | N bulk = VSS; L = 30 nm. P bulk DVDD: MPA0, MPA1, MPB0, MPB1; VREFP: MGPP, MGNP, MPOUT", size=1.05, textcolor="#52606d");
// }
ends mq_cdac_drv0

// Matched half-capacitor pair j=0
subckt mq_cdac_bit0 (VIN VG DH RL EN ENB TOP VREFP VREFN VSS PHI_S DVDD PHI_SB EQBUS APGATE)
// CP*: user-specified 5% bottom-plate estimate for every physical MOM unit, not extraction.
// Series tails retain one unit parasitic at MID and one at B.
// APGATE PMOS assist connects each bottom plate to VIN.
// MID-to-VIN transmission gates provide physical initialization during PHI_S.
// Additional ENB NMOS sharing retains a common EQBUS.
XHCTL (DH HHIB DVDD VREFN VSS) mq_cdac_ctl_h
XLCTL (RL LHIB DVDD VREFN VSS) mq_cdac_ctl_l
XDH (HHIB EN ENB BH VREFP VREFN VSS DVDD) mq_cdac_drv0
CHA (TOP MIDH) cfmom_2t w=5e-08 s=2.4e-07 nr=6 lr=1.69e-06 stm=2 spm=4 multi=1
CPHA (MIDH VSS) capacitor c=5.01145e-17
CHB (MIDH BH) cfmom_2t w=5e-08 s=2.4e-07 nr=6 lr=1.69e-06 stm=2 spm=4 multi=1
CPHB (BH VSS) capacitor c=5.01145e-17
MSH (BH VG VIN VSS) nch_ulvt_mac w=1.2e-07 l=3e-08 nf=1
XDL (LHIB EN ENB BL VREFP VREFN VSS DVDD) mq_cdac_drv0
CLA (TOP MIDL) cfmom_2t w=5e-08 s=2.4e-07 nr=6 lr=1.69e-06 stm=2 spm=4 multi=1
CPLA (MIDL VSS) capacitor c=5.01145e-17
CLB (MIDL BL) cfmom_2t w=5e-08 s=2.4e-07 nr=6 lr=1.69e-06 stm=2 spm=4 multi=1
CPLB (BL VSS) capacitor c=5.01145e-17
MSL (BL VG VIN VSS) nch_ulvt_mac w=1.2e-07 l=3e-08 nf=1
MEQ1 (BH APGATE VIN VREFP) pch_ulvt_mac w=1.2e-07 l=3e-08 nf=1
MEQ2 (BL APGATE VIN VREFP) pch_ulvt_mac w=1.2e-07 l=3e-08 nf=1
MMIDNH (MIDH PHI_S VIN VSS) nch_ulvt_mac w=1.2e-07 l=3e-08 nf=1
MMIDPH (MIDH PHI_SB VIN VREFP) pch_mac w=1.2e-07 l=3e-08 nf=1
MMIDNL (MIDL PHI_S VIN VSS) nch_ulvt_mac w=1.2e-07 l=3e-08 nf=1
MMIDPL (MIDL PHI_SB VIN VREFP) pch_mac w=1.2e-07 l=3e-08 nf=1
MSHAREH (BH ENB EQBUS VSS) nch_ulvt_mac w=1.2e-07 l=3e-08 nf=1
MSHAREL (BL ENB EQBUS VSS) nch_ulvt_mac w=1.2e-07 l=3e-08 nf=1
// @RNL {
//   {&VIN &VG &DH &RL &EN &ENB &TOP &VREFP &VREFN &VSS &PHI_S &DVDD &PHI_SB &EQBUS &APGATE} @REMOVE-FROM $PORT_FILL_SET;
//   &VSS @ADD-TO $GROUND_NET_SET;
//   &VREFN @ADD-TO $GROUND_NET_SET;
//   #XHCTL @PLACE(0, 20) => @ORIENT("R0");
//   #XDH @PLACE(19, 18) => @ORIENT("R0");
//   &HHIB @WIRE {#XHCTL:2 #XDH:1};
//   %j1 = (115, 20);
//   %j2 = (38, 20);
//   %j3 = (52, 20);
//   %j4 = (66, 20);
//   %j5 = (84, 20);
//   &BH @WIRE {#XDH:4 %j2 %j3 %j4 %j5};
//   #CHA @PLACE(106, 40) => @ORIENT("R270");
//   #CHA @TEXT("", key="value");
//   #CHA @TEXT("", key="name");
//   (106, 42.2) @TEXT("CHA", size=1.05);
//   (106, 36.8) @TEXT("1 Cu", size=1.05);
//   #CHB @PLACE(84, 40) => @ORIENT("R270");
//   #CHB @TEXT("", key="value");
//   #CHB @TEXT("", key="name");
//   (84, 42.2) @TEXT("CHB", size=1.05);
//   (84, 36.8) @TEXT("1 Cu", size=1.05);
//   &BH @WIRE {%j5 (76, 20) (76, 40) #CHB:2};
//   %j6 = (94, 40);
//   &MIDH @WIRE {#CHB:1 %j6 #CHA:2};
//   (94, 42) @TEXT("MIDH", size=1.05);
//   %j7 = (115, 40);
//   &TOP @WIRE {#CHA:1 %j7};
//   #CPHA @PLACE(94, 31) => @ORIENT("R0");
//   #CPHA @TEXT("", key="value");
//   #CPHA @TEXT("", key="name");
//   (96, 32) @TEXT("CPHA", size=1.05);
//   (96, 30) @TEXT("0.05011 fF / 5%", size=1.05);
//   &MIDH @WIRE {%j6 #CPHA:1};
//   #CPHB @PLACE(98, 12) => @ORIENT("R0");
//   #CPHB @TEXT("", key="value");
//   #CPHB @TEXT("", key="name");
//   (100, 13) @TEXT("CPHB", size=1.05);
//   (100, 11) @TEXT("0.05011 fF / 5%", size=1.05);
//   &BH @WIRE {%j5 (98, 20) #CPHB:1};
//   #MSH @PLACE(38, 7) => @ORIENT("R0");
//   #MSH @SET-SYMBOL $NMOS;
//   #MSH @TEXT("ULVT 0.12u", key="model", size=1.05, dx=1.5, dy=-1);
//   #MSH @TEXT("MSH", key="name", size=1.1, dx=1.5, dy=1);
//   &BH @WIRE {%j2 #MSH:1};
//   #MEQ1 @PLACE(52, 7) => @ORIENT("MX");
//   #MEQ1 @SET-SYMBOL $PMOS;
//   #MEQ1 @TEXT("ULVT 0.12u", key="model", size=1.05, dx=1.5, dy=-1);
//   #MEQ1 @TEXT("MEQ1", key="name", size=1.1, dx=1.5, dy=1);
//   &BH @WIRE {%j3 #MEQ1:1};
//   #MSHAREH @PLACE(66, 7) => @ORIENT("R0");
//   #MSHAREH @SET-SYMBOL $NMOS;
//   #MSHAREH @TEXT("ULVT 0.12u", key="model", size=1.05, dx=1.5, dy=-1);
//   #MSHAREH @TEXT("MSHAREH", key="name", size=1.1, dx=1.5, dy=1);
//   &BH @WIRE {%j4 #MSHAREH:1};
//   #MMIDNH @PLACE(126, 14) => @ORIENT("R0");
//   #MMIDNH @SET-SYMBOL $NMOS;
//   #MMIDNH @TEXT("ULVT 0.12u", key="model", size=1.05, dx=1.5, dy=-1);
//   #MMIDNH @TEXT("MMIDNH", key="name", size=1.1, dx=1.5, dy=1);
//   #MMIDPH @PLACE(142, 14) => @ORIENT("MX");
//   #MMIDPH @SET-SYMBOL $PMOS;
//   #MMIDPH @TEXT("SVT 0.12u", key="model", size=1.05, dx=1.5, dy=-1);
//   #MMIDPH @TEXT("MMIDPH", key="name", size=1.1, dx=1.5, dy=1);
//   &MIDH @WIRE {#MMIDNH:1 (126, 23) (142, 23) #MMIDPH:1};
//   (132, 24) @TEXT("MIDH", size=1.05);
//   (123, 27) @TEXT("MIDH sampling TG", size=1.05);
//   (-8, 35) @TEXT("High bank", size=1.05);
//   #XLCTL @PLACE(0, -27) => @ORIENT("R0");
//   #XDL @PLACE(19, -29) => @ORIENT("R0");
//   &LHIB @WIRE {#XLCTL:2 #XDL:1};
//   %j8 = (115, -27);
//   %j9 = (38, -27);
//   %j10 = (52, -27);
//   %j11 = (66, -27);
//   %j12 = (84, -27);
//   &BL @WIRE {#XDL:4 %j9 %j10 %j11 %j12};
//   #CLA @PLACE(106, -7) => @ORIENT("R270");
//   #CLA @TEXT("", key="value");
//   #CLA @TEXT("", key="name");
//   (106, -4.8) @TEXT("CLA", size=1.05);
//   (106, -10.2) @TEXT("1 Cu", size=1.05);
//   #CLB @PLACE(84, -7) => @ORIENT("R270");
//   #CLB @TEXT("", key="value");
//   #CLB @TEXT("", key="name");
//   (84, -4.8) @TEXT("CLB", size=1.05);
//   (84, -10.2) @TEXT("1 Cu", size=1.05);
//   &BL @WIRE {%j12 (76, -27) (76, -7) #CLB:2};
//   %j13 = (94, -7);
//   &MIDL @WIRE {#CLB:1 %j13 #CLA:2};
//   (94, -5) @TEXT("MIDL", size=1.05);
//   %j14 = (115, -7);
//   &TOP @WIRE {#CLA:1 %j14};
//   #CPLA @PLACE(94, -16) => @ORIENT("R0");
//   #CPLA @TEXT("", key="value");
//   #CPLA @TEXT("", key="name");
//   (96, -15) @TEXT("CPLA", size=1.05);
//   (96, -17) @TEXT("0.05011 fF / 5%", size=1.05);
//   &MIDL @WIRE {%j13 #CPLA:1};
//   #CPLB @PLACE(98, -35) => @ORIENT("R0");
//   #CPLB @TEXT("", key="value");
//   #CPLB @TEXT("", key="name");
//   (100, -34) @TEXT("CPLB", size=1.05);
//   (100, -36) @TEXT("0.05011 fF / 5%", size=1.05);
//   &BL @WIRE {%j12 (98, -27) #CPLB:1};
//   #MSL @PLACE(38, -40) => @ORIENT("R0");
//   #MSL @SET-SYMBOL $NMOS;
//   #MSL @TEXT("ULVT 0.12u", key="model", size=1.05, dx=1.5, dy=-1);
//   #MSL @TEXT("MSL", key="name", size=1.1, dx=1.5, dy=1);
//   &BL @WIRE {%j9 #MSL:1};
//   #MEQ2 @PLACE(52, -40) => @ORIENT("MX");
//   #MEQ2 @SET-SYMBOL $PMOS;
//   #MEQ2 @TEXT("ULVT 0.12u", key="model", size=1.05, dx=1.5, dy=-1);
//   #MEQ2 @TEXT("MEQ2", key="name", size=1.1, dx=1.5, dy=1);
//   &BL @WIRE {%j10 #MEQ2:1};
//   #MSHAREL @PLACE(66, -40) => @ORIENT("R0");
//   #MSHAREL @SET-SYMBOL $NMOS;
//   #MSHAREL @TEXT("ULVT 0.12u", key="model", size=1.05, dx=1.5, dy=-1);
//   #MSHAREL @TEXT("MSHAREL", key="name", size=1.1, dx=1.5, dy=1);
//   &BL @WIRE {%j11 #MSHAREL:1};
//   #MMIDNL @PLACE(126, -33) => @ORIENT("R0");
//   #MMIDNL @SET-SYMBOL $NMOS;
//   #MMIDNL @TEXT("ULVT 0.12u", key="model", size=1.05, dx=1.5, dy=-1);
//   #MMIDNL @TEXT("MMIDNL", key="name", size=1.1, dx=1.5, dy=1);
//   #MMIDPL @PLACE(142, -33) => @ORIENT("MX");
//   #MMIDPL @SET-SYMBOL $PMOS;
//   #MMIDPL @TEXT("SVT 0.12u", key="model", size=1.05, dx=1.5, dy=-1);
//   #MMIDPL @TEXT("MMIDPL", key="name", size=1.1, dx=1.5, dy=1);
//   &MIDL @WIRE {#MMIDNL:1 (126, -24) (142, -24) #MMIDPL:1};
//   (132, -23) @TEXT("MIDL", size=1.05);
//   (123, -20) @TEXT("MIDL sampling TG", size=1.05);
//   (-8, -12) @TEXT("Low bank", size=1.05);
//   &TOP @WIRE {%j7 %j1 %j14 %j8};
//   (116, -3) @TEXT("TOP", size=1.05);
//   (-8, -51) @TEXT("Cu = 1.00229 fF. Cp = 5% of every physical MOM, including series MID.", size=1.05);
//   (-8, -54) @TEXT("DH -> buffer; RL -> inverter. Control supply: DVDD / VREFN; body: VSS.", size=1.05);
//   (-8, -57) @TEXT("5% Cp is a user estimate, not extraction.", size=1.05);
//   &DH @WIRE {#XHCTL:1 (-6, 20)};
//   (-6.3, 20) @TEXT("DH", size=1.05, halign="end", valign="middle");
//   &EN @WIRE {#XDH:2 (9, 16)};
//   (8.7, 16) @TEXT("EN", size=1.05, halign="end", valign="middle");
//   &ENB @WIRE {#XDH:3 (9, 13)};
//   (8.7, 13) @TEXT("ENB", size=1.05, halign="end", valign="middle");
//   %t18 = $SUPPLY @ATTACH &VREFP => @PLACE(22, 29);
//   &VREFP @WIRE {#XDH:5 %t18:p};
//   %t19 = $GROUND @ATTACH &VREFN => @PLACE(22, 7);
//   &VREFN @WIRE {#XDH:6 %t19:p};
//   %t20 = $GROUND @ATTACH &VSS => @PLACE(16, 7);
//   &VSS @WIRE {#XDH:7 %t20:p};
//   %t21 = $SUPPLY @ATTACH &DVDD => @PLACE(16, 29);
//   &DVDD @WIRE {#XDH:8 %t21:p};
//   %t22 = $GROUND @ATTACH &VSS => @PLACE(94, 27);
//   &VSS @WIRE {#CPHA:2 %t22:p};
//   %t23 = $GROUND @ATTACH &VSS => @PLACE(98, 8);
//   &VSS @WIRE {#CPHB:2 %t23:p};
//   &VG @WIRE {#MSH:2 (33, 7)};
//   (32.7, 10.2) @TEXT("VG", size=1.05, halign="end", valign="middle");
//   &VIN @WIRE {#MSH:3 (38, 3)};
//   (38, 2.4) @TEXT("VIN", size=1.05, halign="middle", valign="top");
//   &APGATE @WIRE {#MEQ1:2 (47, 7)};
//   (46.7, 10.2) @TEXT("APGATE", size=1.05, halign="end", valign="middle");
//   &VIN @WIRE {#MEQ1:3 (52, 3)};
//   (52, 2.4) @TEXT("VIN", size=1.05, halign="middle", valign="top");
//   &ENB @WIRE {#MSHAREH:2 (61, 7)};
//   (60.7, 10.2) @TEXT("ENB", size=1.05, halign="end", valign="middle");
//   &EQBUS @WIRE {#MSHAREH:3 (66, 3)};
//   (66, 2.4) @TEXT("EQBUS", size=1.05, halign="middle", valign="top");
//   &PHI_S @WIRE {#MMIDNH:2 (121, 14)};
//   (120.7, 17.2) @TEXT("PHI_S", size=1.05, halign="end", valign="middle");
//   &VIN @WIRE {#MMIDNH:3 (126, 10)};
//   (126, 9.4) @TEXT("VIN", size=1.05, halign="middle", valign="top");
//   &PHI_SB @WIRE {#MMIDPH:2 (137, 14)};
//   (136.7, 17.2) @TEXT("PHI_SB", size=1.05, halign="end", valign="middle");
//   &VIN @WIRE {#MMIDPH:3 (142, 10)};
//   (142, 9.4) @TEXT("VIN", size=1.05, halign="middle", valign="top");
//   &RL @WIRE {#XLCTL:1 (-6, -27)};
//   (-6.3, -27) @TEXT("RL", size=1.05, halign="end", valign="middle");
//   &EN @WIRE {#XDL:2 (9, -31)};
//   (8.7, -31) @TEXT("EN", size=1.05, halign="end", valign="middle");
//   &ENB @WIRE {#XDL:3 (9, -34)};
//   (8.7, -34) @TEXT("ENB", size=1.05, halign="end", valign="middle");
//   %t37 = $SUPPLY @ATTACH &VREFP => @PLACE(22, -18);
//   &VREFP @WIRE {#XDL:5 %t37:p};
//   %t38 = $GROUND @ATTACH &VREFN => @PLACE(22, -40);
//   &VREFN @WIRE {#XDL:6 %t38:p};
//   %t39 = $GROUND @ATTACH &VSS => @PLACE(16, -40);
//   &VSS @WIRE {#XDL:7 %t39:p};
//   %t40 = $SUPPLY @ATTACH &DVDD => @PLACE(16, -18);
//   &DVDD @WIRE {#XDL:8 %t40:p};
//   %t41 = $GROUND @ATTACH &VSS => @PLACE(94, -20);
//   &VSS @WIRE {#CPLA:2 %t41:p};
//   %t42 = $GROUND @ATTACH &VSS => @PLACE(98, -39);
//   &VSS @WIRE {#CPLB:2 %t42:p};
//   &VG @WIRE {#MSL:2 (33, -40)};
//   (32.7, -36.8) @TEXT("VG", size=1.05, halign="end", valign="middle");
//   &VIN @WIRE {#MSL:3 (38, -44)};
//   (38, -44.6) @TEXT("VIN", size=1.05, halign="middle", valign="top");
//   &APGATE @WIRE {#MEQ2:2 (47, -40)};
//   (46.7, -36.8) @TEXT("APGATE", size=1.05, halign="end", valign="middle");
//   &VIN @WIRE {#MEQ2:3 (52, -44)};
//   (52, -44.6) @TEXT("VIN", size=1.05, halign="middle", valign="top");
//   &ENB @WIRE {#MSHAREL:2 (61, -40)};
//   (60.7, -36.8) @TEXT("ENB", size=1.05, halign="end", valign="middle");
//   &EQBUS @WIRE {#MSHAREL:3 (66, -44)};
//   (66, -44.6) @TEXT("EQBUS", size=1.05, halign="middle", valign="top");
//   &PHI_S @WIRE {#MMIDNL:2 (121, -33)};
//   (120.7, -29.8) @TEXT("PHI_S", size=1.05, halign="end", valign="middle");
//   &VIN @WIRE {#MMIDNL:3 (126, -37)};
//   (126, -37.6) @TEXT("VIN", size=1.05, halign="middle", valign="top");
//   &PHI_SB @WIRE {#MMIDPL:2 (137, -33)};
//   (136.7, -29.8) @TEXT("PHI_SB", size=1.05, halign="end", valign="middle");
//   &VIN @WIRE {#MMIDPL:3 (142, -37)};
//   (142, -37.6) @TEXT("VIN", size=1.05, halign="middle", valign="top");
//   $JUNCTION @ATTACH %j2;
//   $JUNCTION @ATTACH %j3;
//   $JUNCTION @ATTACH %j4;
//   $JUNCTION @ATTACH %j6;
//   $JUNCTION @ATTACH %j9;
//   $JUNCTION @ATTACH %j10;
//   $JUNCTION @ATTACH %j11;
//   $JUNCTION @ATTACH %j13;
//   $JUNCTION @ATTACH %j14;
//   (-8, 57) @TEXT("N4 formal candidate / WIP | weight 0: 1 | matched H/L banks | unit series tail", size=1.4, bold=true, textcolor="#17365d");
//   (-8, 54.6) @TEXT("Drawing only | N bulk = VSS; L = 30 nm. P bulk VREFP: MEQ1, MEQ2, MMIDPH, MMIDPL", size=1.05, textcolor="#52606d");
// }
ends mq_cdac_bit0

// Physical sampling-entry assistance pulse
subckt mq_cdac_assist_pulse (PHI_S PHI_SB AGATE DVDD VREFN VSS)
// MOS gate loads delay a PHI_S inverter; two inverters restore the delayed control.
// The pass TG first passes PHI_SB to AGATE, then a PMOS pulls AGATE to DVDD.
// The pulse duration and overlap require PVT, startup and full-circuit verification.
M0N (D0 PHI_S VREFN VSS) nch_ulvt_mac w=4e-07 l=3e-08 nf=1
M0P (D0 PHI_S DVDD DVDD) pch_mac w=8e-07 l=3e-08 nf=1
MLOAD0 (VREFN D0 VREFN VSS) nch_ulvt_mac w=2.4e-05 l=3e-08 nf=12
MLOAD1 (VREFN D0 VREFN VSS) nch_ulvt_mac w=2.4e-05 l=3e-08 nf=12
MLOAD2 (VREFN D0 VREFN VSS) nch_ulvt_mac w=2.4e-05 l=3e-08 nf=12
MLOAD3 (VREFN D0 VREFN VSS) nch_ulvt_mac w=2.4e-05 l=3e-08 nf=12
M1N (D1 D0 VREFN VSS) nch_ulvt_mac w=2e-06 l=3e-08 nf=1
M1P (D1 D0 DVDD DVDD) pch_ulvt_mac w=4e-06 l=3e-08 nf=2
M2N (D2 D1 VREFN VSS) nch_ulvt_mac w=4e-06 l=3e-08 nf=2
M2P (D2 D1 DVDD DVDD) pch_mac w=8e-06 l=3e-08 nf=4
MNPASS (AGATE D2 PHI_SB VSS) nch_ulvt_mac w=4e-06 l=3e-08 nf=2
MPPASS (AGATE D1 PHI_SB DVDD) pch_mac w=8e-06 l=3e-08 nf=4
MPUP (AGATE D2 DVDD DVDD) pch_mac w=8e-06 l=3e-08 nf=4
// @RNL {
//   {&PHI_S &PHI_SB &AGATE &DVDD &VREFN &VSS} @REMOVE-FROM $PORT_FILL_SET;
//   &VSS @ADD-TO $GROUND_NET_SET;
//   &VREFN @ADD-TO $GROUND_NET_SET;
//   #M0N @PLACE(8, 7) => @ORIENT("R0");
//   #M0N @SET-SYMBOL $NMOS;
//   #M0N @TEXT("ULVT 0.4u", key="model", size=1.05, dx=1.5, dy=-1);
//   #M0N @TEXT("M0N", key="name", size=1.1, dx=1.5, dy=1);
//   #M0P @PLACE(8, 21) => @ORIENT("R0");
//   #M0P @SET-SYMBOL $PMOS;
//   #M0P @TEXT("SVT 0.8u", key="model", size=1.05, dx=1.5, dy=-1);
//   #M0P @TEXT("M0P", key="name", size=1.1, dx=1.5, dy=1);
//   %j1 = (8, 14);
//   %j2 = (3, 14);
//   &D0 @WIRE {#M0N:1 %j1 #M0P:1};
//   &PHI_S @WIRE {#M0N:2 (3, 7) %j2 (3, 21) #M0P:2};
//   #M1N @PLACE(34, 7) => @ORIENT("R0");
//   #M1N @SET-SYMBOL $NMOS;
//   #M1N @TEXT("ULVT 2u", key="model", size=1.05, dx=1.5, dy=-1);
//   #M1N @TEXT("M1N", key="name", size=1.1, dx=1.5, dy=1);
//   #M1P @PLACE(34, 21) => @ORIENT("R0");
//   #M1P @SET-SYMBOL $PMOS;
//   #M1P @TEXT("ULVT 4u", key="model", size=1.05, dx=1.5, dy=-1);
//   #M1P @TEXT("M1P", key="name", size=1.1, dx=1.5, dy=1);
//   %j3 = (34, 14);
//   %j4 = (29, 14);
//   &D1 @WIRE {#M1N:1 %j3 #M1P:1};
//   &D0 @WIRE {#M1N:2 (29, 7) %j4 (29, 21) #M1P:2};
//   &D0 @WIRE {%j1 %j4};
//   #M2N @PLACE(60, 7) => @ORIENT("R0");
//   #M2N @SET-SYMBOL $NMOS;
//   #M2N @TEXT("ULVT 4u", key="model", size=1.05, dx=1.5, dy=-1);
//   #M2N @TEXT("M2N", key="name", size=1.1, dx=1.5, dy=1);
//   #M2P @PLACE(60, 21) => @ORIENT("R0");
//   #M2P @SET-SYMBOL $PMOS;
//   #M2P @TEXT("SVT 8u", key="model", size=1.05, dx=1.5, dy=-1);
//   #M2P @TEXT("M2P", key="name", size=1.1, dx=1.5, dy=1);
//   %j5 = (60, 14);
//   %j6 = (55, 14);
//   &D2 @WIRE {#M2N:1 %j5 #M2P:1};
//   &D1 @WIRE {#M2N:2 (55, 7) %j6 (55, 21) #M2P:2};
//   &D1 @WIRE {%j3 %j6};
//   #MLOAD0 @PLACE(0, -16) => @ORIENT("R0");
//   #MLOAD0 @SET-SYMBOL $NMOS;
//   #MLOAD0 @TEXT("ULVT 24u", key="model", size=1.05, dx=1.5, dy=-1);
//   #MLOAD0 @TEXT("MLOAD0", key="name", size=1.1, dx=1.5, dy=1);
//   %j7 = (7, -18);
//   &VREFN @WIRE {#MLOAD0:1 (7, -14) %j7 #MLOAD0:3};
//   &VREFN @WIRE {%j7 (7, -21)};
//   $GROUND @ATTACH &VREFN => @PLACE(7, -21);
//   #MLOAD1 @PLACE(16, -16) => @ORIENT("R0");
//   #MLOAD1 @SET-SYMBOL $NMOS;
//   #MLOAD1 @TEXT("ULVT 24u", key="model", size=1.05, dx=1.5, dy=-1);
//   #MLOAD1 @TEXT("MLOAD1", key="name", size=1.1, dx=1.5, dy=1);
//   %j8 = (23, -18);
//   &VREFN @WIRE {#MLOAD1:1 (23, -14) %j8 #MLOAD1:3};
//   &VREFN @WIRE {%j8 (23, -21)};
//   $GROUND @ATTACH &VREFN => @PLACE(23, -21);
//   #MLOAD2 @PLACE(32, -16) => @ORIENT("R0");
//   #MLOAD2 @SET-SYMBOL $NMOS;
//   #MLOAD2 @TEXT("ULVT 24u", key="model", size=1.05, dx=1.5, dy=-1);
//   #MLOAD2 @TEXT("MLOAD2", key="name", size=1.1, dx=1.5, dy=1);
//   %j9 = (39, -18);
//   &VREFN @WIRE {#MLOAD2:1 (39, -14) %j9 #MLOAD2:3};
//   &VREFN @WIRE {%j9 (39, -21)};
//   $GROUND @ATTACH &VREFN => @PLACE(39, -21);
//   #MLOAD3 @PLACE(48, -16) => @ORIENT("R0");
//   #MLOAD3 @SET-SYMBOL $NMOS;
//   #MLOAD3 @TEXT("ULVT 24u", key="model", size=1.05, dx=1.5, dy=-1);
//   #MLOAD3 @TEXT("MLOAD3", key="name", size=1.1, dx=1.5, dy=1);
//   %j10 = (55, -18);
//   &VREFN @WIRE {#MLOAD3:1 (55, -14) %j10 #MLOAD3:3};
//   &VREFN @WIRE {%j10 (55, -21)};
//   $GROUND @ATTACH &VREFN => @PLACE(55, -21);
//   (10, 15) @TEXT("D0", size=1.05);
//   (36, 15) @TEXT("D1", size=1.05);
//   (62, 15) @TEXT("D2", size=1.05);
//   &PHI_S @WIRE {%j2 (-3, 14)};
//   (-3, 15) @TEXT("PHI_S", size=1.05);
//   (-5, -28) @TEXT("D0 delay load: four physical MOS gates", size=1.05);
//   #MPPASS @PLACE(89, 12) => @ORIENT("MX");
//   #MPPASS @SET-SYMBOL $PMOS;
//   #MPPASS @TEXT("SVT 8u", key="model", size=1.05, dx=1.5, dy=-1);
//   #MPPASS @TEXT("MPPASS", key="name", size=1.1, dx=1.5, dy=1);
//   #MNPASS @PLACE(89, -2) => @ORIENT("R0");
//   #MNPASS @SET-SYMBOL $NMOS;
//   #MNPASS @TEXT("ULVT 4u", key="model", size=1.05, dx=1.5, dy=-1);
//   #MNPASS @TEXT("MNPASS", key="name", size=1.1, dx=1.5, dy=1);
//   #MPUP @PLACE(112, 21) => @ORIENT("R0");
//   #MPUP @SET-SYMBOL $PMOS;
//   #MPUP @TEXT("SVT 8u", key="model", size=1.05, dx=1.5, dy=-1);
//   #MPUP @TEXT("MPUP", key="name", size=1.1, dx=1.5, dy=1);
//   %j11 = (101, 7);
//   &AGATE @WIRE {#MPPASS:1 (101, 14) %j11 (101, 0) #MNPASS:1};
//   &AGATE @WIRE {%j11 (112, 7) #MPUP:1};
//   (116, 7) @TEXT("AGATE", size=1.05);
//   (79, 32) @TEXT("Delayed transmission gate + pull-up", size=1.05);
//   %t12 = $GROUND @ATTACH &VREFN => @PLACE(8, 3);
//   &VREFN @WIRE {#M0N:3 %t12:p};
//   %t13 = $SUPPLY @ATTACH &DVDD => @PLACE(8, 25);
//   &DVDD @WIRE {#M0P:3 %t13:p};
//   %t14 = $GROUND @ATTACH &VREFN => @PLACE(34, 3);
//   &VREFN @WIRE {#M1N:3 %t14:p};
//   %t15 = $SUPPLY @ATTACH &DVDD => @PLACE(34, 25);
//   &DVDD @WIRE {#M1P:3 %t15:p};
//   %t16 = $GROUND @ATTACH &VREFN => @PLACE(60, 3);
//   &VREFN @WIRE {#M2N:3 %t16:p};
//   %t17 = $SUPPLY @ATTACH &DVDD => @PLACE(60, 25);
//   &DVDD @WIRE {#M2P:3 %t17:p};
//   &D0 @WIRE {#MLOAD0:2 (-5, -16)};
//   (-5.3, -16) @TEXT("D0", size=1.05, halign="end", valign="middle");
//   &D0 @WIRE {#MLOAD1:2 (11, -16)};
//   (10.7, -16) @TEXT("D0", size=1.05, halign="end", valign="middle");
//   &D0 @WIRE {#MLOAD2:2 (27, -16)};
//   (26.7, -16) @TEXT("D0", size=1.05, halign="end", valign="middle");
//   &D0 @WIRE {#MLOAD3:2 (43, -16)};
//   (42.7, -16) @TEXT("D0", size=1.05, halign="end", valign="middle");
//   &D1 @WIRE {#MPPASS:2 (84, 12)};
//   (83.7, 12) @TEXT("D1", size=1.05, halign="end", valign="middle");
//   &PHI_SB @WIRE {#MPPASS:3 (89, 8)};
//   (89, 7.4) @TEXT("PHI_SB", size=1.05, halign="middle", valign="top");
//   &D2 @WIRE {#MNPASS:2 (84, -2)};
//   (83.7, -2) @TEXT("D2", size=1.05, halign="end", valign="middle");
//   &PHI_SB @WIRE {#MNPASS:3 (89, -6)};
//   (89, -6.6) @TEXT("PHI_SB", size=1.05, halign="middle", valign="top");
//   &D2 @WIRE {#MPUP:2 (107, 21)};
//   (106.7, 21) @TEXT("D2", size=1.05, halign="end", valign="middle");
//   %t27 = $SUPPLY @ATTACH &DVDD => @PLACE(112, 25);
//   &DVDD @WIRE {#MPUP:3 %t27:p};
//   $JUNCTION @ATTACH %j1;
//   $JUNCTION @ATTACH %j2;
//   $JUNCTION @ATTACH %j3;
//   $JUNCTION @ATTACH %j4;
//   $JUNCTION @ATTACH %j6;
//   $JUNCTION @ATTACH %j7;
//   $JUNCTION @ATTACH %j8;
//   $JUNCTION @ATTACH %j9;
//   $JUNCTION @ATTACH %j10;
//   $JUNCTION @ATTACH %j11;
//   (-7, 44) @TEXT("N4 formal candidate / WIP | sampling-entry assist | three delay stages", size=1.4, bold=true, textcolor="#17365d");
//   (-7, 41.6) @TEXT("Drawing only | N bulk = VSS; L = 30 nm. P bulk DVDD: M0P, M1P, M2P, MPPASS, MPUP", size=1.05, textcolor="#52606d");
// }
ends mq_cdac_assist_pulse

// CDAC: split-supply drivers and physical sampling switches
subckt adc_cdac (VIN VG TOP VCM VREFP VREFN PHI_S PHI_SB CONV DH12 DH11 DH10 DH9 DH8 DH7 DH6 DH5 DH4 DH3 DH2 DH1 DH0 RL12 RL11 RL10 RL9 RL8 RL7 RL6 RL5 RL4 RL3 RL2 RL1 RL0 DVDD VSS)
// ENB controls NMOS sharing; APGATE controls PMOS VIN assistance.
// Non-sampled j9 and j6 remain reference-driven during sampling.
// The top-plate transmission gate is driven directly by PHI_S/PHI_SB.
// Experimental dummy NMOS: D/S tied to TOP, gate PHI_SB; added hold capacitance and clock load require verification.
XEN (CONV EN ENB DVDD VREFN VSS) mq_cdac_enable
XAPULSE (PHI_S PHI_SB APGATE DVDD VREFN VSS) mq_cdac_assist_pulse
MTN (TOP PHI_S VCM VSS) nch_ulvt_mac w=1.2e-05 l=3e-08 nf=6
MTP (TOP PHI_SB VCM DVDD) pch_ulvt_mac w=4e-06 l=3e-08 nf=2
MTD (TOP PHI_SB TOP VSS) nch_ulvt_mac w=4e-06 l=3e-08 nf=2
XB12 (VIN VG DH12 RL12 EN ENB TOP VREFP VREFN VSS DVDD EQBUS APGATE) mq_cdac_bit12
XB11 (VIN VG DH11 RL11 EN ENB TOP VREFP VREFN VSS DVDD EQBUS APGATE) mq_cdac_bit11
XB10 (VIN VG DH10 RL10 EN ENB TOP VREFP VREFN VSS DVDD EQBUS APGATE) mq_cdac_bit10
XB9 (DH9 RL9 DVDD VREFN TOP VREFP VREFN VSS DVDD) mq_cdac_bit9
XB8 (VIN VG DH8 RL8 EN ENB TOP VREFP VREFN VSS DVDD EQBUS APGATE) mq_cdac_bit8
XB7 (VIN VG DH7 RL7 EN ENB TOP VREFP VREFN VSS PHI_S DVDD PHI_SB EQBUS APGATE) mq_cdac_bit7
XB6 (DH6 RL6 DVDD VREFN TOP VREFP VREFN VSS DVDD) mq_cdac_bit6
XB5 (VIN VG DH5 RL5 EN ENB TOP VREFP VREFN VSS DVDD EQBUS APGATE) mq_cdac_bit5
XB4 (VIN VG DH4 RL4 EN ENB TOP VREFP VREFN VSS DVDD EQBUS APGATE) mq_cdac_bit4
XB3 (VIN VG DH3 RL3 EN ENB TOP VREFP VREFN VSS DVDD EQBUS APGATE) mq_cdac_bit3
XB2 (VIN VG DH2 RL2 EN ENB TOP VREFP VREFN VSS PHI_S DVDD PHI_SB EQBUS APGATE) mq_cdac_bit2
XB1 (VIN VG DH1 RL1 EN ENB TOP VREFP VREFN VSS DVDD EQBUS APGATE) mq_cdac_bit1
XB0 (VIN VG DH0 RL0 EN ENB TOP VREFP VREFN VSS PHI_S DVDD PHI_SB EQBUS APGATE) mq_cdac_bit0
// @RNL {
//   {&VIN &VG &TOP &VCM &VREFP &VREFN &PHI_S &PHI_SB &CONV &DH12 &DH11 &DH10 &DH9 &DH8 &DH7 &DH6 &DH5 &DH4 &DH3 &DH2 &DH1 &DH0 &RL12 &RL11 &RL10 &RL9 &RL8 &RL7 &RL6 &RL5 &RL4 &RL3 &RL2 &RL1 &RL0 &DVDD &VSS} @REMOVE-FROM $PORT_FILL_SET;
//   &VSS @ADD-TO $GROUND_NET_SET;
//   &VREFN @ADD-TO $GROUND_NET_SET;
//   #XB12 @PLACE(0, 0) => @ORIENT("R0");
//   %j1 = (22, 23);
//   &TOP @WIRE {#XB12:7 (22, 0) %j1};
//   #XB11 @PLACE(57, 0) => @ORIENT("R0");
//   %j2 = (79, 23);
//   &TOP @WIRE {#XB11:7 (79, 0) %j2};
//   &TOP @WIRE {%j1 %j2};
//   #XB10 @PLACE(114, 0) => @ORIENT("R0");
//   %j3 = (136, 23);
//   &TOP @WIRE {#XB10:7 (136, 0) %j3};
//   &TOP @WIRE {%j2 %j3};
//   #XB9 @PLACE(171, 0) => @ORIENT("R0");
//   %j4 = (193, 23);
//   &TOP @WIRE {#XB9:5 (193, 0) %j4};
//   &TOP @WIRE {%j3 %j4};
//   %j5 = (211, 23);
//   &TOP @WIRE {%j4 %j5};
//   #XB8 @PLACE(0, -47) => @ORIENT("R0");
//   %j6 = (22, -24);
//   &TOP @WIRE {#XB8:7 (22, -47) %j6};
//   #XB7 @PLACE(57, -47) => @ORIENT("R0");
//   %j7 = (79, -24);
//   &TOP @WIRE {#XB7:7 (79, -47) %j7};
//   &TOP @WIRE {%j6 %j7};
//   #XB6 @PLACE(114, -47) => @ORIENT("R0");
//   %j8 = (136, -24);
//   &TOP @WIRE {#XB6:5 (136, -47) %j8};
//   &TOP @WIRE {%j7 %j8};
//   #XB5 @PLACE(171, -47) => @ORIENT("R0");
//   %j9 = (193, -24);
//   &TOP @WIRE {#XB5:7 (193, -47) %j9};
//   &TOP @WIRE {%j8 %j9};
//   %j10 = (211, -24);
//   &TOP @WIRE {%j9 %j10};
//   #XB4 @PLACE(0, -94) => @ORIENT("R0");
//   %j11 = (22, -71);
//   &TOP @WIRE {#XB4:7 (22, -94) %j11};
//   #XB3 @PLACE(57, -94) => @ORIENT("R0");
//   %j12 = (79, -71);
//   &TOP @WIRE {#XB3:7 (79, -94) %j12};
//   &TOP @WIRE {%j11 %j12};
//   #XB2 @PLACE(114, -94) => @ORIENT("R0");
//   %j13 = (136, -71);
//   &TOP @WIRE {#XB2:7 (136, -94) %j13};
//   &TOP @WIRE {%j12 %j13};
//   #XB1 @PLACE(171, -94) => @ORIENT("R0");
//   %j14 = (193, -71);
//   &TOP @WIRE {#XB1:7 (193, -94) %j14};
//   &TOP @WIRE {%j13 %j14};
//   %j15 = (211, -71);
//   &TOP @WIRE {%j14 %j15};
//   #XB0 @PLACE(0, -141) => @ORIENT("R0");
//   %j16 = (22, -118);
//   &TOP @WIRE {#XB0:7 (22, -141) %j16};
//   %j17 = (211, -118);
//   &TOP @WIRE {%j16 %j17};
//   (213, 24) @TEXT("TOP to comparator", size=1.05);
//   #XEN @PLACE(65, -141) => @ORIENT("R0");
//   #XAPULSE @PLACE(114, -141) => @ORIENT("R0");
//   (47, -119) @TEXT("Shared control", size=1.3);
//   #MTN @PLACE(163, -141) => @ORIENT("R0");
//   #MTN @SET-SYMBOL $NMOS;
//   #MTN @TEXT("ULVT 12u", key="model", size=1.05, dx=1.5, dy=-1);
//   #MTN @TEXT("MTN", key="name", size=1.1, dx=1.5, dy=1);
//   #MTP @PLACE(183, -141) => @ORIENT("MX");
//   #MTP @SET-SYMBOL $PMOS;
//   #MTP @TEXT("ULVT 4u", key="model", size=1.05, dx=1.5, dy=-1);
//   #MTP @TEXT("MTP", key="name", size=1.1, dx=1.5, dy=1);
//   #MTD @PLACE(205, -141) => @ORIENT("R0");
//   #MTD @SET-SYMBOL $NMOS;
//   #MTD @TEXT("ULVT 4u", key="model", size=1.05, dx=1.5, dy=-1);
//   #MTD @TEXT("MTD", key="name", size=1.1, dx=1.5, dy=1);
//   %j18 = (163, -134);
//   %j19 = (211, -128);
//   &TOP @WIRE {#MTN:1 %j18 (183, -134) #MTP:1};
//   &TOP @WIRE {%j18 (163, -128) %j19};
//   &TOP @WIRE {#MTD:1 (212, -139) (212, -143) #MTD:3};
//   &VCM @WIRE {#MTN:3 (163, -149) (183, -149) #MTP:3};
//   (151, -155) @TEXT("VCM clamp / TOP dummy", size=1.05);
//   (125, -176) @TEXT("Unsampled: j9 = 180, j6 = 32", size=1.3);
//   (125, -181) @TEXT("DH/RL: per-bit. EN/ENB, EQBUS: shared.", size=1.1);
//   (125, -186) @TEXT("Cu = 1.00229 fF. All bottoms retain 5% Cp.", size=1.1);
//   &TOP @WIRE {%j5 %j10 %j15 %j17 %j19};
//   &VIN @WIRE {#XB12:1 (-19, 10)};
//   (-19.3, 10) @TEXT("VIN", size=1.05, halign="end", valign="middle");
//   &VG @WIRE {#XB12:2 (-19, 8)};
//   (-19.3, 8) @TEXT("VG", size=1.05, halign="end", valign="middle");
//   &DH12 @WIRE {#XB12:3 (-19, 6)};
//   (-19.3, 6) @TEXT("DH12", size=1.05, halign="end", valign="middle");
//   &RL12 @WIRE {#XB12:4 (-19, 4)};
//   (-19.3, 4) @TEXT("RL12", size=1.05, halign="end", valign="middle");
//   &EN @WIRE {#XB12:5 (-19, 2)};
//   (-19.3, 2) @TEXT("EN", size=1.05, halign="end", valign="middle");
//   &ENB @WIRE {#XB12:6 (-19, 0)};
//   (-19.3, 0) @TEXT("ENB", size=1.05, halign="end", valign="middle");
//   &EQBUS @WIRE {#XB12:12 (-19, -2)};
//   (-19.3, -2) @TEXT("EQBUS", size=1.05, halign="end", valign="middle");
//   &APGATE @WIRE {#XB12:13 (-19, -4)};
//   (-19.3, -4) @TEXT("APGATE", size=1.05, halign="end", valign="middle");
//   %t28 = $SUPPLY @ATTACH &VREFP => @PLACE(-5, 17);
//   &VREFP @WIRE {#XB12:8 %t28:p};
//   %t29 = $SUPPLY @ATTACH &DVDD => @PLACE(5, 17);
//   &DVDD @WIRE {#XB12:11 %t29:p};
//   %t30 = $GROUND @ATTACH &VREFN => @PLACE(-5, -17);
//   &VREFN @WIRE {#XB12:9 %t30:p};
//   %t31 = $GROUND @ATTACH &VSS => @PLACE(5, -17);
//   &VSS @WIRE {#XB12:10 %t31:p};
//   &VIN @WIRE {#XB11:1 (38, 10)};
//   (37.7, 10) @TEXT("VIN", size=1.05, halign="end", valign="middle");
//   &VG @WIRE {#XB11:2 (38, 8)};
//   (37.7, 8) @TEXT("VG", size=1.05, halign="end", valign="middle");
//   &DH11 @WIRE {#XB11:3 (38, 6)};
//   (37.7, 6) @TEXT("DH11", size=1.05, halign="end", valign="middle");
//   &RL11 @WIRE {#XB11:4 (38, 4)};
//   (37.7, 4) @TEXT("RL11", size=1.05, halign="end", valign="middle");
//   &EN @WIRE {#XB11:5 (38, 2)};
//   (37.7, 2) @TEXT("EN", size=1.05, halign="end", valign="middle");
//   &ENB @WIRE {#XB11:6 (38, 0)};
//   (37.7, 0) @TEXT("ENB", size=1.05, halign="end", valign="middle");
//   &EQBUS @WIRE {#XB11:12 (38, -2)};
//   (37.7, -2) @TEXT("EQBUS", size=1.05, halign="end", valign="middle");
//   &APGATE @WIRE {#XB11:13 (38, -4)};
//   (37.7, -4) @TEXT("APGATE", size=1.05, halign="end", valign="middle");
//   %t40 = $SUPPLY @ATTACH &VREFP => @PLACE(52, 17);
//   &VREFP @WIRE {#XB11:8 %t40:p};
//   %t41 = $SUPPLY @ATTACH &DVDD => @PLACE(62, 17);
//   &DVDD @WIRE {#XB11:11 %t41:p};
//   %t42 = $GROUND @ATTACH &VREFN => @PLACE(52, -17);
//   &VREFN @WIRE {#XB11:9 %t42:p};
//   %t43 = $GROUND @ATTACH &VSS => @PLACE(62, -17);
//   &VSS @WIRE {#XB11:10 %t43:p};
//   &VIN @WIRE {#XB10:1 (95, 10)};
//   (94.7, 10) @TEXT("VIN", size=1.05, halign="end", valign="middle");
//   &VG @WIRE {#XB10:2 (95, 8)};
//   (94.7, 8) @TEXT("VG", size=1.05, halign="end", valign="middle");
//   &DH10 @WIRE {#XB10:3 (95, 6)};
//   (94.7, 6) @TEXT("DH10", size=1.05, halign="end", valign="middle");
//   &RL10 @WIRE {#XB10:4 (95, 4)};
//   (94.7, 4) @TEXT("RL10", size=1.05, halign="end", valign="middle");
//   &EN @WIRE {#XB10:5 (95, 2)};
//   (94.7, 2) @TEXT("EN", size=1.05, halign="end", valign="middle");
//   &ENB @WIRE {#XB10:6 (95, 0)};
//   (94.7, 0) @TEXT("ENB", size=1.05, halign="end", valign="middle");
//   &EQBUS @WIRE {#XB10:12 (95, -2)};
//   (94.7, -2) @TEXT("EQBUS", size=1.05, halign="end", valign="middle");
//   &APGATE @WIRE {#XB10:13 (95, -4)};
//   (94.7, -4) @TEXT("APGATE", size=1.05, halign="end", valign="middle");
//   %t52 = $SUPPLY @ATTACH &VREFP => @PLACE(109, 17);
//   &VREFP @WIRE {#XB10:8 %t52:p};
//   %t53 = $SUPPLY @ATTACH &DVDD => @PLACE(119, 17);
//   &DVDD @WIRE {#XB10:11 %t53:p};
//   %t54 = $GROUND @ATTACH &VREFN => @PLACE(109, -17);
//   &VREFN @WIRE {#XB10:9 %t54:p};
//   %t55 = $GROUND @ATTACH &VSS => @PLACE(119, -17);
//   &VSS @WIRE {#XB10:10 %t55:p};
//   &DH9 @WIRE {#XB9:1 (152, 10)};
//   (151.7, 10) @TEXT("DH9", size=1.05, halign="end", valign="middle");
//   &RL9 @WIRE {#XB9:2 (152, 8)};
//   (151.7, 8) @TEXT("RL9", size=1.05, halign="end", valign="middle");
//   %t58 = $SUPPLY @ATTACH &DVDD => @PLACE(154, 8);
//   &DVDD @WIRE {#XB9:3 %t58:p};
//   %t59 = $GROUND @ATTACH &VREFN => @PLACE(154, 2);
//   &VREFN @WIRE {#XB9:4 %t59:p};
//   %t60 = $SUPPLY @ATTACH &VREFP => @PLACE(166, 17);
//   &VREFP @WIRE {#XB9:6 %t60:p};
//   %t61 = $SUPPLY @ATTACH &DVDD => @PLACE(176, 17);
//   &DVDD @WIRE {#XB9:9 %t61:p};
//   %t62 = $GROUND @ATTACH &VREFN => @PLACE(166, -17);
//   &VREFN @WIRE {#XB9:7 %t62:p};
//   %t63 = $GROUND @ATTACH &VSS => @PLACE(176, -17);
//   &VSS @WIRE {#XB9:8 %t63:p};
//   &VIN @WIRE {#XB8:1 (-19, -37)};
//   (-19.3, -37) @TEXT("VIN", size=1.05, halign="end", valign="middle");
//   &VG @WIRE {#XB8:2 (-19, -39)};
//   (-19.3, -39) @TEXT("VG", size=1.05, halign="end", valign="middle");
//   &DH8 @WIRE {#XB8:3 (-19, -41)};
//   (-19.3, -41) @TEXT("DH8", size=1.05, halign="end", valign="middle");
//   &RL8 @WIRE {#XB8:4 (-19, -43)};
//   (-19.3, -43) @TEXT("RL8", size=1.05, halign="end", valign="middle");
//   &EN @WIRE {#XB8:5 (-19, -45)};
//   (-19.3, -45) @TEXT("EN", size=1.05, halign="end", valign="middle");
//   &ENB @WIRE {#XB8:6 (-19, -47)};
//   (-19.3, -47) @TEXT("ENB", size=1.05, halign="end", valign="middle");
//   &EQBUS @WIRE {#XB8:12 (-19, -49)};
//   (-19.3, -49) @TEXT("EQBUS", size=1.05, halign="end", valign="middle");
//   &APGATE @WIRE {#XB8:13 (-19, -51)};
//   (-19.3, -51) @TEXT("APGATE", size=1.05, halign="end", valign="middle");
//   %t72 = $SUPPLY @ATTACH &VREFP => @PLACE(-5, -30);
//   &VREFP @WIRE {#XB8:8 %t72:p};
//   %t73 = $SUPPLY @ATTACH &DVDD => @PLACE(5, -30);
//   &DVDD @WIRE {#XB8:11 %t73:p};
//   %t74 = $GROUND @ATTACH &VREFN => @PLACE(-5, -64);
//   &VREFN @WIRE {#XB8:9 %t74:p};
//   %t75 = $GROUND @ATTACH &VSS => @PLACE(5, -64);
//   &VSS @WIRE {#XB8:10 %t75:p};
//   &VIN @WIRE {#XB7:1 (38, -37)};
//   (37.7, -37) @TEXT("VIN", size=1.05, halign="end", valign="middle");
//   &VG @WIRE {#XB7:2 (38, -39)};
//   (37.7, -39) @TEXT("VG", size=1.05, halign="end", valign="middle");
//   &DH7 @WIRE {#XB7:3 (38, -41)};
//   (37.7, -41) @TEXT("DH7", size=1.05, halign="end", valign="middle");
//   &RL7 @WIRE {#XB7:4 (38, -43)};
//   (37.7, -43) @TEXT("RL7", size=1.05, halign="end", valign="middle");
//   &EN @WIRE {#XB7:5 (38, -45)};
//   (37.7, -45) @TEXT("EN", size=1.05, halign="end", valign="middle");
//   &ENB @WIRE {#XB7:6 (38, -47)};
//   (37.7, -47) @TEXT("ENB", size=1.05, halign="end", valign="middle");
//   &PHI_S @WIRE {#XB7:11 (38, -49)};
//   (37.7, -49) @TEXT("PHI_S", size=1.05, halign="end", valign="middle");
//   &PHI_SB @WIRE {#XB7:13 (38, -51)};
//   (37.7, -51) @TEXT("PHI_SB", size=1.05, halign="end", valign="middle");
//   &EQBUS @WIRE {#XB7:14 (38, -53)};
//   (37.7, -53) @TEXT("EQBUS", size=1.05, halign="end", valign="middle");
//   &APGATE @WIRE {#XB7:15 (38, -55)};
//   (37.7, -55) @TEXT("APGATE", size=1.05, halign="end", valign="middle");
//   %t86 = $SUPPLY @ATTACH &VREFP => @PLACE(52, -30);
//   &VREFP @WIRE {#XB7:8 %t86:p};
//   %t87 = $SUPPLY @ATTACH &DVDD => @PLACE(62, -30);
//   &DVDD @WIRE {#XB7:12 %t87:p};
//   %t88 = $GROUND @ATTACH &VREFN => @PLACE(52, -64);
//   &VREFN @WIRE {#XB7:9 %t88:p};
//   %t89 = $GROUND @ATTACH &VSS => @PLACE(62, -64);
//   &VSS @WIRE {#XB7:10 %t89:p};
//   &DH6 @WIRE {#XB6:1 (95, -37)};
//   (94.7, -37) @TEXT("DH6", size=1.05, halign="end", valign="middle");
//   &RL6 @WIRE {#XB6:2 (95, -39)};
//   (94.7, -39) @TEXT("RL6", size=1.05, halign="end", valign="middle");
//   %t92 = $SUPPLY @ATTACH &DVDD => @PLACE(97, -39);
//   &DVDD @WIRE {#XB6:3 %t92:p};
//   %t93 = $GROUND @ATTACH &VREFN => @PLACE(97, -45);
//   &VREFN @WIRE {#XB6:4 %t93:p};
//   %t94 = $SUPPLY @ATTACH &VREFP => @PLACE(109, -30);
//   &VREFP @WIRE {#XB6:6 %t94:p};
//   %t95 = $SUPPLY @ATTACH &DVDD => @PLACE(119, -30);
//   &DVDD @WIRE {#XB6:9 %t95:p};
//   %t96 = $GROUND @ATTACH &VREFN => @PLACE(109, -64);
//   &VREFN @WIRE {#XB6:7 %t96:p};
//   %t97 = $GROUND @ATTACH &VSS => @PLACE(119, -64);
//   &VSS @WIRE {#XB6:8 %t97:p};
//   &VIN @WIRE {#XB5:1 (152, -37)};
//   (151.7, -37) @TEXT("VIN", size=1.05, halign="end", valign="middle");
//   &VG @WIRE {#XB5:2 (152, -39)};
//   (151.7, -39) @TEXT("VG", size=1.05, halign="end", valign="middle");
//   &DH5 @WIRE {#XB5:3 (152, -41)};
//   (151.7, -41) @TEXT("DH5", size=1.05, halign="end", valign="middle");
//   &RL5 @WIRE {#XB5:4 (152, -43)};
//   (151.7, -43) @TEXT("RL5", size=1.05, halign="end", valign="middle");
//   &EN @WIRE {#XB5:5 (152, -45)};
//   (151.7, -45) @TEXT("EN", size=1.05, halign="end", valign="middle");
//   &ENB @WIRE {#XB5:6 (152, -47)};
//   (151.7, -47) @TEXT("ENB", size=1.05, halign="end", valign="middle");
//   &EQBUS @WIRE {#XB5:12 (152, -49)};
//   (151.7, -49) @TEXT("EQBUS", size=1.05, halign="end", valign="middle");
//   &APGATE @WIRE {#XB5:13 (152, -51)};
//   (151.7, -51) @TEXT("APGATE", size=1.05, halign="end", valign="middle");
//   %t106 = $SUPPLY @ATTACH &VREFP => @PLACE(166, -30);
//   &VREFP @WIRE {#XB5:8 %t106:p};
//   %t107 = $SUPPLY @ATTACH &DVDD => @PLACE(176, -30);
//   &DVDD @WIRE {#XB5:11 %t107:p};
//   %t108 = $GROUND @ATTACH &VREFN => @PLACE(166, -64);
//   &VREFN @WIRE {#XB5:9 %t108:p};
//   %t109 = $GROUND @ATTACH &VSS => @PLACE(176, -64);
//   &VSS @WIRE {#XB5:10 %t109:p};
//   &VIN @WIRE {#XB4:1 (-19, -84)};
//   (-19.3, -84) @TEXT("VIN", size=1.05, halign="end", valign="middle");
//   &VG @WIRE {#XB4:2 (-19, -86)};
//   (-19.3, -86) @TEXT("VG", size=1.05, halign="end", valign="middle");
//   &DH4 @WIRE {#XB4:3 (-19, -88)};
//   (-19.3, -88) @TEXT("DH4", size=1.05, halign="end", valign="middle");
//   &RL4 @WIRE {#XB4:4 (-19, -90)};
//   (-19.3, -90) @TEXT("RL4", size=1.05, halign="end", valign="middle");
//   &EN @WIRE {#XB4:5 (-19, -92)};
//   (-19.3, -92) @TEXT("EN", size=1.05, halign="end", valign="middle");
//   &ENB @WIRE {#XB4:6 (-19, -94)};
//   (-19.3, -94) @TEXT("ENB", size=1.05, halign="end", valign="middle");
//   &EQBUS @WIRE {#XB4:12 (-19, -96)};
//   (-19.3, -96) @TEXT("EQBUS", size=1.05, halign="end", valign="middle");
//   &APGATE @WIRE {#XB4:13 (-19, -98)};
//   (-19.3, -98) @TEXT("APGATE", size=1.05, halign="end", valign="middle");
//   %t118 = $SUPPLY @ATTACH &VREFP => @PLACE(-5, -77);
//   &VREFP @WIRE {#XB4:8 %t118:p};
//   %t119 = $SUPPLY @ATTACH &DVDD => @PLACE(5, -77);
//   &DVDD @WIRE {#XB4:11 %t119:p};
//   %t120 = $GROUND @ATTACH &VREFN => @PLACE(-5, -111);
//   &VREFN @WIRE {#XB4:9 %t120:p};
//   %t121 = $GROUND @ATTACH &VSS => @PLACE(5, -111);
//   &VSS @WIRE {#XB4:10 %t121:p};
//   &VIN @WIRE {#XB3:1 (38, -84)};
//   (37.7, -84) @TEXT("VIN", size=1.05, halign="end", valign="middle");
//   &VG @WIRE {#XB3:2 (38, -86)};
//   (37.7, -86) @TEXT("VG", size=1.05, halign="end", valign="middle");
//   &DH3 @WIRE {#XB3:3 (38, -88)};
//   (37.7, -88) @TEXT("DH3", size=1.05, halign="end", valign="middle");
//   &RL3 @WIRE {#XB3:4 (38, -90)};
//   (37.7, -90) @TEXT("RL3", size=1.05, halign="end", valign="middle");
//   &EN @WIRE {#XB3:5 (38, -92)};
//   (37.7, -92) @TEXT("EN", size=1.05, halign="end", valign="middle");
//   &ENB @WIRE {#XB3:6 (38, -94)};
//   (37.7, -94) @TEXT("ENB", size=1.05, halign="end", valign="middle");
//   &EQBUS @WIRE {#XB3:12 (38, -96)};
//   (37.7, -96) @TEXT("EQBUS", size=1.05, halign="end", valign="middle");
//   &APGATE @WIRE {#XB3:13 (38, -98)};
//   (37.7, -98) @TEXT("APGATE", size=1.05, halign="end", valign="middle");
//   %t130 = $SUPPLY @ATTACH &VREFP => @PLACE(52, -77);
//   &VREFP @WIRE {#XB3:8 %t130:p};
//   %t131 = $SUPPLY @ATTACH &DVDD => @PLACE(62, -77);
//   &DVDD @WIRE {#XB3:11 %t131:p};
//   %t132 = $GROUND @ATTACH &VREFN => @PLACE(52, -111);
//   &VREFN @WIRE {#XB3:9 %t132:p};
//   %t133 = $GROUND @ATTACH &VSS => @PLACE(62, -111);
//   &VSS @WIRE {#XB3:10 %t133:p};
//   &VIN @WIRE {#XB2:1 (95, -84)};
//   (94.7, -84) @TEXT("VIN", size=1.05, halign="end", valign="middle");
//   &VG @WIRE {#XB2:2 (95, -86)};
//   (94.7, -86) @TEXT("VG", size=1.05, halign="end", valign="middle");
//   &DH2 @WIRE {#XB2:3 (95, -88)};
//   (94.7, -88) @TEXT("DH2", size=1.05, halign="end", valign="middle");
//   &RL2 @WIRE {#XB2:4 (95, -90)};
//   (94.7, -90) @TEXT("RL2", size=1.05, halign="end", valign="middle");
//   &EN @WIRE {#XB2:5 (95, -92)};
//   (94.7, -92) @TEXT("EN", size=1.05, halign="end", valign="middle");
//   &ENB @WIRE {#XB2:6 (95, -94)};
//   (94.7, -94) @TEXT("ENB", size=1.05, halign="end", valign="middle");
//   &PHI_S @WIRE {#XB2:11 (95, -96)};
//   (94.7, -96) @TEXT("PHI_S", size=1.05, halign="end", valign="middle");
//   &PHI_SB @WIRE {#XB2:13 (95, -98)};
//   (94.7, -98) @TEXT("PHI_SB", size=1.05, halign="end", valign="middle");
//   &EQBUS @WIRE {#XB2:14 (95, -100)};
//   (94.7, -100) @TEXT("EQBUS", size=1.05, halign="end", valign="middle");
//   &APGATE @WIRE {#XB2:15 (95, -102)};
//   (94.7, -102) @TEXT("APGATE", size=1.05, halign="end", valign="middle");
//   %t144 = $SUPPLY @ATTACH &VREFP => @PLACE(109, -77);
//   &VREFP @WIRE {#XB2:8 %t144:p};
//   %t145 = $SUPPLY @ATTACH &DVDD => @PLACE(119, -77);
//   &DVDD @WIRE {#XB2:12 %t145:p};
//   %t146 = $GROUND @ATTACH &VREFN => @PLACE(109, -111);
//   &VREFN @WIRE {#XB2:9 %t146:p};
//   %t147 = $GROUND @ATTACH &VSS => @PLACE(119, -111);
//   &VSS @WIRE {#XB2:10 %t147:p};
//   &VIN @WIRE {#XB1:1 (152, -84)};
//   (151.7, -84) @TEXT("VIN", size=1.05, halign="end", valign="middle");
//   &VG @WIRE {#XB1:2 (152, -86)};
//   (151.7, -86) @TEXT("VG", size=1.05, halign="end", valign="middle");
//   &DH1 @WIRE {#XB1:3 (152, -88)};
//   (151.7, -88) @TEXT("DH1", size=1.05, halign="end", valign="middle");
//   &RL1 @WIRE {#XB1:4 (152, -90)};
//   (151.7, -90) @TEXT("RL1", size=1.05, halign="end", valign="middle");
//   &EN @WIRE {#XB1:5 (152, -92)};
//   (151.7, -92) @TEXT("EN", size=1.05, halign="end", valign="middle");
//   &ENB @WIRE {#XB1:6 (152, -94)};
//   (151.7, -94) @TEXT("ENB", size=1.05, halign="end", valign="middle");
//   &EQBUS @WIRE {#XB1:12 (152, -96)};
//   (151.7, -96) @TEXT("EQBUS", size=1.05, halign="end", valign="middle");
//   &APGATE @WIRE {#XB1:13 (152, -98)};
//   (151.7, -98) @TEXT("APGATE", size=1.05, halign="end", valign="middle");
//   %t156 = $SUPPLY @ATTACH &VREFP => @PLACE(166, -77);
//   &VREFP @WIRE {#XB1:8 %t156:p};
//   %t157 = $SUPPLY @ATTACH &DVDD => @PLACE(176, -77);
//   &DVDD @WIRE {#XB1:11 %t157:p};
//   %t158 = $GROUND @ATTACH &VREFN => @PLACE(166, -111);
//   &VREFN @WIRE {#XB1:9 %t158:p};
//   %t159 = $GROUND @ATTACH &VSS => @PLACE(176, -111);
//   &VSS @WIRE {#XB1:10 %t159:p};
//   &VIN @WIRE {#XB0:1 (-19, -131)};
//   (-19.3, -131) @TEXT("VIN", size=1.05, halign="end", valign="middle");
//   &VG @WIRE {#XB0:2 (-19, -133)};
//   (-19.3, -133) @TEXT("VG", size=1.05, halign="end", valign="middle");
//   &DH0 @WIRE {#XB0:3 (-19, -135)};
//   (-19.3, -135) @TEXT("DH0", size=1.05, halign="end", valign="middle");
//   &RL0 @WIRE {#XB0:4 (-19, -137)};
//   (-19.3, -137) @TEXT("RL0", size=1.05, halign="end", valign="middle");
//   &EN @WIRE {#XB0:5 (-19, -139)};
//   (-19.3, -139) @TEXT("EN", size=1.05, halign="end", valign="middle");
//   &ENB @WIRE {#XB0:6 (-19, -141)};
//   (-19.3, -141) @TEXT("ENB", size=1.05, halign="end", valign="middle");
//   &PHI_S @WIRE {#XB0:11 (-19, -143)};
//   (-19.3, -143) @TEXT("PHI_S", size=1.05, halign="end", valign="middle");
//   &PHI_SB @WIRE {#XB0:13 (-19, -145)};
//   (-19.3, -145) @TEXT("PHI_SB", size=1.05, halign="end", valign="middle");
//   &EQBUS @WIRE {#XB0:14 (-19, -147)};
//   (-19.3, -147) @TEXT("EQBUS", size=1.05, halign="end", valign="middle");
//   &APGATE @WIRE {#XB0:15 (-19, -149)};
//   (-19.3, -149) @TEXT("APGATE", size=1.05, halign="end", valign="middle");
//   %t170 = $SUPPLY @ATTACH &VREFP => @PLACE(-5, -124);
//   &VREFP @WIRE {#XB0:8 %t170:p};
//   %t171 = $SUPPLY @ATTACH &DVDD => @PLACE(5, -124);
//   &DVDD @WIRE {#XB0:12 %t171:p};
//   %t172 = $GROUND @ATTACH &VREFN => @PLACE(-5, -158);
//   &VREFN @WIRE {#XB0:9 %t172:p};
//   %t173 = $GROUND @ATTACH &VSS => @PLACE(5, -158);
//   &VSS @WIRE {#XB0:10 %t173:p};
//   &CONV @WIRE {#XEN:1 (53, -141)};
//   (52.7, -141) @TEXT("CONV", size=1.05, halign="end", valign="middle");
//   &EN @WIRE {#XEN:2 (79, -138)};
//   (79.3, -138) @TEXT("EN", size=1.05, halign="start", valign="middle");
//   &ENB @WIRE {#XEN:3 (79, -144)};
//   (79.3, -144) @TEXT("ENB", size=1.05, halign="start", valign="middle");
//   %t177 = $SUPPLY @ATTACH &DVDD => @PLACE(60, -128);
//   &DVDD @WIRE {#XEN:4 %t177:p};
//   %t178 = $GROUND @ATTACH &VREFN => @PLACE(60, -154);
//   &VREFN @WIRE {#XEN:5 %t178:p};
//   %t179 = $GROUND @ATTACH &VSS => @PLACE(70, -154);
//   &VSS @WIRE {#XEN:6 %t179:p};
//   &PHI_S @WIRE {#XAPULSE:1 (100, -137)};
//   (99.7, -137) @TEXT("PHI_S", size=1.05, halign="end", valign="middle");
//   &PHI_SB @WIRE {#XAPULSE:2 (100, -145)};
//   (99.7, -145) @TEXT("PHI_SB", size=1.05, halign="end", valign="middle");
//   &APGATE @WIRE {#XAPULSE:3 (128, -141)};
//   (128.3, -141) @TEXT("APGATE", size=1.05, halign="start", valign="middle");
//   %t183 = $SUPPLY @ATTACH &DVDD => @PLACE(109, -128);
//   &DVDD @WIRE {#XAPULSE:4 %t183:p};
//   %t184 = $GROUND @ATTACH &VREFN => @PLACE(109, -154);
//   &VREFN @WIRE {#XAPULSE:5 %t184:p};
//   %t185 = $GROUND @ATTACH &VSS => @PLACE(119, -154);
//   &VSS @WIRE {#XAPULSE:6 %t185:p};
//   &PHI_S @WIRE {#MTN:2 (158, -141)};
//   (157.7, -141) @TEXT("PHI_S", size=1.05, halign="end", valign="middle");
//   &PHI_SB @WIRE {#MTP:2 (178, -141)};
//   (177.7, -141) @TEXT("PHI_SB", size=1.05, halign="end", valign="middle");
//   &PHI_SB @WIRE {#MTD:2 (200, -141)};
//   (199.7, -141) @TEXT("PHI_SB", size=1.05, halign="end", valign="middle");
//   $JUNCTION @ATTACH %j2;
//   $JUNCTION @ATTACH %j3;
//   $JUNCTION @ATTACH %j4;
//   $JUNCTION @ATTACH %j7;
//   $JUNCTION @ATTACH %j8;
//   $JUNCTION @ATTACH %j9;
//   $JUNCTION @ATTACH %j10;
//   $JUNCTION @ATTACH %j12;
//   $JUNCTION @ATTACH %j13;
//   $JUNCTION @ATTACH %j14;
//   $JUNCTION @ATTACH %j15;
//   $JUNCTION @ATTACH %j17;
//   $JUNCTION @ATTACH %j18;
//   (-20, 35) @TEXT("N4 formal candidate / WIP | CDAC array | weights and control hierarchy", size=1.4, bold=true, textcolor="#17365d");
//   (-20, 32.6) @TEXT("Drawing only | N bulk = VSS; L = 30 nm. P bulk DVDD: MTP", size=1.05, textcolor="#52606d");
// }
ends adc_cdac
