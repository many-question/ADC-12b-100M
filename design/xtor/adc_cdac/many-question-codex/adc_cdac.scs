// adc_cdac: MOM banks and transistor drivers with user-specified pre-layout parasitic estimates.
// @RNL(type="header") {
//   @VERSION("0.3");
//   @USE-PACKAGE(name="adc28", version="0.1", path="../../../rnl/adc28.rnl")
// }
simulator lang=spectre
// @RNL {
//   $S_mq_cdac_ctl_l = @DEFINE-SYMBOL(box=[-7, -4, 7, 4]) {
//     @LINE(linewidth=0.24) {(-6, -3) (6, -3) (6, 3) (-6, 3) (-6, -3)};
//     (-7, 0) @PIN(terminal=1, direction="left");
//     @LINE {(-7, 0) (-6, 0)};
//     (-5.65, 0) @TEXT("IN", size=0.55, halign="start", valign="middle");
//     (7, 0) @PIN(terminal=2, direction="right");
//     @LINE {(7, 0) (6, 0)};
//     (5.65, 0) @TEXT("HI", size=0.55, halign="end", valign="middle");
//     (0, 4) @PIN(terminal=3, direction="up");
//     @LINE {(0, 4) (0, 3)};
//     (-2, -4) @PIN(terminal=4, direction="down");
//     @LINE {(-2, -4) (-2, -3)};
//     (2, -4) @PIN(terminal=5, direction="down");
//     @LINE {(2, -4) (2, -3)};
//     (0, 0.3) @TEXT("Reference-domain command buffer L", size=0.7, bold=true, halign="middle", valign="bottom");
//     ? @TEXT("${name}", key="name", size=0.8, valign="bottom") => @PLACE(-6, 3.5);
//     ? @TEXT("${model}", key="model", size=0.5, halign="middle", valign="top") => @PLACE(0, -0.3)
//   };
//   # @SELECT-INSTANCE(model="mq_cdac_ctl_l") => @SET-SYMBOL $S_mq_cdac_ctl_l;
//   $S_mq_cdac_ctl_h = @DEFINE-SYMBOL(box=[-7, -4, 7, 4]) {
//     @LINE(linewidth=0.24) {(-6, -3) (6, -3) (6, 3) (-6, 3) (-6, -3)};
//     (-7, 0) @PIN(terminal=1, direction="left");
//     @LINE {(-7, 0) (-6, 0)};
//     (-5.65, 0) @TEXT("IN", size=0.55, halign="start", valign="middle");
//     (7, 0) @PIN(terminal=2, direction="right");
//     @LINE {(7, 0) (6, 0)};
//     (5.65, 0) @TEXT("HI", size=0.55, halign="end", valign="middle");
//     (0, 4) @PIN(terminal=3, direction="up");
//     @LINE {(0, 4) (0, 3)};
//     (-2, -4) @PIN(terminal=4, direction="down");
//     @LINE {(-2, -4) (-2, -3)};
//     (2, -4) @PIN(terminal=5, direction="down");
//     @LINE {(2, -4) (2, -3)};
//     (0, 0.3) @TEXT("Reference-domain command buffer H", size=0.7, bold=true, halign="middle", valign="bottom");
//     ? @TEXT("${name}", key="name", size=0.8, valign="bottom") => @PLACE(-6, 3.5);
//     ? @TEXT("${model}", key="model", size=0.5, halign="middle", valign="top") => @PLACE(0, -0.3)
//   };
//   # @SELECT-INSTANCE(model="mq_cdac_ctl_h") => @SET-SYMBOL $S_mq_cdac_ctl_h;
//   $S_mq_cdac_enable = @DEFINE-SYMBOL(box=[-7, -4, 7, 4]) {
//     @LINE(linewidth=0.24) {(-6, -3) (6, -3) (6, 3) (-6, 3) (-6, -3)};
//     (-7, 0) @PIN(terminal=1, direction="left");
//     @LINE {(-7, 0) (-6, 0)};
//     (-5.65, 0) @TEXT("IN", size=0.55, halign="start", valign="middle");
//     (7, 1) @PIN(terminal=2, direction="right");
//     @LINE {(7, 1) (6, 1)};
//     (5.65, 1) @TEXT("EN", size=0.55, halign="end", valign="middle");
//     (7, -1) @PIN(terminal=3, direction="right");
//     @LINE {(7, -1) (6, -1)};
//     (5.65, -1) @TEXT("ENB", size=0.55, halign="end", valign="middle");
//     (0, 4) @PIN(terminal=4, direction="up");
//     @LINE {(0, 4) (0, 3)};
//     (-2, -4) @PIN(terminal=5, direction="down");
//     @LINE {(-2, -4) (-2, -3)};
//     (2, -4) @PIN(terminal=6, direction="down");
//     @LINE {(2, -4) (2, -3)};
//     (0, 0.3) @TEXT("Conversion-enable buffer", size=0.7, bold=true, halign="middle", valign="bottom");
//     ? @TEXT("${name}", key="name", size=0.8, valign="bottom") => @PLACE(-6, 3.5);
//     ? @TEXT("${model}", key="model", size=0.5, halign="middle", valign="top") => @PLACE(0, -0.3)
//   };
//   # @SELECT-INSTANCE(model="mq_cdac_enable") => @SET-SYMBOL $S_mq_cdac_enable;
//   $S_mq_cdac_drv12 = @DEFINE-SYMBOL(box=[-7, -5, 7, 5]) {
//     @LINE(linewidth=0.24) {(-6, -4) (6, -4) (6, 4) (-6, 4) (-6, -4)};
//     (-7, 2) @PIN(terminal=1, direction="left");
//     @LINE {(-7, 2) (-6, 2)};
//     (-5.65, 2) @TEXT("HI", size=0.55, halign="start", valign="middle");
//     (-7, 0) @PIN(terminal=2, direction="left");
//     @LINE {(-7, 0) (-6, 0)};
//     (-5.65, 0) @TEXT("EN", size=0.55, halign="start", valign="middle");
//     (-7, -2) @PIN(terminal=3, direction="left");
//     @LINE {(-7, -2) (-6, -2)};
//     (-5.65, -2) @TEXT("ENB", size=0.55, halign="start", valign="middle");
//     (7, 0) @PIN(terminal=4, direction="right");
//     @LINE {(7, 0) (6, 0)};
//     (5.65, 0) @TEXT("BP", size=0.55, halign="end", valign="middle");
//     (0, 5) @PIN(terminal=5, direction="up");
//     @LINE {(0, 5) (0, 4)};
//     (-2, -5) @PIN(terminal=6, direction="down");
//     @LINE {(-2, -5) (-2, -4)};
//     (2, -5) @PIN(terminal=7, direction="down");
//     @LINE {(2, -5) (2, -4)};
//     (0, 0.3) @TEXT("Tristate nonoverlap driver j=12", size=0.7, bold=true, halign="middle", valign="bottom");
//     ? @TEXT("${name}", key="name", size=0.8, valign="bottom") => @PLACE(-6, 4.5);
//     ? @TEXT("${model}", key="model", size=0.5, halign="middle", valign="top") => @PLACE(0, -0.3)
//   };
//   # @SELECT-INSTANCE(model="mq_cdac_drv12") => @SET-SYMBOL $S_mq_cdac_drv12;
//   $S_mq_cdac_bit12 = @DEFINE-SYMBOL(box=[-7, -8, 7, 8]) {
//     @LINE(linewidth=0.24) {(-6, -7) (6, -7) (6, 7) (-6, 7) (-6, -7)};
//     (-7, 5) @PIN(terminal=1, direction="left");
//     @LINE {(-7, 5) (-6, 5)};
//     (-5.65, 5) @TEXT("VIN", size=0.55, halign="start", valign="middle");
//     (-7, 3) @PIN(terminal=2, direction="left");
//     @LINE {(-7, 3) (-6, 3)};
//     (-5.65, 3) @TEXT("VG", size=0.55, halign="start", valign="middle");
//     (-7, 1) @PIN(terminal=3, direction="left");
//     @LINE {(-7, 1) (-6, 1)};
//     (-5.65, 1) @TEXT("DH", size=0.55, halign="start", valign="middle");
//     (-7, -1) @PIN(terminal=4, direction="left");
//     @LINE {(-7, -1) (-6, -1)};
//     (-5.65, -1) @TEXT("RL", size=0.55, halign="start", valign="middle");
//     (-7, -3) @PIN(terminal=5, direction="left");
//     @LINE {(-7, -3) (-6, -3)};
//     (-5.65, -3) @TEXT("EN", size=0.55, halign="start", valign="middle");
//     (-7, -5) @PIN(terminal=6, direction="left");
//     @LINE {(-7, -5) (-6, -5)};
//     (-5.65, -5) @TEXT("ENB", size=0.55, halign="start", valign="middle");
//     (7, 0) @PIN(terminal=7, direction="right");
//     @LINE {(7, 0) (6, 0)};
//     (5.65, 0) @TEXT("TOP", size=0.55, halign="end", valign="middle");
//     (0, 8) @PIN(terminal=8, direction="up");
//     @LINE {(0, 8) (0, 7)};
//     (-2, -8) @PIN(terminal=9, direction="down");
//     @LINE {(-2, -8) (-2, -7)};
//     (2, -8) @PIN(terminal=10, direction="down");
//     @LINE {(2, -8) (2, -7)};
//     (0, 0.3) @TEXT("Matched half-capacitor pair j=12, weight 980", size=0.7, bold=true, halign="middle", valign="bottom");
//     ? @TEXT("${name}", key="name", size=0.8, valign="bottom") => @PLACE(-6, 7.5);
//     ? @TEXT("${model}", key="model", size=0.5, halign="middle", valign="top") => @PLACE(0, -0.3)
//   };
//   # @SELECT-INSTANCE(model="mq_cdac_bit12") => @SET-SYMBOL $S_mq_cdac_bit12;
//   $S_mq_cdac_drv11 = @DEFINE-SYMBOL(box=[-7, -5, 7, 5]) {
//     @LINE(linewidth=0.24) {(-6, -4) (6, -4) (6, 4) (-6, 4) (-6, -4)};
//     (-7, 2) @PIN(terminal=1, direction="left");
//     @LINE {(-7, 2) (-6, 2)};
//     (-5.65, 2) @TEXT("HI", size=0.55, halign="start", valign="middle");
//     (-7, 0) @PIN(terminal=2, direction="left");
//     @LINE {(-7, 0) (-6, 0)};
//     (-5.65, 0) @TEXT("EN", size=0.55, halign="start", valign="middle");
//     (-7, -2) @PIN(terminal=3, direction="left");
//     @LINE {(-7, -2) (-6, -2)};
//     (-5.65, -2) @TEXT("ENB", size=0.55, halign="start", valign="middle");
//     (7, 0) @PIN(terminal=4, direction="right");
//     @LINE {(7, 0) (6, 0)};
//     (5.65, 0) @TEXT("BP", size=0.55, halign="end", valign="middle");
//     (0, 5) @PIN(terminal=5, direction="up");
//     @LINE {(0, 5) (0, 4)};
//     (-2, -5) @PIN(terminal=6, direction="down");
//     @LINE {(-2, -5) (-2, -4)};
//     (2, -5) @PIN(terminal=7, direction="down");
//     @LINE {(2, -5) (2, -4)};
//     (0, 0.3) @TEXT("Tristate nonoverlap driver j=11", size=0.7, bold=true, halign="middle", valign="bottom");
//     ? @TEXT("${name}", key="name", size=0.8, valign="bottom") => @PLACE(-6, 4.5);
//     ? @TEXT("${model}", key="model", size=0.5, halign="middle", valign="top") => @PLACE(0, -0.3)
//   };
//   # @SELECT-INSTANCE(model="mq_cdac_drv11") => @SET-SYMBOL $S_mq_cdac_drv11;
//   $S_mq_cdac_bit11 = @DEFINE-SYMBOL(box=[-7, -8, 7, 8]) {
//     @LINE(linewidth=0.24) {(-6, -7) (6, -7) (6, 7) (-6, 7) (-6, -7)};
//     (-7, 5) @PIN(terminal=1, direction="left");
//     @LINE {(-7, 5) (-6, 5)};
//     (-5.65, 5) @TEXT("VIN", size=0.55, halign="start", valign="middle");
//     (-7, 3) @PIN(terminal=2, direction="left");
//     @LINE {(-7, 3) (-6, 3)};
//     (-5.65, 3) @TEXT("VG", size=0.55, halign="start", valign="middle");
//     (-7, 1) @PIN(terminal=3, direction="left");
//     @LINE {(-7, 1) (-6, 1)};
//     (-5.65, 1) @TEXT("DH", size=0.55, halign="start", valign="middle");
//     (-7, -1) @PIN(terminal=4, direction="left");
//     @LINE {(-7, -1) (-6, -1)};
//     (-5.65, -1) @TEXT("RL", size=0.55, halign="start", valign="middle");
//     (-7, -3) @PIN(terminal=5, direction="left");
//     @LINE {(-7, -3) (-6, -3)};
//     (-5.65, -3) @TEXT("EN", size=0.55, halign="start", valign="middle");
//     (-7, -5) @PIN(terminal=6, direction="left");
//     @LINE {(-7, -5) (-6, -5)};
//     (-5.65, -5) @TEXT("ENB", size=0.55, halign="start", valign="middle");
//     (7, 0) @PIN(terminal=7, direction="right");
//     @LINE {(7, 0) (6, 0)};
//     (5.65, 0) @TEXT("TOP", size=0.55, halign="end", valign="middle");
//     (0, 8) @PIN(terminal=8, direction="up");
//     @LINE {(0, 8) (0, 7)};
//     (-2, -8) @PIN(terminal=9, direction="down");
//     @LINE {(-2, -8) (-2, -7)};
//     (2, -8) @PIN(terminal=10, direction="down");
//     @LINE {(2, -8) (2, -7)};
//     (0, 0.3) @TEXT("Matched half-capacitor pair j=11, weight 560", size=0.7, bold=true, halign="middle", valign="bottom");
//     ? @TEXT("${name}", key="name", size=0.8, valign="bottom") => @PLACE(-6, 7.5);
//     ? @TEXT("${model}", key="model", size=0.5, halign="middle", valign="top") => @PLACE(0, -0.3)
//   };
//   # @SELECT-INSTANCE(model="mq_cdac_bit11") => @SET-SYMBOL $S_mq_cdac_bit11;
//   $S_mq_cdac_drv10 = @DEFINE-SYMBOL(box=[-7, -5, 7, 5]) {
//     @LINE(linewidth=0.24) {(-6, -4) (6, -4) (6, 4) (-6, 4) (-6, -4)};
//     (-7, 2) @PIN(terminal=1, direction="left");
//     @LINE {(-7, 2) (-6, 2)};
//     (-5.65, 2) @TEXT("HI", size=0.55, halign="start", valign="middle");
//     (-7, 0) @PIN(terminal=2, direction="left");
//     @LINE {(-7, 0) (-6, 0)};
//     (-5.65, 0) @TEXT("EN", size=0.55, halign="start", valign="middle");
//     (-7, -2) @PIN(terminal=3, direction="left");
//     @LINE {(-7, -2) (-6, -2)};
//     (-5.65, -2) @TEXT("ENB", size=0.55, halign="start", valign="middle");
//     (7, 0) @PIN(terminal=4, direction="right");
//     @LINE {(7, 0) (6, 0)};
//     (5.65, 0) @TEXT("BP", size=0.55, halign="end", valign="middle");
//     (0, 5) @PIN(terminal=5, direction="up");
//     @LINE {(0, 5) (0, 4)};
//     (-2, -5) @PIN(terminal=6, direction="down");
//     @LINE {(-2, -5) (-2, -4)};
//     (2, -5) @PIN(terminal=7, direction="down");
//     @LINE {(2, -5) (2, -4)};
//     (0, 0.3) @TEXT("Tristate nonoverlap driver j=10", size=0.7, bold=true, halign="middle", valign="bottom");
//     ? @TEXT("${name}", key="name", size=0.8, valign="bottom") => @PLACE(-6, 4.5);
//     ? @TEXT("${model}", key="model", size=0.5, halign="middle", valign="top") => @PLACE(0, -0.3)
//   };
//   # @SELECT-INSTANCE(model="mq_cdac_drv10") => @SET-SYMBOL $S_mq_cdac_drv10;
//   $S_mq_cdac_bit10 = @DEFINE-SYMBOL(box=[-7, -8, 7, 8]) {
//     @LINE(linewidth=0.24) {(-6, -7) (6, -7) (6, 7) (-6, 7) (-6, -7)};
//     (-7, 5) @PIN(terminal=1, direction="left");
//     @LINE {(-7, 5) (-6, 5)};
//     (-5.65, 5) @TEXT("VIN", size=0.55, halign="start", valign="middle");
//     (-7, 3) @PIN(terminal=2, direction="left");
//     @LINE {(-7, 3) (-6, 3)};
//     (-5.65, 3) @TEXT("VG", size=0.55, halign="start", valign="middle");
//     (-7, 1) @PIN(terminal=3, direction="left");
//     @LINE {(-7, 1) (-6, 1)};
//     (-5.65, 1) @TEXT("DH", size=0.55, halign="start", valign="middle");
//     (-7, -1) @PIN(terminal=4, direction="left");
//     @LINE {(-7, -1) (-6, -1)};
//     (-5.65, -1) @TEXT("RL", size=0.55, halign="start", valign="middle");
//     (-7, -3) @PIN(terminal=5, direction="left");
//     @LINE {(-7, -3) (-6, -3)};
//     (-5.65, -3) @TEXT("EN", size=0.55, halign="start", valign="middle");
//     (-7, -5) @PIN(terminal=6, direction="left");
//     @LINE {(-7, -5) (-6, -5)};
//     (-5.65, -5) @TEXT("ENB", size=0.55, halign="start", valign="middle");
//     (7, 0) @PIN(terminal=7, direction="right");
//     @LINE {(7, 0) (6, 0)};
//     (5.65, 0) @TEXT("TOP", size=0.55, halign="end", valign="middle");
//     (0, 8) @PIN(terminal=8, direction="up");
//     @LINE {(0, 8) (0, 7)};
//     (-2, -8) @PIN(terminal=9, direction="down");
//     @LINE {(-2, -8) (-2, -7)};
//     (2, -8) @PIN(terminal=10, direction="down");
//     @LINE {(2, -8) (2, -7)};
//     (0, 0.3) @TEXT("Matched half-capacitor pair j=10, weight 318", size=0.7, bold=true, halign="middle", valign="bottom");
//     ? @TEXT("${name}", key="name", size=0.8, valign="bottom") => @PLACE(-6, 7.5);
//     ? @TEXT("${model}", key="model", size=0.5, halign="middle", valign="top") => @PLACE(0, -0.3)
//   };
//   # @SELECT-INSTANCE(model="mq_cdac_bit10") => @SET-SYMBOL $S_mq_cdac_bit10;
//   $S_mq_cdac_drv9 = @DEFINE-SYMBOL(box=[-7, -5, 7, 5]) {
//     @LINE(linewidth=0.24) {(-6, -4) (6, -4) (6, 4) (-6, 4) (-6, -4)};
//     (-7, 2) @PIN(terminal=1, direction="left");
//     @LINE {(-7, 2) (-6, 2)};
//     (-5.65, 2) @TEXT("HI", size=0.55, halign="start", valign="middle");
//     (-7, 0) @PIN(terminal=2, direction="left");
//     @LINE {(-7, 0) (-6, 0)};
//     (-5.65, 0) @TEXT("EN", size=0.55, halign="start", valign="middle");
//     (-7, -2) @PIN(terminal=3, direction="left");
//     @LINE {(-7, -2) (-6, -2)};
//     (-5.65, -2) @TEXT("ENB", size=0.55, halign="start", valign="middle");
//     (7, 0) @PIN(terminal=4, direction="right");
//     @LINE {(7, 0) (6, 0)};
//     (5.65, 0) @TEXT("BP", size=0.55, halign="end", valign="middle");
//     (0, 5) @PIN(terminal=5, direction="up");
//     @LINE {(0, 5) (0, 4)};
//     (-2, -5) @PIN(terminal=6, direction="down");
//     @LINE {(-2, -5) (-2, -4)};
//     (2, -5) @PIN(terminal=7, direction="down");
//     @LINE {(2, -5) (2, -4)};
//     (0, 0.3) @TEXT("Tristate nonoverlap driver j=9", size=0.7, bold=true, halign="middle", valign="bottom");
//     ? @TEXT("${name}", key="name", size=0.8, valign="bottom") => @PLACE(-6, 4.5);
//     ? @TEXT("${model}", key="model", size=0.5, halign="middle", valign="top") => @PLACE(0, -0.3)
//   };
//   # @SELECT-INSTANCE(model="mq_cdac_drv9") => @SET-SYMBOL $S_mq_cdac_drv9;
//   $S_mq_cdac_bit9 = @DEFINE-SYMBOL(box=[-7, -6, 7, 6]) {
//     @LINE(linewidth=0.24) {(-6, -5) (6, -5) (6, 5) (-6, 5) (-6, -5)};
//     (-7, 3) @PIN(terminal=1, direction="left");
//     @LINE {(-7, 3) (-6, 3)};
//     (-5.65, 3) @TEXT("DH", size=0.55, halign="start", valign="middle");
//     (-7, 1) @PIN(terminal=2, direction="left");
//     @LINE {(-7, 1) (-6, 1)};
//     (-5.65, 1) @TEXT("RL", size=0.55, halign="start", valign="middle");
//     (-7, -1) @PIN(terminal=3, direction="left");
//     @LINE {(-7, -1) (-6, -1)};
//     (-5.65, -1) @TEXT("EN", size=0.55, halign="start", valign="middle");
//     (-7, -3) @PIN(terminal=4, direction="left");
//     @LINE {(-7, -3) (-6, -3)};
//     (-5.65, -3) @TEXT("ENB", size=0.55, halign="start", valign="middle");
//     (7, 0) @PIN(terminal=5, direction="right");
//     @LINE {(7, 0) (6, 0)};
//     (5.65, 0) @TEXT("TOP", size=0.55, halign="end", valign="middle");
//     (0, 6) @PIN(terminal=6, direction="up");
//     @LINE {(0, 6) (0, 5)};
//     (-2, -6) @PIN(terminal=7, direction="down");
//     @LINE {(-2, -6) (-2, -5)};
//     (2, -6) @PIN(terminal=8, direction="down");
//     @LINE {(2, -6) (2, -5)};
//     (0, 0.3) @TEXT("Matched half-capacitor pair j=9, weight 180", size=0.7, bold=true, halign="middle", valign="bottom");
//     ? @TEXT("${name}", key="name", size=0.8, valign="bottom") => @PLACE(-6, 5.5);
//     ? @TEXT("${model}", key="model", size=0.5, halign="middle", valign="top") => @PLACE(0, -0.3)
//   };
//   # @SELECT-INSTANCE(model="mq_cdac_bit9") => @SET-SYMBOL $S_mq_cdac_bit9;
//   $S_mq_cdac_drv8 = @DEFINE-SYMBOL(box=[-7, -5, 7, 5]) {
//     @LINE(linewidth=0.24) {(-6, -4) (6, -4) (6, 4) (-6, 4) (-6, -4)};
//     (-7, 2) @PIN(terminal=1, direction="left");
//     @LINE {(-7, 2) (-6, 2)};
//     (-5.65, 2) @TEXT("HI", size=0.55, halign="start", valign="middle");
//     (-7, 0) @PIN(terminal=2, direction="left");
//     @LINE {(-7, 0) (-6, 0)};
//     (-5.65, 0) @TEXT("EN", size=0.55, halign="start", valign="middle");
//     (-7, -2) @PIN(terminal=3, direction="left");
//     @LINE {(-7, -2) (-6, -2)};
//     (-5.65, -2) @TEXT("ENB", size=0.55, halign="start", valign="middle");
//     (7, 0) @PIN(terminal=4, direction="right");
//     @LINE {(7, 0) (6, 0)};
//     (5.65, 0) @TEXT("BP", size=0.55, halign="end", valign="middle");
//     (0, 5) @PIN(terminal=5, direction="up");
//     @LINE {(0, 5) (0, 4)};
//     (-2, -5) @PIN(terminal=6, direction="down");
//     @LINE {(-2, -5) (-2, -4)};
//     (2, -5) @PIN(terminal=7, direction="down");
//     @LINE {(2, -5) (2, -4)};
//     (0, 0.3) @TEXT("Tristate nonoverlap driver j=8", size=0.7, bold=true, halign="middle", valign="bottom");
//     ? @TEXT("${name}", key="name", size=0.8, valign="bottom") => @PLACE(-6, 4.5);
//     ? @TEXT("${model}", key="model", size=0.5, halign="middle", valign="top") => @PLACE(0, -0.3)
//   };
//   # @SELECT-INSTANCE(model="mq_cdac_drv8") => @SET-SYMBOL $S_mq_cdac_drv8;
//   $S_mq_cdac_bit8 = @DEFINE-SYMBOL(box=[-7, -8, 7, 8]) {
//     @LINE(linewidth=0.24) {(-6, -7) (6, -7) (6, 7) (-6, 7) (-6, -7)};
//     (-7, 5) @PIN(terminal=1, direction="left");
//     @LINE {(-7, 5) (-6, 5)};
//     (-5.65, 5) @TEXT("VIN", size=0.55, halign="start", valign="middle");
//     (-7, 3) @PIN(terminal=2, direction="left");
//     @LINE {(-7, 3) (-6, 3)};
//     (-5.65, 3) @TEXT("VG", size=0.55, halign="start", valign="middle");
//     (-7, 1) @PIN(terminal=3, direction="left");
//     @LINE {(-7, 1) (-6, 1)};
//     (-5.65, 1) @TEXT("DH", size=0.55, halign="start", valign="middle");
//     (-7, -1) @PIN(terminal=4, direction="left");
//     @LINE {(-7, -1) (-6, -1)};
//     (-5.65, -1) @TEXT("RL", size=0.55, halign="start", valign="middle");
//     (-7, -3) @PIN(terminal=5, direction="left");
//     @LINE {(-7, -3) (-6, -3)};
//     (-5.65, -3) @TEXT("EN", size=0.55, halign="start", valign="middle");
//     (-7, -5) @PIN(terminal=6, direction="left");
//     @LINE {(-7, -5) (-6, -5)};
//     (-5.65, -5) @TEXT("ENB", size=0.55, halign="start", valign="middle");
//     (7, 0) @PIN(terminal=7, direction="right");
//     @LINE {(7, 0) (6, 0)};
//     (5.65, 0) @TEXT("TOP", size=0.55, halign="end", valign="middle");
//     (0, 8) @PIN(terminal=8, direction="up");
//     @LINE {(0, 8) (0, 7)};
//     (-2, -8) @PIN(terminal=9, direction="down");
//     @LINE {(-2, -8) (-2, -7)};
//     (2, -8) @PIN(terminal=10, direction="down");
//     @LINE {(2, -8) (2, -7)};
//     (0, 0.3) @TEXT("Matched half-capacitor pair j=8, weight 102", size=0.7, bold=true, halign="middle", valign="bottom");
//     ? @TEXT("${name}", key="name", size=0.8, valign="bottom") => @PLACE(-6, 7.5);
//     ? @TEXT("${model}", key="model", size=0.5, halign="middle", valign="top") => @PLACE(0, -0.3)
//   };
//   # @SELECT-INSTANCE(model="mq_cdac_bit8") => @SET-SYMBOL $S_mq_cdac_bit8;
//   $S_mq_cdac_drv7 = @DEFINE-SYMBOL(box=[-7, -5, 7, 5]) {
//     @LINE(linewidth=0.24) {(-6, -4) (6, -4) (6, 4) (-6, 4) (-6, -4)};
//     (-7, 2) @PIN(terminal=1, direction="left");
//     @LINE {(-7, 2) (-6, 2)};
//     (-5.65, 2) @TEXT("HI", size=0.55, halign="start", valign="middle");
//     (-7, 0) @PIN(terminal=2, direction="left");
//     @LINE {(-7, 0) (-6, 0)};
//     (-5.65, 0) @TEXT("EN", size=0.55, halign="start", valign="middle");
//     (-7, -2) @PIN(terminal=3, direction="left");
//     @LINE {(-7, -2) (-6, -2)};
//     (-5.65, -2) @TEXT("ENB", size=0.55, halign="start", valign="middle");
//     (7, 0) @PIN(terminal=4, direction="right");
//     @LINE {(7, 0) (6, 0)};
//     (5.65, 0) @TEXT("BP", size=0.55, halign="end", valign="middle");
//     (0, 5) @PIN(terminal=5, direction="up");
//     @LINE {(0, 5) (0, 4)};
//     (-2, -5) @PIN(terminal=6, direction="down");
//     @LINE {(-2, -5) (-2, -4)};
//     (2, -5) @PIN(terminal=7, direction="down");
//     @LINE {(2, -5) (2, -4)};
//     (0, 0.3) @TEXT("Tristate nonoverlap driver j=7", size=0.7, bold=true, halign="middle", valign="bottom");
//     ? @TEXT("${name}", key="name", size=0.8, valign="bottom") => @PLACE(-6, 4.5);
//     ? @TEXT("${model}", key="model", size=0.5, halign="middle", valign="top") => @PLACE(0, -0.3)
//   };
//   # @SELECT-INSTANCE(model="mq_cdac_drv7") => @SET-SYMBOL $S_mq_cdac_drv7;
//   $S_mq_cdac_bit7 = @DEFINE-SYMBOL(box=[-7, -8, 7, 8]) {
//     @LINE(linewidth=0.24) {(-6, -7) (6, -7) (6, 7) (-6, 7) (-6, -7)};
//     (-7, 5) @PIN(terminal=1, direction="left");
//     @LINE {(-7, 5) (-6, 5)};
//     (-5.65, 5) @TEXT("VIN", size=0.55, halign="start", valign="middle");
//     (-7, 3) @PIN(terminal=2, direction="left");
//     @LINE {(-7, 3) (-6, 3)};
//     (-5.65, 3) @TEXT("VG", size=0.55, halign="start", valign="middle");
//     (-7, 1) @PIN(terminal=3, direction="left");
//     @LINE {(-7, 1) (-6, 1)};
//     (-5.65, 1) @TEXT("DH", size=0.55, halign="start", valign="middle");
//     (-7, -1) @PIN(terminal=4, direction="left");
//     @LINE {(-7, -1) (-6, -1)};
//     (-5.65, -1) @TEXT("RL", size=0.55, halign="start", valign="middle");
//     (-7, -3) @PIN(terminal=5, direction="left");
//     @LINE {(-7, -3) (-6, -3)};
//     (-5.65, -3) @TEXT("EN", size=0.55, halign="start", valign="middle");
//     (-7, -5) @PIN(terminal=6, direction="left");
//     @LINE {(-7, -5) (-6, -5)};
//     (-5.65, -5) @TEXT("ENB", size=0.55, halign="start", valign="middle");
//     (7, 0) @PIN(terminal=7, direction="right");
//     @LINE {(7, 0) (6, 0)};
//     (5.65, 0) @TEXT("TOP", size=0.55, halign="end", valign="middle");
//     (0, 8) @PIN(terminal=8, direction="up");
//     @LINE {(0, 8) (0, 7)};
//     (-2, -8) @PIN(terminal=9, direction="down");
//     @LINE {(-2, -8) (-2, -7)};
//     (2, -8) @PIN(terminal=10, direction="down");
//     @LINE {(2, -8) (2, -7)};
//     (0, 0.3) @TEXT("Matched half-capacitor pair j=7, weight 57", size=0.7, bold=true, halign="middle", valign="bottom");
//     ? @TEXT("${name}", key="name", size=0.8, valign="bottom") => @PLACE(-6, 7.5);
//     ? @TEXT("${model}", key="model", size=0.5, halign="middle", valign="top") => @PLACE(0, -0.3)
//   };
//   # @SELECT-INSTANCE(model="mq_cdac_bit7") => @SET-SYMBOL $S_mq_cdac_bit7;
//   $S_mq_cdac_drv6 = @DEFINE-SYMBOL(box=[-7, -5, 7, 5]) {
//     @LINE(linewidth=0.24) {(-6, -4) (6, -4) (6, 4) (-6, 4) (-6, -4)};
//     (-7, 2) @PIN(terminal=1, direction="left");
//     @LINE {(-7, 2) (-6, 2)};
//     (-5.65, 2) @TEXT("HI", size=0.55, halign="start", valign="middle");
//     (-7, 0) @PIN(terminal=2, direction="left");
//     @LINE {(-7, 0) (-6, 0)};
//     (-5.65, 0) @TEXT("EN", size=0.55, halign="start", valign="middle");
//     (-7, -2) @PIN(terminal=3, direction="left");
//     @LINE {(-7, -2) (-6, -2)};
//     (-5.65, -2) @TEXT("ENB", size=0.55, halign="start", valign="middle");
//     (7, 0) @PIN(terminal=4, direction="right");
//     @LINE {(7, 0) (6, 0)};
//     (5.65, 0) @TEXT("BP", size=0.55, halign="end", valign="middle");
//     (0, 5) @PIN(terminal=5, direction="up");
//     @LINE {(0, 5) (0, 4)};
//     (-2, -5) @PIN(terminal=6, direction="down");
//     @LINE {(-2, -5) (-2, -4)};
//     (2, -5) @PIN(terminal=7, direction="down");
//     @LINE {(2, -5) (2, -4)};
//     (0, 0.3) @TEXT("Tristate nonoverlap driver j=6", size=0.7, bold=true, halign="middle", valign="bottom");
//     ? @TEXT("${name}", key="name", size=0.8, valign="bottom") => @PLACE(-6, 4.5);
//     ? @TEXT("${model}", key="model", size=0.5, halign="middle", valign="top") => @PLACE(0, -0.3)
//   };
//   # @SELECT-INSTANCE(model="mq_cdac_drv6") => @SET-SYMBOL $S_mq_cdac_drv6;
//   $S_mq_cdac_bit6 = @DEFINE-SYMBOL(box=[-7, -6, 7, 6]) {
//     @LINE(linewidth=0.24) {(-6, -5) (6, -5) (6, 5) (-6, 5) (-6, -5)};
//     (-7, 3) @PIN(terminal=1, direction="left");
//     @LINE {(-7, 3) (-6, 3)};
//     (-5.65, 3) @TEXT("DH", size=0.55, halign="start", valign="middle");
//     (-7, 1) @PIN(terminal=2, direction="left");
//     @LINE {(-7, 1) (-6, 1)};
//     (-5.65, 1) @TEXT("RL", size=0.55, halign="start", valign="middle");
//     (-7, -1) @PIN(terminal=3, direction="left");
//     @LINE {(-7, -1) (-6, -1)};
//     (-5.65, -1) @TEXT("EN", size=0.55, halign="start", valign="middle");
//     (-7, -3) @PIN(terminal=4, direction="left");
//     @LINE {(-7, -3) (-6, -3)};
//     (-5.65, -3) @TEXT("ENB", size=0.55, halign="start", valign="middle");
//     (7, 0) @PIN(terminal=5, direction="right");
//     @LINE {(7, 0) (6, 0)};
//     (5.65, 0) @TEXT("TOP", size=0.55, halign="end", valign="middle");
//     (0, 6) @PIN(terminal=6, direction="up");
//     @LINE {(0, 6) (0, 5)};
//     (-2, -6) @PIN(terminal=7, direction="down");
//     @LINE {(-2, -6) (-2, -5)};
//     (2, -6) @PIN(terminal=8, direction="down");
//     @LINE {(2, -6) (2, -5)};
//     (0, 0.3) @TEXT("Matched half-capacitor pair j=6, weight 32", size=0.7, bold=true, halign="middle", valign="bottom");
//     ? @TEXT("${name}", key="name", size=0.8, valign="bottom") => @PLACE(-6, 5.5);
//     ? @TEXT("${model}", key="model", size=0.5, halign="middle", valign="top") => @PLACE(0, -0.3)
//   };
//   # @SELECT-INSTANCE(model="mq_cdac_bit6") => @SET-SYMBOL $S_mq_cdac_bit6;
//   $S_mq_cdac_drv5 = @DEFINE-SYMBOL(box=[-7, -5, 7, 5]) {
//     @LINE(linewidth=0.24) {(-6, -4) (6, -4) (6, 4) (-6, 4) (-6, -4)};
//     (-7, 2) @PIN(terminal=1, direction="left");
//     @LINE {(-7, 2) (-6, 2)};
//     (-5.65, 2) @TEXT("HI", size=0.55, halign="start", valign="middle");
//     (-7, 0) @PIN(terminal=2, direction="left");
//     @LINE {(-7, 0) (-6, 0)};
//     (-5.65, 0) @TEXT("EN", size=0.55, halign="start", valign="middle");
//     (-7, -2) @PIN(terminal=3, direction="left");
//     @LINE {(-7, -2) (-6, -2)};
//     (-5.65, -2) @TEXT("ENB", size=0.55, halign="start", valign="middle");
//     (7, 0) @PIN(terminal=4, direction="right");
//     @LINE {(7, 0) (6, 0)};
//     (5.65, 0) @TEXT("BP", size=0.55, halign="end", valign="middle");
//     (0, 5) @PIN(terminal=5, direction="up");
//     @LINE {(0, 5) (0, 4)};
//     (-2, -5) @PIN(terminal=6, direction="down");
//     @LINE {(-2, -5) (-2, -4)};
//     (2, -5) @PIN(terminal=7, direction="down");
//     @LINE {(2, -5) (2, -4)};
//     (0, 0.3) @TEXT("Tristate nonoverlap driver j=5", size=0.7, bold=true, halign="middle", valign="bottom");
//     ? @TEXT("${name}", key="name", size=0.8, valign="bottom") => @PLACE(-6, 4.5);
//     ? @TEXT("${model}", key="model", size=0.5, halign="middle", valign="top") => @PLACE(0, -0.3)
//   };
//   # @SELECT-INSTANCE(model="mq_cdac_drv5") => @SET-SYMBOL $S_mq_cdac_drv5;
//   $S_mq_cdac_bit5 = @DEFINE-SYMBOL(box=[-7, -8, 7, 8]) {
//     @LINE(linewidth=0.24) {(-6, -7) (6, -7) (6, 7) (-6, 7) (-6, -7)};
//     (-7, 5) @PIN(terminal=1, direction="left");
//     @LINE {(-7, 5) (-6, 5)};
//     (-5.65, 5) @TEXT("VIN", size=0.55, halign="start", valign="middle");
//     (-7, 3) @PIN(terminal=2, direction="left");
//     @LINE {(-7, 3) (-6, 3)};
//     (-5.65, 3) @TEXT("VG", size=0.55, halign="start", valign="middle");
//     (-7, 1) @PIN(terminal=3, direction="left");
//     @LINE {(-7, 1) (-6, 1)};
//     (-5.65, 1) @TEXT("DH", size=0.55, halign="start", valign="middle");
//     (-7, -1) @PIN(terminal=4, direction="left");
//     @LINE {(-7, -1) (-6, -1)};
//     (-5.65, -1) @TEXT("RL", size=0.55, halign="start", valign="middle");
//     (-7, -3) @PIN(terminal=5, direction="left");
//     @LINE {(-7, -3) (-6, -3)};
//     (-5.65, -3) @TEXT("EN", size=0.55, halign="start", valign="middle");
//     (-7, -5) @PIN(terminal=6, direction="left");
//     @LINE {(-7, -5) (-6, -5)};
//     (-5.65, -5) @TEXT("ENB", size=0.55, halign="start", valign="middle");
//     (7, 0) @PIN(terminal=7, direction="right");
//     @LINE {(7, 0) (6, 0)};
//     (5.65, 0) @TEXT("TOP", size=0.55, halign="end", valign="middle");
//     (0, 8) @PIN(terminal=8, direction="up");
//     @LINE {(0, 8) (0, 7)};
//     (-2, -8) @PIN(terminal=9, direction="down");
//     @LINE {(-2, -8) (-2, -7)};
//     (2, -8) @PIN(terminal=10, direction="down");
//     @LINE {(2, -8) (2, -7)};
//     (0, 0.3) @TEXT("Matched half-capacitor pair j=5, weight 18", size=0.7, bold=true, halign="middle", valign="bottom");
//     ? @TEXT("${name}", key="name", size=0.8, valign="bottom") => @PLACE(-6, 7.5);
//     ? @TEXT("${model}", key="model", size=0.5, halign="middle", valign="top") => @PLACE(0, -0.3)
//   };
//   # @SELECT-INSTANCE(model="mq_cdac_bit5") => @SET-SYMBOL $S_mq_cdac_bit5;
//   $S_mq_cdac_drv4 = @DEFINE-SYMBOL(box=[-7, -5, 7, 5]) {
//     @LINE(linewidth=0.24) {(-6, -4) (6, -4) (6, 4) (-6, 4) (-6, -4)};
//     (-7, 2) @PIN(terminal=1, direction="left");
//     @LINE {(-7, 2) (-6, 2)};
//     (-5.65, 2) @TEXT("HI", size=0.55, halign="start", valign="middle");
//     (-7, 0) @PIN(terminal=2, direction="left");
//     @LINE {(-7, 0) (-6, 0)};
//     (-5.65, 0) @TEXT("EN", size=0.55, halign="start", valign="middle");
//     (-7, -2) @PIN(terminal=3, direction="left");
//     @LINE {(-7, -2) (-6, -2)};
//     (-5.65, -2) @TEXT("ENB", size=0.55, halign="start", valign="middle");
//     (7, 0) @PIN(terminal=4, direction="right");
//     @LINE {(7, 0) (6, 0)};
//     (5.65, 0) @TEXT("BP", size=0.55, halign="end", valign="middle");
//     (0, 5) @PIN(terminal=5, direction="up");
//     @LINE {(0, 5) (0, 4)};
//     (-2, -5) @PIN(terminal=6, direction="down");
//     @LINE {(-2, -5) (-2, -4)};
//     (2, -5) @PIN(terminal=7, direction="down");
//     @LINE {(2, -5) (2, -4)};
//     (0, 0.3) @TEXT("Tristate nonoverlap driver j=4", size=0.7, bold=true, halign="middle", valign="bottom");
//     ? @TEXT("${name}", key="name", size=0.8, valign="bottom") => @PLACE(-6, 4.5);
//     ? @TEXT("${model}", key="model", size=0.5, halign="middle", valign="top") => @PLACE(0, -0.3)
//   };
//   # @SELECT-INSTANCE(model="mq_cdac_drv4") => @SET-SYMBOL $S_mq_cdac_drv4;
//   $S_mq_cdac_bit4 = @DEFINE-SYMBOL(box=[-7, -8, 7, 8]) {
//     @LINE(linewidth=0.24) {(-6, -7) (6, -7) (6, 7) (-6, 7) (-6, -7)};
//     (-7, 5) @PIN(terminal=1, direction="left");
//     @LINE {(-7, 5) (-6, 5)};
//     (-5.65, 5) @TEXT("VIN", size=0.55, halign="start", valign="middle");
//     (-7, 3) @PIN(terminal=2, direction="left");
//     @LINE {(-7, 3) (-6, 3)};
//     (-5.65, 3) @TEXT("VG", size=0.55, halign="start", valign="middle");
//     (-7, 1) @PIN(terminal=3, direction="left");
//     @LINE {(-7, 1) (-6, 1)};
//     (-5.65, 1) @TEXT("DH", size=0.55, halign="start", valign="middle");
//     (-7, -1) @PIN(terminal=4, direction="left");
//     @LINE {(-7, -1) (-6, -1)};
//     (-5.65, -1) @TEXT("RL", size=0.55, halign="start", valign="middle");
//     (-7, -3) @PIN(terminal=5, direction="left");
//     @LINE {(-7, -3) (-6, -3)};
//     (-5.65, -3) @TEXT("EN", size=0.55, halign="start", valign="middle");
//     (-7, -5) @PIN(terminal=6, direction="left");
//     @LINE {(-7, -5) (-6, -5)};
//     (-5.65, -5) @TEXT("ENB", size=0.55, halign="start", valign="middle");
//     (7, 0) @PIN(terminal=7, direction="right");
//     @LINE {(7, 0) (6, 0)};
//     (5.65, 0) @TEXT("TOP", size=0.55, halign="end", valign="middle");
//     (0, 8) @PIN(terminal=8, direction="up");
//     @LINE {(0, 8) (0, 7)};
//     (-2, -8) @PIN(terminal=9, direction="down");
//     @LINE {(-2, -8) (-2, -7)};
//     (2, -8) @PIN(terminal=10, direction="down");
//     @LINE {(2, -8) (2, -7)};
//     (0, 0.3) @TEXT("Matched half-capacitor pair j=4, weight 10", size=0.7, bold=true, halign="middle", valign="bottom");
//     ? @TEXT("${name}", key="name", size=0.8, valign="bottom") => @PLACE(-6, 7.5);
//     ? @TEXT("${model}", key="model", size=0.5, halign="middle", valign="top") => @PLACE(0, -0.3)
//   };
//   # @SELECT-INSTANCE(model="mq_cdac_bit4") => @SET-SYMBOL $S_mq_cdac_bit4;
//   $S_mq_cdac_drv3 = @DEFINE-SYMBOL(box=[-7, -5, 7, 5]) {
//     @LINE(linewidth=0.24) {(-6, -4) (6, -4) (6, 4) (-6, 4) (-6, -4)};
//     (-7, 2) @PIN(terminal=1, direction="left");
//     @LINE {(-7, 2) (-6, 2)};
//     (-5.65, 2) @TEXT("HI", size=0.55, halign="start", valign="middle");
//     (-7, 0) @PIN(terminal=2, direction="left");
//     @LINE {(-7, 0) (-6, 0)};
//     (-5.65, 0) @TEXT("EN", size=0.55, halign="start", valign="middle");
//     (-7, -2) @PIN(terminal=3, direction="left");
//     @LINE {(-7, -2) (-6, -2)};
//     (-5.65, -2) @TEXT("ENB", size=0.55, halign="start", valign="middle");
//     (7, 0) @PIN(terminal=4, direction="right");
//     @LINE {(7, 0) (6, 0)};
//     (5.65, 0) @TEXT("BP", size=0.55, halign="end", valign="middle");
//     (0, 5) @PIN(terminal=5, direction="up");
//     @LINE {(0, 5) (0, 4)};
//     (-2, -5) @PIN(terminal=6, direction="down");
//     @LINE {(-2, -5) (-2, -4)};
//     (2, -5) @PIN(terminal=7, direction="down");
//     @LINE {(2, -5) (2, -4)};
//     (0, 0.3) @TEXT("Tristate nonoverlap driver j=3", size=0.7, bold=true, halign="middle", valign="bottom");
//     ? @TEXT("${name}", key="name", size=0.8, valign="bottom") => @PLACE(-6, 4.5);
//     ? @TEXT("${model}", key="model", size=0.5, halign="middle", valign="top") => @PLACE(0, -0.3)
//   };
//   # @SELECT-INSTANCE(model="mq_cdac_drv3") => @SET-SYMBOL $S_mq_cdac_drv3;
//   $S_mq_cdac_bit3 = @DEFINE-SYMBOL(box=[-7, -8, 7, 8]) {
//     @LINE(linewidth=0.24) {(-6, -7) (6, -7) (6, 7) (-6, 7) (-6, -7)};
//     (-7, 5) @PIN(terminal=1, direction="left");
//     @LINE {(-7, 5) (-6, 5)};
//     (-5.65, 5) @TEXT("VIN", size=0.55, halign="start", valign="middle");
//     (-7, 3) @PIN(terminal=2, direction="left");
//     @LINE {(-7, 3) (-6, 3)};
//     (-5.65, 3) @TEXT("VG", size=0.55, halign="start", valign="middle");
//     (-7, 1) @PIN(terminal=3, direction="left");
//     @LINE {(-7, 1) (-6, 1)};
//     (-5.65, 1) @TEXT("DH", size=0.55, halign="start", valign="middle");
//     (-7, -1) @PIN(terminal=4, direction="left");
//     @LINE {(-7, -1) (-6, -1)};
//     (-5.65, -1) @TEXT("RL", size=0.55, halign="start", valign="middle");
//     (-7, -3) @PIN(terminal=5, direction="left");
//     @LINE {(-7, -3) (-6, -3)};
//     (-5.65, -3) @TEXT("EN", size=0.55, halign="start", valign="middle");
//     (-7, -5) @PIN(terminal=6, direction="left");
//     @LINE {(-7, -5) (-6, -5)};
//     (-5.65, -5) @TEXT("ENB", size=0.55, halign="start", valign="middle");
//     (7, 0) @PIN(terminal=7, direction="right");
//     @LINE {(7, 0) (6, 0)};
//     (5.65, 0) @TEXT("TOP", size=0.55, halign="end", valign="middle");
//     (0, 8) @PIN(terminal=8, direction="up");
//     @LINE {(0, 8) (0, 7)};
//     (-2, -8) @PIN(terminal=9, direction="down");
//     @LINE {(-2, -8) (-2, -7)};
//     (2, -8) @PIN(terminal=10, direction="down");
//     @LINE {(2, -8) (2, -7)};
//     (0, 0.3) @TEXT("Matched half-capacitor pair j=3, weight 6", size=0.7, bold=true, halign="middle", valign="bottom");
//     ? @TEXT("${name}", key="name", size=0.8, valign="bottom") => @PLACE(-6, 7.5);
//     ? @TEXT("${model}", key="model", size=0.5, halign="middle", valign="top") => @PLACE(0, -0.3)
//   };
//   # @SELECT-INSTANCE(model="mq_cdac_bit3") => @SET-SYMBOL $S_mq_cdac_bit3;
//   $S_mq_cdac_drv2 = @DEFINE-SYMBOL(box=[-7, -5, 7, 5]) {
//     @LINE(linewidth=0.24) {(-6, -4) (6, -4) (6, 4) (-6, 4) (-6, -4)};
//     (-7, 2) @PIN(terminal=1, direction="left");
//     @LINE {(-7, 2) (-6, 2)};
//     (-5.65, 2) @TEXT("HI", size=0.55, halign="start", valign="middle");
//     (-7, 0) @PIN(terminal=2, direction="left");
//     @LINE {(-7, 0) (-6, 0)};
//     (-5.65, 0) @TEXT("EN", size=0.55, halign="start", valign="middle");
//     (-7, -2) @PIN(terminal=3, direction="left");
//     @LINE {(-7, -2) (-6, -2)};
//     (-5.65, -2) @TEXT("ENB", size=0.55, halign="start", valign="middle");
//     (7, 0) @PIN(terminal=4, direction="right");
//     @LINE {(7, 0) (6, 0)};
//     (5.65, 0) @TEXT("BP", size=0.55, halign="end", valign="middle");
//     (0, 5) @PIN(terminal=5, direction="up");
//     @LINE {(0, 5) (0, 4)};
//     (-2, -5) @PIN(terminal=6, direction="down");
//     @LINE {(-2, -5) (-2, -4)};
//     (2, -5) @PIN(terminal=7, direction="down");
//     @LINE {(2, -5) (2, -4)};
//     (0, 0.3) @TEXT("Tristate nonoverlap driver j=2", size=0.7, bold=true, halign="middle", valign="bottom");
//     ? @TEXT("${name}", key="name", size=0.8, valign="bottom") => @PLACE(-6, 4.5);
//     ? @TEXT("${model}", key="model", size=0.5, halign="middle", valign="top") => @PLACE(0, -0.3)
//   };
//   # @SELECT-INSTANCE(model="mq_cdac_drv2") => @SET-SYMBOL $S_mq_cdac_drv2;
//   $S_mq_cdac_bit2 = @DEFINE-SYMBOL(box=[-7, -8, 7, 8]) {
//     @LINE(linewidth=0.24) {(-6, -7) (6, -7) (6, 7) (-6, 7) (-6, -7)};
//     (-7, 5) @PIN(terminal=1, direction="left");
//     @LINE {(-7, 5) (-6, 5)};
//     (-5.65, 5) @TEXT("VIN", size=0.55, halign="start", valign="middle");
//     (-7, 3) @PIN(terminal=2, direction="left");
//     @LINE {(-7, 3) (-6, 3)};
//     (-5.65, 3) @TEXT("VG", size=0.55, halign="start", valign="middle");
//     (-7, 1) @PIN(terminal=3, direction="left");
//     @LINE {(-7, 1) (-6, 1)};
//     (-5.65, 1) @TEXT("DH", size=0.55, halign="start", valign="middle");
//     (-7, -1) @PIN(terminal=4, direction="left");
//     @LINE {(-7, -1) (-6, -1)};
//     (-5.65, -1) @TEXT("RL", size=0.55, halign="start", valign="middle");
//     (-7, -3) @PIN(terminal=5, direction="left");
//     @LINE {(-7, -3) (-6, -3)};
//     (-5.65, -3) @TEXT("EN", size=0.55, halign="start", valign="middle");
//     (-7, -5) @PIN(terminal=6, direction="left");
//     @LINE {(-7, -5) (-6, -5)};
//     (-5.65, -5) @TEXT("ENB", size=0.55, halign="start", valign="middle");
//     (7, 0) @PIN(terminal=7, direction="right");
//     @LINE {(7, 0) (6, 0)};
//     (5.65, 0) @TEXT("TOP", size=0.55, halign="end", valign="middle");
//     (0, 8) @PIN(terminal=8, direction="up");
//     @LINE {(0, 8) (0, 7)};
//     (-2, -8) @PIN(terminal=9, direction="down");
//     @LINE {(-2, -8) (-2, -7)};
//     (2, -8) @PIN(terminal=10, direction="down");
//     @LINE {(2, -8) (2, -7)};
//     (0, 0.3) @TEXT("Matched half-capacitor pair j=2, weight 3", size=0.7, bold=true, halign="middle", valign="bottom");
//     ? @TEXT("${name}", key="name", size=0.8, valign="bottom") => @PLACE(-6, 7.5);
//     ? @TEXT("${model}", key="model", size=0.5, halign="middle", valign="top") => @PLACE(0, -0.3)
//   };
//   # @SELECT-INSTANCE(model="mq_cdac_bit2") => @SET-SYMBOL $S_mq_cdac_bit2;
//   $S_mq_cdac_drv1 = @DEFINE-SYMBOL(box=[-7, -5, 7, 5]) {
//     @LINE(linewidth=0.24) {(-6, -4) (6, -4) (6, 4) (-6, 4) (-6, -4)};
//     (-7, 2) @PIN(terminal=1, direction="left");
//     @LINE {(-7, 2) (-6, 2)};
//     (-5.65, 2) @TEXT("HI", size=0.55, halign="start", valign="middle");
//     (-7, 0) @PIN(terminal=2, direction="left");
//     @LINE {(-7, 0) (-6, 0)};
//     (-5.65, 0) @TEXT("EN", size=0.55, halign="start", valign="middle");
//     (-7, -2) @PIN(terminal=3, direction="left");
//     @LINE {(-7, -2) (-6, -2)};
//     (-5.65, -2) @TEXT("ENB", size=0.55, halign="start", valign="middle");
//     (7, 0) @PIN(terminal=4, direction="right");
//     @LINE {(7, 0) (6, 0)};
//     (5.65, 0) @TEXT("BP", size=0.55, halign="end", valign="middle");
//     (0, 5) @PIN(terminal=5, direction="up");
//     @LINE {(0, 5) (0, 4)};
//     (-2, -5) @PIN(terminal=6, direction="down");
//     @LINE {(-2, -5) (-2, -4)};
//     (2, -5) @PIN(terminal=7, direction="down");
//     @LINE {(2, -5) (2, -4)};
//     (0, 0.3) @TEXT("Tristate nonoverlap driver j=1", size=0.7, bold=true, halign="middle", valign="bottom");
//     ? @TEXT("${name}", key="name", size=0.8, valign="bottom") => @PLACE(-6, 4.5);
//     ? @TEXT("${model}", key="model", size=0.5, halign="middle", valign="top") => @PLACE(0, -0.3)
//   };
//   # @SELECT-INSTANCE(model="mq_cdac_drv1") => @SET-SYMBOL $S_mq_cdac_drv1;
//   $S_mq_cdac_bit1 = @DEFINE-SYMBOL(box=[-7, -8, 7, 8]) {
//     @LINE(linewidth=0.24) {(-6, -7) (6, -7) (6, 7) (-6, 7) (-6, -7)};
//     (-7, 5) @PIN(terminal=1, direction="left");
//     @LINE {(-7, 5) (-6, 5)};
//     (-5.65, 5) @TEXT("VIN", size=0.55, halign="start", valign="middle");
//     (-7, 3) @PIN(terminal=2, direction="left");
//     @LINE {(-7, 3) (-6, 3)};
//     (-5.65, 3) @TEXT("VG", size=0.55, halign="start", valign="middle");
//     (-7, 1) @PIN(terminal=3, direction="left");
//     @LINE {(-7, 1) (-6, 1)};
//     (-5.65, 1) @TEXT("DH", size=0.55, halign="start", valign="middle");
//     (-7, -1) @PIN(terminal=4, direction="left");
//     @LINE {(-7, -1) (-6, -1)};
//     (-5.65, -1) @TEXT("RL", size=0.55, halign="start", valign="middle");
//     (-7, -3) @PIN(terminal=5, direction="left");
//     @LINE {(-7, -3) (-6, -3)};
//     (-5.65, -3) @TEXT("EN", size=0.55, halign="start", valign="middle");
//     (-7, -5) @PIN(terminal=6, direction="left");
//     @LINE {(-7, -5) (-6, -5)};
//     (-5.65, -5) @TEXT("ENB", size=0.55, halign="start", valign="middle");
//     (7, 0) @PIN(terminal=7, direction="right");
//     @LINE {(7, 0) (6, 0)};
//     (5.65, 0) @TEXT("TOP", size=0.55, halign="end", valign="middle");
//     (0, 8) @PIN(terminal=8, direction="up");
//     @LINE {(0, 8) (0, 7)};
//     (-2, -8) @PIN(terminal=9, direction="down");
//     @LINE {(-2, -8) (-2, -7)};
//     (2, -8) @PIN(terminal=10, direction="down");
//     @LINE {(2, -8) (2, -7)};
//     (0, 0.3) @TEXT("Matched half-capacitor pair j=1, weight 2", size=0.7, bold=true, halign="middle", valign="bottom");
//     ? @TEXT("${name}", key="name", size=0.8, valign="bottom") => @PLACE(-6, 7.5);
//     ? @TEXT("${model}", key="model", size=0.5, halign="middle", valign="top") => @PLACE(0, -0.3)
//   };
//   # @SELECT-INSTANCE(model="mq_cdac_bit1") => @SET-SYMBOL $S_mq_cdac_bit1;
//   $S_mq_cdac_drv0 = @DEFINE-SYMBOL(box=[-7, -5, 7, 5]) {
//     @LINE(linewidth=0.24) {(-6, -4) (6, -4) (6, 4) (-6, 4) (-6, -4)};
//     (-7, 2) @PIN(terminal=1, direction="left");
//     @LINE {(-7, 2) (-6, 2)};
//     (-5.65, 2) @TEXT("HI", size=0.55, halign="start", valign="middle");
//     (-7, 0) @PIN(terminal=2, direction="left");
//     @LINE {(-7, 0) (-6, 0)};
//     (-5.65, 0) @TEXT("EN", size=0.55, halign="start", valign="middle");
//     (-7, -2) @PIN(terminal=3, direction="left");
//     @LINE {(-7, -2) (-6, -2)};
//     (-5.65, -2) @TEXT("ENB", size=0.55, halign="start", valign="middle");
//     (7, 0) @PIN(terminal=4, direction="right");
//     @LINE {(7, 0) (6, 0)};
//     (5.65, 0) @TEXT("BP", size=0.55, halign="end", valign="middle");
//     (0, 5) @PIN(terminal=5, direction="up");
//     @LINE {(0, 5) (0, 4)};
//     (-2, -5) @PIN(terminal=6, direction="down");
//     @LINE {(-2, -5) (-2, -4)};
//     (2, -5) @PIN(terminal=7, direction="down");
//     @LINE {(2, -5) (2, -4)};
//     (0, 0.3) @TEXT("Tristate nonoverlap driver j=0", size=0.7, bold=true, halign="middle", valign="bottom");
//     ? @TEXT("${name}", key="name", size=0.8, valign="bottom") => @PLACE(-6, 4.5);
//     ? @TEXT("${model}", key="model", size=0.5, halign="middle", valign="top") => @PLACE(0, -0.3)
//   };
//   # @SELECT-INSTANCE(model="mq_cdac_drv0") => @SET-SYMBOL $S_mq_cdac_drv0;
//   $S_mq_cdac_bit0 = @DEFINE-SYMBOL(box=[-7, -8, 7, 8]) {
//     @LINE(linewidth=0.24) {(-6, -7) (6, -7) (6, 7) (-6, 7) (-6, -7)};
//     (-7, 5) @PIN(terminal=1, direction="left");
//     @LINE {(-7, 5) (-6, 5)};
//     (-5.65, 5) @TEXT("VIN", size=0.55, halign="start", valign="middle");
//     (-7, 3) @PIN(terminal=2, direction="left");
//     @LINE {(-7, 3) (-6, 3)};
//     (-5.65, 3) @TEXT("VG", size=0.55, halign="start", valign="middle");
//     (-7, 1) @PIN(terminal=3, direction="left");
//     @LINE {(-7, 1) (-6, 1)};
//     (-5.65, 1) @TEXT("DH", size=0.55, halign="start", valign="middle");
//     (-7, -1) @PIN(terminal=4, direction="left");
//     @LINE {(-7, -1) (-6, -1)};
//     (-5.65, -1) @TEXT("RL", size=0.55, halign="start", valign="middle");
//     (-7, -3) @PIN(terminal=5, direction="left");
//     @LINE {(-7, -3) (-6, -3)};
//     (-5.65, -3) @TEXT("EN", size=0.55, halign="start", valign="middle");
//     (-7, -5) @PIN(terminal=6, direction="left");
//     @LINE {(-7, -5) (-6, -5)};
//     (-5.65, -5) @TEXT("ENB", size=0.55, halign="start", valign="middle");
//     (7, 0) @PIN(terminal=7, direction="right");
//     @LINE {(7, 0) (6, 0)};
//     (5.65, 0) @TEXT("TOP", size=0.55, halign="end", valign="middle");
//     (0, 8) @PIN(terminal=8, direction="up");
//     @LINE {(0, 8) (0, 7)};
//     (-2, -8) @PIN(terminal=9, direction="down");
//     @LINE {(-2, -8) (-2, -7)};
//     (2, -8) @PIN(terminal=10, direction="down");
//     @LINE {(2, -8) (2, -7)};
//     (0, 0.3) @TEXT("Matched half-capacitor pair j=0, weight 1", size=0.7, bold=true, halign="middle", valign="bottom");
//     ? @TEXT("${name}", key="name", size=0.8, valign="bottom") => @PLACE(-6, 7.5);
//     ? @TEXT("${model}", key="model", size=0.5, halign="middle", valign="top") => @PLACE(0, -0.3)
//   };
//   # @SELECT-INSTANCE(model="mq_cdac_bit0") => @SET-SYMBOL $S_mq_cdac_bit0
// }

// Reference-domain command buffer L
subckt mq_cdac_ctl_l (IN HI VREFP VREFN VSS)
// The first PMOS uses a higher threshold than the output logic for the low-DVDD/high-reference condition.
M0N (I0 IN VREFN VSS) nch_ulvt_mac w=4e-07 l=3e-08 nf=1
M0P (I0 IN VREFP VREFP) pch_mac w=8e-07 l=3e-08 nf=1
M1N (HI I0 VREFN VSS) nch_ulvt_mac w=2e-06 l=3e-08 nf=1
M1P (HI I0 VREFP VREFP) pch_ulvt_mac w=4e-06 l=3e-08 nf=2
// @RNL {
//   /* pins connected by net name: the net-name label of rnl-std-fill on every unwired pin, placed below by its key netname */
//   $LABEL_TERMINAL_SET @TEXT("${net}", key="netname", size=0.6);
//   &VSS @ADD-TO $GROUND_NET_SET; &VREFN @ADD-TO $GROUND_NET_SET; &VREFP @ADD-TO $SUPPLY_NET_SET;
//   {#M0N #M0P} @GROUP;
//   {#M1N #M1P} @GROUP;
//   #M0N @PLACE(0, 0);
//   #M0N @ORIENT("R0");
//   #M0N:1 @TEXT("${net}", key="netname", size=0.6, halign="start", valign="middle", rotate=90, dx=0, dy=0.4);
//   #M0N:2 @TEXT("${net}", key="netname", size=0.6, halign="end", valign="middle", dx=-0.4, dy=0);
//   %g1 = $GROUND @ATTACH &VREFN => @PLACE(0, -5.2);
//   &VREFN @WIRE {#M0N:3 (0, -2) %g1:p};
//   %g2 = $GROUND @ATTACH &VSS => @PLACE(3, -3.2);
//   &VSS @WIRE {#M0N:4 (3, 0) %g2:p};
//   #M0P @PLACE(0, 10);
//   #M0P @ORIENT("R0");
//   #M0P:1 @TEXT("${net}", key="netname", size=0.6, halign="end", valign="middle", rotate=90, dx=0, dy=-0.4);
//   #M0P:2 @TEXT("${net}", key="netname", size=0.6, halign="end", valign="middle", dx=-0.4, dy=0);
//   %v3 = $SUPPLY @ATTACH &VREFP => @PLACE(0, 15.2);
//   &VREFP @WIRE {#M0P:3 (0, 12) %v3:p};
//   %v4 = $SUPPLY @ATTACH &VREFP => @PLACE(3, 13.2);
//   &VREFP @WIRE {#M0P:4 (3, 10) %v4:p};
//   #M1N @PLACE(24, 0);
//   #M1N @ORIENT("R0");
//   #M1N:1 @TEXT("${net}", key="netname", size=0.6, halign="start", valign="middle", rotate=90, dx=0, dy=0.4);
//   #M1N:2 @TEXT("${net}", key="netname", size=0.6, halign="end", valign="middle", dx=-0.4, dy=0);
//   %g5 = $GROUND @ATTACH &VREFN => @PLACE(24, -5.2);
//   &VREFN @WIRE {#M1N:3 (24, -2) %g5:p};
//   %g6 = $GROUND @ATTACH &VSS => @PLACE(27, -3.2);
//   &VSS @WIRE {#M1N:4 (27, 0) %g6:p};
//   #M1P @PLACE(24, 10);
//   #M1P @ORIENT("R0");
//   #M1P:1 @TEXT("${net}", key="netname", size=0.6, halign="end", valign="middle", rotate=90, dx=0, dy=-0.4);
//   #M1P:2 @TEXT("${net}", key="netname", size=0.6, halign="end", valign="middle", dx=-0.4, dy=0);
//   %v7 = $SUPPLY @ATTACH &VREFP => @PLACE(24, 15.2);
//   &VREFP @WIRE {#M1P:3 (24, 12) %v7:p};
//   %v8 = $SUPPLY @ATTACH &VREFP => @PLACE(27, 13.2);
//   &VREFP @WIRE {#M1P:4 (27, 10) %v8:p};
//   &I0 @WIRE {#M0N:1 #M0P:1};
//   &IN @WIRE {#M0N:2 (-5, 0) (-5, 10) #M0P:2};
//   &HI @WIRE {#M1N:1 #M1P:1};
//   &I0 @WIRE {#M1N:2 (19, 0) (19, 10) #M1P:2};
//   %p_in = $IO_PORT @ATTACH &IN => @PLACE(-7, 0) => @ORIENT("R0");
//   &IN @WIRE {%p_in:p #M0N:2};
//   %p_hi = $IO_PORT @ATTACH &HI => @PLACE(24, 6) => @ORIENT("R270");
//   &HI @WIRE {%p_hi:p #M1N:1};
//   (-10, 32) @TEXT("Reference-domain command buffer L") => @SET-STYLE $title_style
// }
ends mq_cdac_ctl_l

// Reference-domain command buffer H
subckt mq_cdac_ctl_h (IN HI VREFP VREFN VSS)
// The first PMOS uses a higher threshold than the output logic for the low-DVDD/high-reference condition.
M0N (I0 IN VREFN VSS) nch_ulvt_mac w=4e-07 l=3e-08 nf=1
M0P (I0 IN VREFP VREFP) pch_mac w=8e-07 l=3e-08 nf=1
M1N (I1 I0 VREFN VSS) nch_ulvt_mac w=2e-06 l=3e-08 nf=1
M1P (I1 I0 VREFP VREFP) pch_ulvt_mac w=4e-06 l=3e-08 nf=2
M2N (HI I1 VREFN VSS) nch_ulvt_mac w=2e-06 l=3e-08 nf=1
M2P (HI I1 VREFP VREFP) pch_ulvt_mac w=4e-06 l=3e-08 nf=2
// @RNL {
//   /* pins connected by net name: the net-name label of rnl-std-fill on every unwired pin, placed below by its key netname */
//   $LABEL_TERMINAL_SET @TEXT("${net}", key="netname", size=0.6);
//   &VSS @ADD-TO $GROUND_NET_SET; &VREFN @ADD-TO $GROUND_NET_SET; &VREFP @ADD-TO $SUPPLY_NET_SET;
//   {#M0N #M0P} @GROUP;
//   {#M1N #M1P} @GROUP;
//   {#M2N #M2P} @GROUP;
//   #M0N @PLACE(0, 0);
//   #M0N @ORIENT("R0");
//   #M0N:1 @TEXT("${net}", key="netname", size=0.6, halign="start", valign="middle", rotate=90, dx=0, dy=0.4);
//   #M0N:2 @TEXT("${net}", key="netname", size=0.6, halign="end", valign="middle", dx=-0.4, dy=0);
//   %g1 = $GROUND @ATTACH &VREFN => @PLACE(0, -5.2);
//   &VREFN @WIRE {#M0N:3 (0, -2) %g1:p};
//   %g2 = $GROUND @ATTACH &VSS => @PLACE(3, -3.2);
//   &VSS @WIRE {#M0N:4 (3, 0) %g2:p};
//   #M0P @PLACE(0, 10);
//   #M0P @ORIENT("R0");
//   #M0P:1 @TEXT("${net}", key="netname", size=0.6, halign="end", valign="middle", rotate=90, dx=0, dy=-0.4);
//   #M0P:2 @TEXT("${net}", key="netname", size=0.6, halign="end", valign="middle", dx=-0.4, dy=0);
//   %v3 = $SUPPLY @ATTACH &VREFP => @PLACE(0, 15.2);
//   &VREFP @WIRE {#M0P:3 (0, 12) %v3:p};
//   %v4 = $SUPPLY @ATTACH &VREFP => @PLACE(3, 13.2);
//   &VREFP @WIRE {#M0P:4 (3, 10) %v4:p};
//   #M1N @PLACE(24, 0);
//   #M1N @ORIENT("R0");
//   #M1N:1 @TEXT("${net}", key="netname", size=0.6, halign="start", valign="middle", rotate=90, dx=0, dy=0.4);
//   #M1N:2 @TEXT("${net}", key="netname", size=0.6, halign="end", valign="middle", dx=-0.4, dy=0);
//   %g5 = $GROUND @ATTACH &VREFN => @PLACE(24, -5.2);
//   &VREFN @WIRE {#M1N:3 (24, -2) %g5:p};
//   %g6 = $GROUND @ATTACH &VSS => @PLACE(27, -3.2);
//   &VSS @WIRE {#M1N:4 (27, 0) %g6:p};
//   #M1P @PLACE(24, 10);
//   #M1P @ORIENT("R0");
//   #M1P:1 @TEXT("${net}", key="netname", size=0.6, halign="end", valign="middle", rotate=90, dx=0, dy=-0.4);
//   #M1P:2 @TEXT("${net}", key="netname", size=0.6, halign="end", valign="middle", dx=-0.4, dy=0);
//   %v7 = $SUPPLY @ATTACH &VREFP => @PLACE(24, 15.2);
//   &VREFP @WIRE {#M1P:3 (24, 12) %v7:p};
//   %v8 = $SUPPLY @ATTACH &VREFP => @PLACE(27, 13.2);
//   &VREFP @WIRE {#M1P:4 (27, 10) %v8:p};
//   #M2N @PLACE(48, 0);
//   #M2N @ORIENT("R0");
//   #M2N:1 @TEXT("${net}", key="netname", size=0.6, halign="start", valign="middle", rotate=90, dx=0, dy=0.4);
//   #M2N:2 @TEXT("${net}", key="netname", size=0.6, halign="end", valign="middle", dx=-0.4, dy=0);
//   %g9 = $GROUND @ATTACH &VREFN => @PLACE(48, -5.2);
//   &VREFN @WIRE {#M2N:3 (48, -2) %g9:p};
//   %g10 = $GROUND @ATTACH &VSS => @PLACE(51, -3.2);
//   &VSS @WIRE {#M2N:4 (51, 0) %g10:p};
//   #M2P @PLACE(48, 10);
//   #M2P @ORIENT("R0");
//   #M2P:1 @TEXT("${net}", key="netname", size=0.6, halign="end", valign="middle", rotate=90, dx=0, dy=-0.4);
//   #M2P:2 @TEXT("${net}", key="netname", size=0.6, halign="end", valign="middle", dx=-0.4, dy=0);
//   %v11 = $SUPPLY @ATTACH &VREFP => @PLACE(48, 15.2);
//   &VREFP @WIRE {#M2P:3 (48, 12) %v11:p};
//   %v12 = $SUPPLY @ATTACH &VREFP => @PLACE(51, 13.2);
//   &VREFP @WIRE {#M2P:4 (51, 10) %v12:p};
//   &I0 @WIRE {#M0N:1 #M0P:1};
//   &IN @WIRE {#M0N:2 (-5, 0) (-5, 10) #M0P:2};
//   &I1 @WIRE {#M1N:1 #M1P:1};
//   &I0 @WIRE {#M1N:2 (19, 0) (19, 10) #M1P:2};
//   &HI @WIRE {#M2N:1 #M2P:1};
//   &I1 @WIRE {#M2N:2 (43, 0) (43, 10) #M2P:2};
//   %p_in = $IO_PORT @ATTACH &IN => @PLACE(-7, 0) => @ORIENT("R0");
//   &IN @WIRE {%p_in:p #M0N:2};
//   %p_hi = $IO_PORT @ATTACH &HI => @PLACE(48, 6) => @ORIENT("R270");
//   &HI @WIRE {%p_hi:p #M2N:1};
//   (-10, 32) @TEXT("Reference-domain command buffer H") => @SET-STYLE $title_style
// }
ends mq_cdac_ctl_h

// Conversion-enable buffer
subckt mq_cdac_enable (IN EN ENB VREFP VREFN VSS)
M0N (ENB IN VREFN VSS) nch_ulvt_mac w=4e-06 l=3e-08 nf=2
M0P (ENB IN VREFP VREFP) pch_mac w=8e-06 l=3e-08 nf=4
M1N (EN ENB VREFN VSS) nch_ulvt_mac w=2.4e-05 l=3e-08 nf=12
M1P (EN ENB VREFP VREFP) pch_ulvt_mac w=4.8e-05 l=3e-08 nf=24
// @RNL {
//   /* pins connected by net name: the net-name label of rnl-std-fill on every unwired pin, placed below by its key netname */
//   $LABEL_TERMINAL_SET @TEXT("${net}", key="netname", size=0.6);
//   &VSS @ADD-TO $GROUND_NET_SET; &VREFN @ADD-TO $GROUND_NET_SET; &VREFP @ADD-TO $SUPPLY_NET_SET;
//   {#M0N #M0P} @GROUP;
//   {#M1N #M1P} @GROUP;
//   #M0N @PLACE(0, 0);
//   #M0N @ORIENT("R0");
//   #M0N:1 @TEXT("${net}", key="netname", size=0.6, halign="start", valign="middle", rotate=90, dx=0, dy=0.4);
//   #M0N:2 @TEXT("${net}", key="netname", size=0.6, halign="end", valign="middle", dx=-0.4, dy=0);
//   %g1 = $GROUND @ATTACH &VREFN => @PLACE(0, -5.2);
//   &VREFN @WIRE {#M0N:3 (0, -2) %g1:p};
//   %g2 = $GROUND @ATTACH &VSS => @PLACE(3, -3.2);
//   &VSS @WIRE {#M0N:4 (3, 0) %g2:p};
//   #M0P @PLACE(0, 10);
//   #M0P @ORIENT("R0");
//   #M0P:1 @TEXT("${net}", key="netname", size=0.6, halign="end", valign="middle", rotate=90, dx=0, dy=-0.4);
//   #M0P:2 @TEXT("${net}", key="netname", size=0.6, halign="end", valign="middle", dx=-0.4, dy=0);
//   %v3 = $SUPPLY @ATTACH &VREFP => @PLACE(0, 15.2);
//   &VREFP @WIRE {#M0P:3 (0, 12) %v3:p};
//   %v4 = $SUPPLY @ATTACH &VREFP => @PLACE(3, 13.2);
//   &VREFP @WIRE {#M0P:4 (3, 10) %v4:p};
//   #M1N @PLACE(26, 0);
//   #M1N @ORIENT("R0");
//   #M1N:1 @TEXT("${net}", key="netname", size=0.6, halign="start", valign="middle", rotate=90, dx=0, dy=0.4);
//   #M1N:2 @TEXT("${net}", key="netname", size=0.6, halign="end", valign="middle", dx=-0.4, dy=0);
//   %g5 = $GROUND @ATTACH &VREFN => @PLACE(26, -5.2);
//   &VREFN @WIRE {#M1N:3 (26, -2) %g5:p};
//   %g6 = $GROUND @ATTACH &VSS => @PLACE(29, -3.2);
//   &VSS @WIRE {#M1N:4 (29, 0) %g6:p};
//   #M1P @PLACE(26, 10);
//   #M1P @ORIENT("R0");
//   #M1P:1 @TEXT("${net}", key="netname", size=0.6, halign="end", valign="middle", rotate=90, dx=0, dy=-0.4);
//   #M1P:2 @TEXT("${net}", key="netname", size=0.6, halign="end", valign="middle", dx=-0.4, dy=0);
//   %v7 = $SUPPLY @ATTACH &VREFP => @PLACE(26, 15.2);
//   &VREFP @WIRE {#M1P:3 (26, 12) %v7:p};
//   %v8 = $SUPPLY @ATTACH &VREFP => @PLACE(29, 13.2);
//   &VREFP @WIRE {#M1P:4 (29, 10) %v8:p};
//   &ENB @WIRE {#M0N:1 #M0P:1};
//   &IN @WIRE {#M0N:2 (-5, 0) (-5, 10) #M0P:2};
//   &EN @WIRE {#M1N:1 #M1P:1};
//   &ENB @WIRE {#M1N:2 (21, 0) (21, 10) #M1P:2};
//   %p_in = $IO_PORT @ATTACH &IN => @PLACE(-7, 0) => @ORIENT("R0");
//   &IN @WIRE {%p_in:p #M0N:2};
//   %p_en = $IO_PORT @ATTACH &EN => @PLACE(26, 6) => @ORIENT("R270");
//   &EN @WIRE {%p_en:p #M1N:1};
//   %p_enb = $IO_PORT @ATTACH &ENB => @PLACE(0, 6) => @ORIENT("R270");
//   &ENB @WIRE {%p_enb:p #M0N:1};
//   (-10, 32) @TEXT("Conversion-enable buffer") => @SET-STYLE $title_style
// }
ends mq_cdac_enable

// Tristate nonoverlap driver j=12
subckt mq_cdac_drv12 (HI EN ENB BP VREFP VREFN VSS)
// GP = NAND(EN, HI, NOT(GN)); GN = NOR(ENB, HI, NOT(GP)).
// Feedback senses the opposite output-device gate; each turn-on waits for the opposite turn-off.
MPA0 (GP EN VREFP VREFP) pch_ulvt_mac w=4e-06 l=3e-08 nf=2
MNA0 (GP EN AN1 VSS) nch_ulvt_mac w=8e-06 l=3e-08 nf=4
MPA1 (GP HI VREFP VREFP) pch_ulvt_mac w=4e-06 l=3e-08 nf=2
MNA1 (AN1 HI AN2 VSS) nch_ulvt_mac w=8e-06 l=3e-08 nf=4
MPA2 (GP NOFF VREFP VREFP) pch_ulvt_mac w=4e-06 l=3e-08 nf=2
MNA2 (AN2 NOFF VREFN VSS) nch_ulvt_mac w=8e-06 l=3e-08 nf=4
MPB0 (BP1 ENB VREFP VREFP) pch_ulvt_mac w=1.2e-05 l=3e-08 nf=6
MNB0 (GN ENB VREFN VSS) nch_ulvt_mac w=4e-06 l=3e-08 nf=2
MPB1 (BP2 HI BP1 VREFP) pch_ulvt_mac w=1.2e-05 l=3e-08 nf=6
MNB1 (GN HI VREFN VSS) nch_ulvt_mac w=4e-06 l=3e-08 nf=2
MPB2 (GN PON BP2 VREFP) pch_ulvt_mac w=1.2e-05 l=3e-08 nf=6
MNB2 (GN PON VREFN VSS) nch_ulvt_mac w=4e-06 l=3e-08 nf=2
MFNN (NOFF GN VREFN VSS) nch_ulvt_mac w=4e-06 l=3e-08 nf=2
MFNP (NOFF GN VREFP VREFP) pch_ulvt_mac w=8e-06 l=3e-08 nf=4
MFPN (PON GP VREFN VSS) nch_ulvt_mac w=4e-06 l=3e-08 nf=2
MFPP (PON GP VREFP VREFP) pch_ulvt_mac w=8e-06 l=3e-08 nf=4
MNOUT (BP GN VREFN VSS) nch_ulvt_mac w=2e-05 l=3e-08 nf=10
MPOUT (BP GP VREFP VREFP) pch_ulvt_mac w=4e-05 l=3e-08 nf=20
// @RNL {
//   /* pins connected by net name: the net-name label of rnl-std-fill on every unwired pin, placed below by its key netname */
//   $LABEL_TERMINAL_SET @TEXT("${net}", key="netname", size=0.6);
//   &VSS @ADD-TO $GROUND_NET_SET; &VREFN @ADD-TO $GROUND_NET_SET; &VREFP @ADD-TO $SUPPLY_NET_SET;
//   {#MFNN #MFNP} @GROUP;
//   {#MFPN #MFPP} @GROUP;
//   {#MPA0 #MPA1 #MPA2 #MNA0 #MNA1 #MNA2} @GROUP;
//   {#MPB0 #MPB1 #MPB2 #MNB0 #MNB1 #MNB2} @GROUP;
//   {#MNOUT #MPOUT} @GROUP;
//   #MPA0 @PLACE(0, 26);
//   #MPA0 @ORIENT("R0");
//   #MPA0:1 @TEXT("${net}", key="netname", size=0.6, halign="end", valign="middle", rotate=90, dx=0, dy=-0.4);
//   #MPA0:2 @TEXT("${net}", key="netname", size=0.6, halign="end", valign="middle", dx=-0.4, dy=0);
//   %v1 = $SUPPLY @ATTACH &VREFP => @PLACE(0, 31.2);
//   &VREFP @WIRE {#MPA0:3 (0, 28) %v1:p};
//   %v2 = $SUPPLY @ATTACH &VREFP => @PLACE(3, 29.2);
//   &VREFP @WIRE {#MPA0:4 (3, 26) %v2:p};
//   #MNA0 @PLACE(16, 12);
//   #MNA0 @ORIENT("R0");
//   #MNA0:1 @TEXT("${net}", key="netname", size=0.6, halign="start", valign="middle", rotate=90, dx=0, dy=0.4);
//   #MNA0:2 @TEXT("${net}", key="netname", size=0.6, halign="end", valign="middle", dx=-0.4, dy=0);
//   #MNA0:3 @TEXT("${net}", key="netname", size=0.6, halign="end", valign="middle", rotate=90, dx=0, dy=-0.4);
//   %g3 = $GROUND @ATTACH &VSS => @PLACE(19, 8.8);
//   &VSS @WIRE {#MNA0:4 (19, 12) %g3:p};
//   #MPA1 @PLACE(16, 26);
//   #MPA1 @ORIENT("R0");
//   #MPA1:1 @TEXT("${net}", key="netname", size=0.6, halign="end", valign="middle", rotate=90, dx=0, dy=-0.4);
//   #MPA1:2 @TEXT("${net}", key="netname", size=0.6, halign="end", valign="middle", dx=-0.4, dy=0);
//   %v4 = $SUPPLY @ATTACH &VREFP => @PLACE(16, 31.2);
//   &VREFP @WIRE {#MPA1:3 (16, 28) %v4:p};
//   %v5 = $SUPPLY @ATTACH &VREFP => @PLACE(19, 29.2);
//   &VREFP @WIRE {#MPA1:4 (19, 26) %v5:p};
//   #MNA1 @PLACE(16, 2);
//   #MNA1 @ORIENT("R0");
//   #MNA1:1 @TEXT("${net}", key="netname", size=0.6, halign="start", valign="middle", rotate=90, dx=0, dy=0.4);
//   #MNA1:2 @TEXT("${net}", key="netname", size=0.6, halign="end", valign="middle", dx=-0.4, dy=0);
//   #MNA1:3 @TEXT("${net}", key="netname", size=0.6, halign="end", valign="middle", rotate=90, dx=0, dy=-0.4);
//   %g6 = $GROUND @ATTACH &VSS => @PLACE(19, -1.2);
//   &VSS @WIRE {#MNA1:4 (19, 2) %g6:p};
//   #MPA2 @PLACE(32, 26);
//   #MPA2 @ORIENT("R0");
//   #MPA2:1 @TEXT("${net}", key="netname", size=0.6, halign="end", valign="middle", rotate=90, dx=0, dy=-0.4);
//   #MPA2:2 @TEXT("${net}", key="netname", size=0.6, halign="end", valign="middle", dx=-0.4, dy=0);
//   %v7 = $SUPPLY @ATTACH &VREFP => @PLACE(32, 31.2);
//   &VREFP @WIRE {#MPA2:3 (32, 28) %v7:p};
//   %v8 = $SUPPLY @ATTACH &VREFP => @PLACE(35, 29.2);
//   &VREFP @WIRE {#MPA2:4 (35, 26) %v8:p};
//   #MNA2 @PLACE(16, -8);
//   #MNA2 @ORIENT("R0");
//   #MNA2:1 @TEXT("${net}", key="netname", size=0.6, halign="start", valign="middle", rotate=90, dx=0, dy=0.4);
//   #MNA2:2 @TEXT("${net}", key="netname", size=0.6, halign="end", valign="middle", dx=-0.4, dy=0);
//   %g9 = $GROUND @ATTACH &VREFN => @PLACE(16, -13.2);
//   &VREFN @WIRE {#MNA2:3 (16, -10) %g9:p};
//   %g10 = $GROUND @ATTACH &VSS => @PLACE(19, -11.2);
//   &VSS @WIRE {#MNA2:4 (19, -8) %g10:p};
//   #MPB0 @PLACE(64, 26);
//   #MPB0 @ORIENT("R0");
//   #MPB0:1 @TEXT("${net}", key="netname", size=0.6, halign="end", valign="middle", rotate=90, dx=0, dy=-0.4);
//   #MPB0:2 @TEXT("${net}", key="netname", size=0.6, halign="end", valign="middle", dx=-0.4, dy=0);
//   %v11 = $SUPPLY @ATTACH &VREFP => @PLACE(64, 31.2);
//   &VREFP @WIRE {#MPB0:3 (64, 28) %v11:p};
//   %v12 = $SUPPLY @ATTACH &VREFP => @PLACE(67, 29.2);
//   &VREFP @WIRE {#MPB0:4 (67, 26) %v12:p};
//   #MNB0 @PLACE(48, -10);
//   #MNB0 @ORIENT("R0");
//   #MNB0:1 @TEXT("${net}", key="netname", size=0.6, halign="start", valign="middle", rotate=90, dx=0, dy=0.4);
//   #MNB0:2 @TEXT("${net}", key="netname", size=0.6, halign="end", valign="middle", dx=-0.4, dy=0);
//   %g13 = $GROUND @ATTACH &VREFN => @PLACE(48, -15.2);
//   &VREFN @WIRE {#MNB0:3 (48, -12) %g13:p};
//   %g14 = $GROUND @ATTACH &VSS => @PLACE(51, -13.2);
//   &VSS @WIRE {#MNB0:4 (51, -10) %g14:p};
//   #MPB1 @PLACE(64, 16);
//   #MPB1 @ORIENT("R0");
//   #MPB1:1 @TEXT("${net}", key="netname", size=0.6, halign="end", valign="middle", rotate=90, dx=0, dy=-0.4);
//   #MPB1:2 @TEXT("${net}", key="netname", size=0.6, halign="end", valign="middle", dx=-0.4, dy=0);
//   #MPB1:3 @TEXT("${net}", key="netname", size=0.6, halign="start", valign="middle", rotate=90, dx=0, dy=0.4);
//   %v15 = $SUPPLY @ATTACH &VREFP => @PLACE(67, 19.2);
//   &VREFP @WIRE {#MPB1:4 (67, 16) %v15:p};
//   #MNB1 @PLACE(64, -10);
//   #MNB1 @ORIENT("R0");
//   #MNB1:1 @TEXT("${net}", key="netname", size=0.6, halign="start", valign="middle", rotate=90, dx=0, dy=0.4);
//   #MNB1:2 @TEXT("${net}", key="netname", size=0.6, halign="end", valign="middle", dx=-0.4, dy=0);
//   %g16 = $GROUND @ATTACH &VREFN => @PLACE(64, -15.2);
//   &VREFN @WIRE {#MNB1:3 (64, -12) %g16:p};
//   %g17 = $GROUND @ATTACH &VSS => @PLACE(67, -13.2);
//   &VSS @WIRE {#MNB1:4 (67, -10) %g17:p};
//   #MPB2 @PLACE(64, 6);
//   #MPB2 @ORIENT("R0");
//   #MPB2:1 @TEXT("${net}", key="netname", size=0.6, halign="end", valign="middle", rotate=90, dx=0, dy=-0.4);
//   #MPB2:2 @TEXT("${net}", key="netname", size=0.6, halign="end", valign="middle", dx=-0.4, dy=0);
//   #MPB2:3 @TEXT("${net}", key="netname", size=0.6, halign="start", valign="middle", rotate=90, dx=0, dy=0.4);
//   %v18 = $SUPPLY @ATTACH &VREFP => @PLACE(67, 9.2);
//   &VREFP @WIRE {#MPB2:4 (67, 6) %v18:p};
//   #MNB2 @PLACE(80, -10);
//   #MNB2 @ORIENT("R0");
//   #MNB2:1 @TEXT("${net}", key="netname", size=0.6, halign="start", valign="middle", rotate=90, dx=0, dy=0.4);
//   #MNB2:2 @TEXT("${net}", key="netname", size=0.6, halign="end", valign="middle", dx=-0.4, dy=0);
//   %g19 = $GROUND @ATTACH &VREFN => @PLACE(80, -15.2);
//   &VREFN @WIRE {#MNB2:3 (80, -12) %g19:p};
//   %g20 = $GROUND @ATTACH &VSS => @PLACE(83, -13.2);
//   &VSS @WIRE {#MNB2:4 (83, -10) %g20:p};
//   #MFNN @PLACE(108, 12);
//   #MFNN @ORIENT("R0");
//   #MFNN:1 @TEXT("${net}", key="netname", size=0.6, halign="start", valign="middle", rotate=90, dx=0, dy=0.4);
//   #MFNN:2 @TEXT("${net}", key="netname", size=0.6, halign="end", valign="middle", dx=-0.4, dy=0);
//   %g21 = $GROUND @ATTACH &VREFN => @PLACE(108, 6.8);
//   &VREFN @WIRE {#MFNN:3 (108, 10) %g21:p};
//   %g22 = $GROUND @ATTACH &VSS => @PLACE(111, 8.8);
//   &VSS @WIRE {#MFNN:4 (111, 12) %g22:p};
//   #MFNP @PLACE(108, 22);
//   #MFNP @ORIENT("R0");
//   #MFNP:1 @TEXT("${net}", key="netname", size=0.6, halign="end", valign="middle", rotate=90, dx=0, dy=-0.4);
//   #MFNP:2 @TEXT("${net}", key="netname", size=0.6, halign="end", valign="middle", dx=-0.4, dy=0);
//   %v23 = $SUPPLY @ATTACH &VREFP => @PLACE(108, 27.2);
//   &VREFP @WIRE {#MFNP:3 (108, 24) %v23:p};
//   %v24 = $SUPPLY @ATTACH &VREFP => @PLACE(111, 25.2);
//   &VREFP @WIRE {#MFNP:4 (111, 22) %v24:p};
//   #MFPN @PLACE(136, 12);
//   #MFPN @ORIENT("R0");
//   #MFPN:1 @TEXT("${net}", key="netname", size=0.6, halign="start", valign="middle", rotate=90, dx=0, dy=0.4);
//   #MFPN:2 @TEXT("${net}", key="netname", size=0.6, halign="end", valign="middle", dx=-0.4, dy=0);
//   %g25 = $GROUND @ATTACH &VREFN => @PLACE(136, 6.8);
//   &VREFN @WIRE {#MFPN:3 (136, 10) %g25:p};
//   %g26 = $GROUND @ATTACH &VSS => @PLACE(139, 8.8);
//   &VSS @WIRE {#MFPN:4 (139, 12) %g26:p};
//   #MFPP @PLACE(136, 22);
//   #MFPP @ORIENT("R0");
//   #MFPP:1 @TEXT("${net}", key="netname", size=0.6, halign="end", valign="middle", rotate=90, dx=0, dy=-0.4);
//   #MFPP:2 @TEXT("${net}", key="netname", size=0.6, halign="end", valign="middle", dx=-0.4, dy=0);
//   %v27 = $SUPPLY @ATTACH &VREFP => @PLACE(136, 27.2);
//   &VREFP @WIRE {#MFPP:3 (136, 24) %v27:p};
//   %v28 = $SUPPLY @ATTACH &VREFP => @PLACE(139, 25.2);
//   &VREFP @WIRE {#MFPP:4 (139, 22) %v28:p};
//   #MNOUT @PLACE(168, 0);
//   #MNOUT @ORIENT("R0");
//   #MNOUT:1 @TEXT("${net}", key="netname", size=0.6, halign="start", valign="middle", rotate=90, dx=0, dy=0.4);
//   #MNOUT:2 @TEXT("${net}", key="netname", size=0.6, halign="end", valign="middle", dx=-0.4, dy=0);
//   %g29 = $GROUND @ATTACH &VREFN => @PLACE(168, -5.2);
//   &VREFN @WIRE {#MNOUT:3 (168, -2) %g29:p};
//   %g30 = $GROUND @ATTACH &VSS => @PLACE(171, -3.2);
//   &VSS @WIRE {#MNOUT:4 (171, 0) %g30:p};
//   #MPOUT @PLACE(168, 22);
//   #MPOUT @ORIENT("R0");
//   #MPOUT:1 @TEXT("${net}", key="netname", size=0.6, halign="end", valign="middle", rotate=90, dx=0, dy=-0.4);
//   #MPOUT:2 @TEXT("${net}", key="netname", size=0.6, halign="end", valign="middle", dx=-0.4, dy=0);
//   %v31 = $SUPPLY @ATTACH &VREFP => @PLACE(168, 27.2);
//   &VREFP @WIRE {#MPOUT:3 (168, 24) %v31:p};
//   %v32 = $SUPPLY @ATTACH &VREFP => @PLACE(171, 25.2);
//   &VREFP @WIRE {#MPOUT:4 (171, 22) %v32:p};
//   &NOFF @WIRE {#MFNN:1 #MFNP:1};
//   &GN @WIRE {#MFNN:2 (103, 12) (103, 22) #MFNP:2};
//   &PON @WIRE {#MFPN:1 #MFPP:1};
//   &GP @WIRE {#MFPN:2 (131, 12) (131, 22) #MFPP:2};
//   %gp_bus = (16, 22);
//   $JUNCTION @ATTACH %gp_bus;
//   &GP @WIRE {#MPA0:1 (0, 22) %gp_bus (32, 22) #MPA2:1};
//   &GP @WIRE {#MPA1:1 %gp_bus #MNA0:1};
//   &AN1 @WIRE {#MNA0:3 #MNA1:1};
//   &AN2 @WIRE {#MNA1:3 #MNA2:1};
//   &BP1 @WIRE {#MPB0:1 #MPB1:3};
//   &BP2 @WIRE {#MPB1:1 #MPB2:3};
//   %gn_bus = (64, -6);
//   $JUNCTION @ATTACH %gn_bus;
//   &GN @WIRE {#MNB0:1 (48, -6) %gn_bus (80, -6) #MNB2:1};
//   &GN @WIRE {#MNB1:1 %gn_bus #MPB2:1};
//   &BP @WIRE {#MNOUT:1 #MPOUT:1};
//   %p_hi = $IO_PORT @ATTACH &HI => @PLACE(9, 26) => @ORIENT("R0");
//   &HI @WIRE {%p_hi:p #MPA1:2};
//   %p_en = $IO_PORT @ATTACH &EN => @PLACE(-7, 26) => @ORIENT("R0");
//   &EN @WIRE {%p_en:p #MPA0:2};
//   %p_enb = $IO_PORT @ATTACH &ENB => @PLACE(57, 26) => @ORIENT("R0");
//   &ENB @WIRE {%p_enb:p #MPB0:2};
//   %p_bp = $IO_PORT @ATTACH &BP => @PLACE(168, 6) => @ORIENT("R270");
//   &BP @WIRE {%p_bp:p #MNOUT:1};
//   (-10, 48) @TEXT("Tristate nonoverlap driver j=12") => @SET-STYLE $title_style
// }
ends mq_cdac_drv12

// Matched half-capacitor pair j=12, weight 980
subckt mq_cdac_bit12 (VIN VG DH RL EN ENB TOP VREFP VREFN VSS)
// CP*: user-specified pre-layout estimate, 5% of each physical MOM unit to VSS.
// The second MOM terminal is its bottom plate; parallel multipliers are aggregated.
// Series tails add one unit parasitic at MID and one at B, not 5% of the equivalent half unit.
XHCTL (DH HHI VREFP VREFN VSS) mq_cdac_ctl_h
XLCTL (RL LHI VREFP VREFN VSS) mq_cdac_ctl_l
XDH (HHI EN ENB BH VREFP VREFN VSS) mq_cdac_drv12
CH (TOP BH) cfmom_2t w=5e-08 s=2.4e-07 nr=6 lr=1.69e-06 stm=2 spm=4 multi=490
CPH (BH VSS) capacitor c=2.45561050e-14
MSH (BH VG VIN VSS) nch_ulvt_mac w=1.143e-05 l=3e-08 nf=6
XDL (LHI EN ENB BL VREFP VREFN VSS) mq_cdac_drv12
CL (TOP BL) cfmom_2t w=5e-08 s=2.4e-07 nr=6 lr=1.69e-06 stm=2 spm=4 multi=490
CPL (BL VSS) capacitor c=2.45561050e-14
MSL (BL VG VIN VSS) nch_ulvt_mac w=1.143e-05 l=3e-08 nf=6
// @RNL {
//   /* pins connected by net name: the net-name label of rnl-std-fill on every unwired pin, placed below by its key netname */
//   $LABEL_TERMINAL_SET @TEXT("${net}", key="netname", size=0.6);
//   &VSS @ADD-TO $GROUND_NET_SET; &VREFN @ADD-TO $GROUND_NET_SET; &VREFP @ADD-TO $SUPPLY_NET_SET;
//   {#CH #CL} @AS $MATCHED;
//   {#MSH #MSL} @AS $MATCHED;
//   {#XDH #XDL} @AS $MATCHED;
//   #XHCTL @PLACE(-70, 24);
//   #XHCTL @ORIENT("R0");
//   #XHCTL:IN @TEXT("${net}", key="netname", size=0.6, halign="end", valign="middle", dx=-0.4, dy=0);
//   #XHCTL:HI @TEXT("${net}", key="netname", size=0.6, halign="start", valign="middle", dx=0.4, dy=0);
//   %v1 = $SUPPLY @ATTACH &VREFP => @PLACE(-70, 31.2);
//   &VREFP @WIRE {#XHCTL:VREFP (-70, 28) %v1:p};
//   %g2 = $GROUND @ATTACH &VREFN => @PLACE(-72, 16.8);
//   &VREFN @WIRE {#XHCTL:VREFN (-72, 20) %g2:p};
//   %g3 = $GROUND @ATTACH &VSS => @PLACE(-68, 16.8);
//   &VSS @WIRE {#XHCTL:VSS (-68, 20) %g3:p};
//   #XLCTL @PLACE(-70, -26);
//   #XLCTL @ORIENT("R0");
//   #XLCTL:IN @TEXT("${net}", key="netname", size=0.6, halign="end", valign="middle", dx=-0.4, dy=0);
//   #XLCTL:HI @TEXT("${net}", key="netname", size=0.6, halign="start", valign="middle", dx=0.4, dy=0);
//   %v4 = $SUPPLY @ATTACH &VREFP => @PLACE(-70, -18.8);
//   &VREFP @WIRE {#XLCTL:VREFP (-70, -22) %v4:p};
//   %g5 = $GROUND @ATTACH &VREFN => @PLACE(-72, -33.2);
//   &VREFN @WIRE {#XLCTL:VREFN (-72, -30) %g5:p};
//   %g6 = $GROUND @ATTACH &VSS => @PLACE(-68, -33.2);
//   &VSS @WIRE {#XLCTL:VSS (-68, -30) %g6:p};
//   #XDH @PLACE(-34, 24);
//   #XDH @ORIENT("R0");
//   #XDH:HI @TEXT("${net}", key="netname", size=0.6, halign="end", valign="middle", dx=-0.4, dy=0);
//   #XDH:EN @TEXT("${net}", key="netname", size=0.6, halign="end", valign="middle", dx=-0.4, dy=0);
//   #XDH:ENB @TEXT("${net}", key="netname", size=0.6, halign="end", valign="middle", dx=-0.4, dy=0);
//   #XDH:BP @TEXT("${net}", key="netname", size=0.6, halign="start", valign="middle", dx=0.4, dy=0);
//   %v7 = $SUPPLY @ATTACH &VREFP => @PLACE(-34, 32.2);
//   &VREFP @WIRE {#XDH:VREFP (-34, 29) %v7:p};
//   %g8 = $GROUND @ATTACH &VREFN => @PLACE(-36, 15.8);
//   &VREFN @WIRE {#XDH:VREFN (-36, 19) %g8:p};
//   %g9 = $GROUND @ATTACH &VSS => @PLACE(-32, 15.8);
//   &VSS @WIRE {#XDH:VSS (-32, 19) %g9:p};
//   #CH @PLACE(14, 24) => @ORIENT("R270");
//   #CH:1 @TEXT("${net}", key="netname", size=0.6, halign="start", valign="middle", dx=0.4, dy=0);
//   #CH:2 @TEXT("${net}", key="netname", size=0.6, halign="end", valign="middle", dx=-0.4, dy=0);
//   #CPH @PLACE(60, 20);
//   #CPH @ORIENT("R0");
//   #CPH:1 @TEXT("${net}", key="netname", size=0.6, halign="start", valign="middle", rotate=90, dx=0, dy=0.4);
//   %g10 = $GROUND @ATTACH &VSS => @PLACE(60, 14.8);
//   &VSS @WIRE {#CPH:2 (60, 18) %g10:p};
//   #MSH @PLACE(2, 8);
//   #MSH @ORIENT("R0");
//   #MSH:1 @TEXT("${net}", key="netname", size=0.6, halign="start", valign="middle", rotate=90, dx=0, dy=0.4);
//   #MSH:2 @TEXT("${net}", key="netname", size=0.6, halign="end", valign="middle", dx=-0.4, dy=0);
//   #MSH:3 @TEXT("${net}", key="netname", size=0.6, halign="end", valign="middle", rotate=90, dx=0, dy=-0.4);
//   %g11 = $GROUND @ATTACH &VSS => @PLACE(5, 4.8);
//   &VSS @WIRE {#MSH:4 (5, 8) %g11:p};
//   #XDL @PLACE(-34, -26);
//   #XDL @ORIENT("R0");
//   #XDL:HI @TEXT("${net}", key="netname", size=0.6, halign="end", valign="middle", dx=-0.4, dy=0);
//   #XDL:EN @TEXT("${net}", key="netname", size=0.6, halign="end", valign="middle", dx=-0.4, dy=0);
//   #XDL:ENB @TEXT("${net}", key="netname", size=0.6, halign="end", valign="middle", dx=-0.4, dy=0);
//   #XDL:BP @TEXT("${net}", key="netname", size=0.6, halign="start", valign="middle", dx=0.4, dy=0);
//   %v12 = $SUPPLY @ATTACH &VREFP => @PLACE(-34, -17.8);
//   &VREFP @WIRE {#XDL:VREFP (-34, -21) %v12:p};
//   %g13 = $GROUND @ATTACH &VREFN => @PLACE(-36, -34.2);
//   &VREFN @WIRE {#XDL:VREFN (-36, -31) %g13:p};
//   %g14 = $GROUND @ATTACH &VSS => @PLACE(-32, -34.2);
//   &VSS @WIRE {#XDL:VSS (-32, -31) %g14:p};
//   #CL @PLACE(14, -26) => @ORIENT("R270");
//   #CL:1 @TEXT("${net}", key="netname", size=0.6, halign="start", valign="middle", dx=0.4, dy=0);
//   #CL:2 @TEXT("${net}", key="netname", size=0.6, halign="end", valign="middle", dx=-0.4, dy=0);
//   #CPL @PLACE(60, -30);
//   #CPL @ORIENT("R0");
//   #CPL:1 @TEXT("${net}", key="netname", size=0.6, halign="start", valign="middle", rotate=90, dx=0, dy=0.4);
//   %g15 = $GROUND @ATTACH &VSS => @PLACE(60, -35.2);
//   &VSS @WIRE {#CPL:2 (60, -32) %g15:p};
//   #MSL @PLACE(2, -42);
//   #MSL @ORIENT("R0");
//   #MSL:1 @TEXT("${net}", key="netname", size=0.6, halign="start", valign="middle", rotate=90, dx=0, dy=0.4);
//   #MSL:2 @TEXT("${net}", key="netname", size=0.6, halign="end", valign="middle", dx=-0.4, dy=0);
//   #MSL:3 @TEXT("${net}", key="netname", size=0.6, halign="end", valign="middle", rotate=90, dx=0, dy=-0.4);
//   %g16 = $GROUND @ATTACH &VSS => @PLACE(5, -45.2);
//   &VSS @WIRE {#MSL:4 (5, -42) %g16:p};
//   &HHI @WIRE {#XHCTL:HI (-52, 24) (-52, 26) #XDH:HI};
//   %b_H = (-12, 24);
//   $JUNCTION @ATTACH %b_H;
//   &BH @WIRE {#XDH:BP %b_H};
//   &BH @WIRE {%b_H #CH:2};
//   &BH @WIRE {%b_H (-12, 10) #MSH:1};
//   &LHI @WIRE {#XLCTL:HI (-52, -26) (-52, -24) #XDL:HI};
//   %b_L = (-12, -26);
//   $JUNCTION @ATTACH %b_L;
//   &BL @WIRE {#XDL:BP %b_L};
//   &BL @WIRE {%b_L #CL:2};
//   &BL @WIRE {%b_L (-12, -40) #MSL:1};
//   &VIN @WIRE {#MSH:3 (6, 6) (6, -44) #MSL:3};
//   &VG @WIRE {#MSH:2 (-5, 8) (-5, -42) #MSL:2};
//   %top_H = (44, 24);
//   $JUNCTION @ATTACH %top_H;
//   %top_L = (44, -26);
//   $JUNCTION @ATTACH %top_L;
//   &TOP @WIRE {#CH:1 %top_H};
//   &TOP @WIRE {#CL:1 %top_L};
//   &TOP @WIRE {%top_H %top_L};
//   %p_vin = $IO_PORT @ATTACH &VIN => @PLACE(2, 2) => @ORIENT("R90");
//   &VIN @WIRE {%p_vin:p #MSH:3};
//   %p_vg = $IO_PORT @ATTACH &VG => @PLACE(-5, 8) => @ORIENT("R0");
//   &VG @WIRE {%p_vg:p #MSH:2};
//   %p_dh = $IO_PORT @ATTACH &DH => @PLACE(-81, 24) => @ORIENT("R0");
//   &DH @WIRE {%p_dh:p #XHCTL:IN};
//   %p_rl = $IO_PORT @ATTACH &RL => @PLACE(-81, -26) => @ORIENT("R0");
//   &RL @WIRE {%p_rl:p #XLCTL:IN};
//   %p_en = $IO_PORT @ATTACH &EN => @PLACE(-45, 24) => @ORIENT("R0");
//   &EN @WIRE {%p_en:p #XDH:EN};
//   %p_enb = $IO_PORT @ATTACH &ENB => @PLACE(-45, 22) => @ORIENT("R0");
//   &ENB @WIRE {%p_enb:p #XDH:ENB};
//   %p_top = $IO_PORT @ATTACH &TOP => @PLACE(20, 24) => @ORIENT("MY");
//   &TOP @WIRE {%p_top:p #CH:1};
//   (-10, 46) @TEXT("Matched half-capacitor pair j=12, weight 980") => @SET-STYLE $title_style
// }
ends mq_cdac_bit12

// Tristate nonoverlap driver j=11
subckt mq_cdac_drv11 (HI EN ENB BP VREFP VREFN VSS)
// GP = NAND(EN, HI, NOT(GN)); GN = NOR(ENB, HI, NOT(GP)).
// Feedback senses the opposite output-device gate; each turn-on waits for the opposite turn-off.
MPA0 (GP EN VREFP VREFP) pch_ulvt_mac w=2.29e-06 l=3e-08 nf=2
MNA0 (GP EN AN1 VSS) nch_ulvt_mac w=4.575e-06 l=3e-08 nf=3
MPA1 (GP HI VREFP VREFP) pch_ulvt_mac w=2.29e-06 l=3e-08 nf=2
MNA1 (AN1 HI AN2 VSS) nch_ulvt_mac w=4.575e-06 l=3e-08 nf=3
MPA2 (GP NOFF VREFP VREFP) pch_ulvt_mac w=2.29e-06 l=3e-08 nf=2
MNA2 (AN2 NOFF VREFN VSS) nch_ulvt_mac w=4.575e-06 l=3e-08 nf=3
MPB0 (BP1 ENB VREFP VREFP) pch_ulvt_mac w=6.86e-06 l=3e-08 nf=4
MNB0 (GN ENB VREFN VSS) nch_ulvt_mac w=2.29e-06 l=3e-08 nf=2
MPB1 (BP2 HI BP1 VREFP) pch_ulvt_mac w=6.86e-06 l=3e-08 nf=4
MNB1 (GN HI VREFN VSS) nch_ulvt_mac w=2.29e-06 l=3e-08 nf=2
MPB2 (GN PON BP2 VREFP) pch_ulvt_mac w=6.86e-06 l=3e-08 nf=4
MNB2 (GN PON VREFN VSS) nch_ulvt_mac w=2.29e-06 l=3e-08 nf=2
MFNN (NOFF GN VREFN VSS) nch_ulvt_mac w=2.29e-06 l=3e-08 nf=2
MFNP (NOFF GN VREFP VREFP) pch_ulvt_mac w=4.575e-06 l=3e-08 nf=3
MFPN (PON GP VREFN VSS) nch_ulvt_mac w=2.29e-06 l=3e-08 nf=2
MFPP (PON GP VREFP VREFP) pch_ulvt_mac w=4.575e-06 l=3e-08 nf=3
MNOUT (BP GN VREFN VSS) nch_ulvt_mac w=1.143e-05 l=3e-08 nf=6
MPOUT (BP GP VREFP VREFP) pch_ulvt_mac w=2.286e-05 l=3e-08 nf=12
// @RNL {
//   /* pins connected by net name: the net-name label of rnl-std-fill on every unwired pin, placed below by its key netname */
//   $LABEL_TERMINAL_SET @TEXT("${net}", key="netname", size=0.6);
//   &VSS @ADD-TO $GROUND_NET_SET; &VREFN @ADD-TO $GROUND_NET_SET; &VREFP @ADD-TO $SUPPLY_NET_SET;
//   {#MFNN #MFNP} @GROUP;
//   {#MFPN #MFPP} @GROUP;
//   {#MPA0 #MPA1 #MPA2 #MNA0 #MNA1 #MNA2} @GROUP;
//   {#MPB0 #MPB1 #MPB2 #MNB0 #MNB1 #MNB2} @GROUP;
//   {#MNOUT #MPOUT} @GROUP;
//   #MPA0 @PLACE(0, 26);
//   #MPA0 @ORIENT("R0");
//   #MPA0:1 @TEXT("${net}", key="netname", size=0.6, halign="end", valign="middle", rotate=90, dx=0, dy=-0.4);
//   #MPA0:2 @TEXT("${net}", key="netname", size=0.6, halign="end", valign="middle", dx=-0.4, dy=0);
//   %v1 = $SUPPLY @ATTACH &VREFP => @PLACE(0, 31.2);
//   &VREFP @WIRE {#MPA0:3 (0, 28) %v1:p};
//   %v2 = $SUPPLY @ATTACH &VREFP => @PLACE(3, 29.2);
//   &VREFP @WIRE {#MPA0:4 (3, 26) %v2:p};
//   #MNA0 @PLACE(16, 12);
//   #MNA0 @ORIENT("R0");
//   #MNA0:1 @TEXT("${net}", key="netname", size=0.6, halign="start", valign="middle", rotate=90, dx=0, dy=0.4);
//   #MNA0:2 @TEXT("${net}", key="netname", size=0.6, halign="end", valign="middle", dx=-0.4, dy=0);
//   #MNA0:3 @TEXT("${net}", key="netname", size=0.6, halign="end", valign="middle", rotate=90, dx=0, dy=-0.4);
//   %g3 = $GROUND @ATTACH &VSS => @PLACE(19, 8.8);
//   &VSS @WIRE {#MNA0:4 (19, 12) %g3:p};
//   #MPA1 @PLACE(16, 26);
//   #MPA1 @ORIENT("R0");
//   #MPA1:1 @TEXT("${net}", key="netname", size=0.6, halign="end", valign="middle", rotate=90, dx=0, dy=-0.4);
//   #MPA1:2 @TEXT("${net}", key="netname", size=0.6, halign="end", valign="middle", dx=-0.4, dy=0);
//   %v4 = $SUPPLY @ATTACH &VREFP => @PLACE(16, 31.2);
//   &VREFP @WIRE {#MPA1:3 (16, 28) %v4:p};
//   %v5 = $SUPPLY @ATTACH &VREFP => @PLACE(19, 29.2);
//   &VREFP @WIRE {#MPA1:4 (19, 26) %v5:p};
//   #MNA1 @PLACE(16, 2);
//   #MNA1 @ORIENT("R0");
//   #MNA1:1 @TEXT("${net}", key="netname", size=0.6, halign="start", valign="middle", rotate=90, dx=0, dy=0.4);
//   #MNA1:2 @TEXT("${net}", key="netname", size=0.6, halign="end", valign="middle", dx=-0.4, dy=0);
//   #MNA1:3 @TEXT("${net}", key="netname", size=0.6, halign="end", valign="middle", rotate=90, dx=0, dy=-0.4);
//   %g6 = $GROUND @ATTACH &VSS => @PLACE(19, -1.2);
//   &VSS @WIRE {#MNA1:4 (19, 2) %g6:p};
//   #MPA2 @PLACE(32, 26);
//   #MPA2 @ORIENT("R0");
//   #MPA2:1 @TEXT("${net}", key="netname", size=0.6, halign="end", valign="middle", rotate=90, dx=0, dy=-0.4);
//   #MPA2:2 @TEXT("${net}", key="netname", size=0.6, halign="end", valign="middle", dx=-0.4, dy=0);
//   %v7 = $SUPPLY @ATTACH &VREFP => @PLACE(32, 31.2);
//   &VREFP @WIRE {#MPA2:3 (32, 28) %v7:p};
//   %v8 = $SUPPLY @ATTACH &VREFP => @PLACE(35, 29.2);
//   &VREFP @WIRE {#MPA2:4 (35, 26) %v8:p};
//   #MNA2 @PLACE(16, -8);
//   #MNA2 @ORIENT("R0");
//   #MNA2:1 @TEXT("${net}", key="netname", size=0.6, halign="start", valign="middle", rotate=90, dx=0, dy=0.4);
//   #MNA2:2 @TEXT("${net}", key="netname", size=0.6, halign="end", valign="middle", dx=-0.4, dy=0);
//   %g9 = $GROUND @ATTACH &VREFN => @PLACE(16, -13.2);
//   &VREFN @WIRE {#MNA2:3 (16, -10) %g9:p};
//   %g10 = $GROUND @ATTACH &VSS => @PLACE(19, -11.2);
//   &VSS @WIRE {#MNA2:4 (19, -8) %g10:p};
//   #MPB0 @PLACE(64, 26);
//   #MPB0 @ORIENT("R0");
//   #MPB0:1 @TEXT("${net}", key="netname", size=0.6, halign="end", valign="middle", rotate=90, dx=0, dy=-0.4);
//   #MPB0:2 @TEXT("${net}", key="netname", size=0.6, halign="end", valign="middle", dx=-0.4, dy=0);
//   %v11 = $SUPPLY @ATTACH &VREFP => @PLACE(64, 31.2);
//   &VREFP @WIRE {#MPB0:3 (64, 28) %v11:p};
//   %v12 = $SUPPLY @ATTACH &VREFP => @PLACE(67, 29.2);
//   &VREFP @WIRE {#MPB0:4 (67, 26) %v12:p};
//   #MNB0 @PLACE(48, -10);
//   #MNB0 @ORIENT("R0");
//   #MNB0:1 @TEXT("${net}", key="netname", size=0.6, halign="start", valign="middle", rotate=90, dx=0, dy=0.4);
//   #MNB0:2 @TEXT("${net}", key="netname", size=0.6, halign="end", valign="middle", dx=-0.4, dy=0);
//   %g13 = $GROUND @ATTACH &VREFN => @PLACE(48, -15.2);
//   &VREFN @WIRE {#MNB0:3 (48, -12) %g13:p};
//   %g14 = $GROUND @ATTACH &VSS => @PLACE(51, -13.2);
//   &VSS @WIRE {#MNB0:4 (51, -10) %g14:p};
//   #MPB1 @PLACE(64, 16);
//   #MPB1 @ORIENT("R0");
//   #MPB1:1 @TEXT("${net}", key="netname", size=0.6, halign="end", valign="middle", rotate=90, dx=0, dy=-0.4);
//   #MPB1:2 @TEXT("${net}", key="netname", size=0.6, halign="end", valign="middle", dx=-0.4, dy=0);
//   #MPB1:3 @TEXT("${net}", key="netname", size=0.6, halign="start", valign="middle", rotate=90, dx=0, dy=0.4);
//   %v15 = $SUPPLY @ATTACH &VREFP => @PLACE(67, 19.2);
//   &VREFP @WIRE {#MPB1:4 (67, 16) %v15:p};
//   #MNB1 @PLACE(64, -10);
//   #MNB1 @ORIENT("R0");
//   #MNB1:1 @TEXT("${net}", key="netname", size=0.6, halign="start", valign="middle", rotate=90, dx=0, dy=0.4);
//   #MNB1:2 @TEXT("${net}", key="netname", size=0.6, halign="end", valign="middle", dx=-0.4, dy=0);
//   %g16 = $GROUND @ATTACH &VREFN => @PLACE(64, -15.2);
//   &VREFN @WIRE {#MNB1:3 (64, -12) %g16:p};
//   %g17 = $GROUND @ATTACH &VSS => @PLACE(67, -13.2);
//   &VSS @WIRE {#MNB1:4 (67, -10) %g17:p};
//   #MPB2 @PLACE(64, 6);
//   #MPB2 @ORIENT("R0");
//   #MPB2:1 @TEXT("${net}", key="netname", size=0.6, halign="end", valign="middle", rotate=90, dx=0, dy=-0.4);
//   #MPB2:2 @TEXT("${net}", key="netname", size=0.6, halign="end", valign="middle", dx=-0.4, dy=0);
//   #MPB2:3 @TEXT("${net}", key="netname", size=0.6, halign="start", valign="middle", rotate=90, dx=0, dy=0.4);
//   %v18 = $SUPPLY @ATTACH &VREFP => @PLACE(67, 9.2);
//   &VREFP @WIRE {#MPB2:4 (67, 6) %v18:p};
//   #MNB2 @PLACE(80, -10);
//   #MNB2 @ORIENT("R0");
//   #MNB2:1 @TEXT("${net}", key="netname", size=0.6, halign="start", valign="middle", rotate=90, dx=0, dy=0.4);
//   #MNB2:2 @TEXT("${net}", key="netname", size=0.6, halign="end", valign="middle", dx=-0.4, dy=0);
//   %g19 = $GROUND @ATTACH &VREFN => @PLACE(80, -15.2);
//   &VREFN @WIRE {#MNB2:3 (80, -12) %g19:p};
//   %g20 = $GROUND @ATTACH &VSS => @PLACE(83, -13.2);
//   &VSS @WIRE {#MNB2:4 (83, -10) %g20:p};
//   #MFNN @PLACE(108, 12);
//   #MFNN @ORIENT("R0");
//   #MFNN:1 @TEXT("${net}", key="netname", size=0.6, halign="start", valign="middle", rotate=90, dx=0, dy=0.4);
//   #MFNN:2 @TEXT("${net}", key="netname", size=0.6, halign="end", valign="middle", dx=-0.4, dy=0);
//   %g21 = $GROUND @ATTACH &VREFN => @PLACE(108, 6.8);
//   &VREFN @WIRE {#MFNN:3 (108, 10) %g21:p};
//   %g22 = $GROUND @ATTACH &VSS => @PLACE(111, 8.8);
//   &VSS @WIRE {#MFNN:4 (111, 12) %g22:p};
//   #MFNP @PLACE(108, 22);
//   #MFNP @ORIENT("R0");
//   #MFNP:1 @TEXT("${net}", key="netname", size=0.6, halign="end", valign="middle", rotate=90, dx=0, dy=-0.4);
//   #MFNP:2 @TEXT("${net}", key="netname", size=0.6, halign="end", valign="middle", dx=-0.4, dy=0);
//   %v23 = $SUPPLY @ATTACH &VREFP => @PLACE(108, 27.2);
//   &VREFP @WIRE {#MFNP:3 (108, 24) %v23:p};
//   %v24 = $SUPPLY @ATTACH &VREFP => @PLACE(111, 25.2);
//   &VREFP @WIRE {#MFNP:4 (111, 22) %v24:p};
//   #MFPN @PLACE(136, 12);
//   #MFPN @ORIENT("R0");
//   #MFPN:1 @TEXT("${net}", key="netname", size=0.6, halign="start", valign="middle", rotate=90, dx=0, dy=0.4);
//   #MFPN:2 @TEXT("${net}", key="netname", size=0.6, halign="end", valign="middle", dx=-0.4, dy=0);
//   %g25 = $GROUND @ATTACH &VREFN => @PLACE(136, 6.8);
//   &VREFN @WIRE {#MFPN:3 (136, 10) %g25:p};
//   %g26 = $GROUND @ATTACH &VSS => @PLACE(139, 8.8);
//   &VSS @WIRE {#MFPN:4 (139, 12) %g26:p};
//   #MFPP @PLACE(136, 22);
//   #MFPP @ORIENT("R0");
//   #MFPP:1 @TEXT("${net}", key="netname", size=0.6, halign="end", valign="middle", rotate=90, dx=0, dy=-0.4);
//   #MFPP:2 @TEXT("${net}", key="netname", size=0.6, halign="end", valign="middle", dx=-0.4, dy=0);
//   %v27 = $SUPPLY @ATTACH &VREFP => @PLACE(136, 27.2);
//   &VREFP @WIRE {#MFPP:3 (136, 24) %v27:p};
//   %v28 = $SUPPLY @ATTACH &VREFP => @PLACE(139, 25.2);
//   &VREFP @WIRE {#MFPP:4 (139, 22) %v28:p};
//   #MNOUT @PLACE(168, 0);
//   #MNOUT @ORIENT("R0");
//   #MNOUT:1 @TEXT("${net}", key="netname", size=0.6, halign="start", valign="middle", rotate=90, dx=0, dy=0.4);
//   #MNOUT:2 @TEXT("${net}", key="netname", size=0.6, halign="end", valign="middle", dx=-0.4, dy=0);
//   %g29 = $GROUND @ATTACH &VREFN => @PLACE(168, -5.2);
//   &VREFN @WIRE {#MNOUT:3 (168, -2) %g29:p};
//   %g30 = $GROUND @ATTACH &VSS => @PLACE(171, -3.2);
//   &VSS @WIRE {#MNOUT:4 (171, 0) %g30:p};
//   #MPOUT @PLACE(168, 22);
//   #MPOUT @ORIENT("R0");
//   #MPOUT:1 @TEXT("${net}", key="netname", size=0.6, halign="end", valign="middle", rotate=90, dx=0, dy=-0.4);
//   #MPOUT:2 @TEXT("${net}", key="netname", size=0.6, halign="end", valign="middle", dx=-0.4, dy=0);
//   %v31 = $SUPPLY @ATTACH &VREFP => @PLACE(168, 27.2);
//   &VREFP @WIRE {#MPOUT:3 (168, 24) %v31:p};
//   %v32 = $SUPPLY @ATTACH &VREFP => @PLACE(171, 25.2);
//   &VREFP @WIRE {#MPOUT:4 (171, 22) %v32:p};
//   &NOFF @WIRE {#MFNN:1 #MFNP:1};
//   &GN @WIRE {#MFNN:2 (103, 12) (103, 22) #MFNP:2};
//   &PON @WIRE {#MFPN:1 #MFPP:1};
//   &GP @WIRE {#MFPN:2 (131, 12) (131, 22) #MFPP:2};
//   %gp_bus = (16, 22);
//   $JUNCTION @ATTACH %gp_bus;
//   &GP @WIRE {#MPA0:1 (0, 22) %gp_bus (32, 22) #MPA2:1};
//   &GP @WIRE {#MPA1:1 %gp_bus #MNA0:1};
//   &AN1 @WIRE {#MNA0:3 #MNA1:1};
//   &AN2 @WIRE {#MNA1:3 #MNA2:1};
//   &BP1 @WIRE {#MPB0:1 #MPB1:3};
//   &BP2 @WIRE {#MPB1:1 #MPB2:3};
//   %gn_bus = (64, -6);
//   $JUNCTION @ATTACH %gn_bus;
//   &GN @WIRE {#MNB0:1 (48, -6) %gn_bus (80, -6) #MNB2:1};
//   &GN @WIRE {#MNB1:1 %gn_bus #MPB2:1};
//   &BP @WIRE {#MNOUT:1 #MPOUT:1};
//   %p_hi = $IO_PORT @ATTACH &HI => @PLACE(9, 26) => @ORIENT("R0");
//   &HI @WIRE {%p_hi:p #MPA1:2};
//   %p_en = $IO_PORT @ATTACH &EN => @PLACE(-7, 26) => @ORIENT("R0");
//   &EN @WIRE {%p_en:p #MPA0:2};
//   %p_enb = $IO_PORT @ATTACH &ENB => @PLACE(57, 26) => @ORIENT("R0");
//   &ENB @WIRE {%p_enb:p #MPB0:2};
//   %p_bp = $IO_PORT @ATTACH &BP => @PLACE(168, 6) => @ORIENT("R270");
//   &BP @WIRE {%p_bp:p #MNOUT:1};
//   (-10, 48) @TEXT("Tristate nonoverlap driver j=11") => @SET-STYLE $title_style
// }
ends mq_cdac_drv11

// Matched half-capacitor pair j=11, weight 560
subckt mq_cdac_bit11 (VIN VG DH RL EN ENB TOP VREFP VREFN VSS)
// CP*: user-specified pre-layout estimate, 5% of each physical MOM unit to VSS.
// The second MOM terminal is its bottom plate; parallel multipliers are aggregated.
// Series tails add one unit parasitic at MID and one at B, not 5% of the equivalent half unit.
XHCTL (DH HHI VREFP VREFN VSS) mq_cdac_ctl_h
XLCTL (RL LHI VREFP VREFN VSS) mq_cdac_ctl_l
XDH (HHI EN ENB BH VREFP VREFN VSS) mq_cdac_drv11
CH (TOP BH) cfmom_2t w=5e-08 s=2.4e-07 nr=6 lr=1.69e-06 stm=2 spm=4 multi=280
CPH (BH VSS) capacitor c=1.40320600e-14
MSH (BH VG VIN VSS) nch_ulvt_mac w=6.54e-06 l=3e-08 nf=4
XDL (LHI EN ENB BL VREFP VREFN VSS) mq_cdac_drv11
CL (TOP BL) cfmom_2t w=5e-08 s=2.4e-07 nr=6 lr=1.69e-06 stm=2 spm=4 multi=280
CPL (BL VSS) capacitor c=1.40320600e-14
MSL (BL VG VIN VSS) nch_ulvt_mac w=6.54e-06 l=3e-08 nf=4
// @RNL {
//   /* pins connected by net name: the net-name label of rnl-std-fill on every unwired pin, placed below by its key netname */
//   $LABEL_TERMINAL_SET @TEXT("${net}", key="netname", size=0.6);
//   &VSS @ADD-TO $GROUND_NET_SET; &VREFN @ADD-TO $GROUND_NET_SET; &VREFP @ADD-TO $SUPPLY_NET_SET;
//   {#CH #CL} @AS $MATCHED;
//   {#MSH #MSL} @AS $MATCHED;
//   {#XDH #XDL} @AS $MATCHED;
//   #XHCTL @PLACE(-70, 24);
//   #XHCTL @ORIENT("R0");
//   #XHCTL:IN @TEXT("${net}", key="netname", size=0.6, halign="end", valign="middle", dx=-0.4, dy=0);
//   #XHCTL:HI @TEXT("${net}", key="netname", size=0.6, halign="start", valign="middle", dx=0.4, dy=0);
//   %v1 = $SUPPLY @ATTACH &VREFP => @PLACE(-70, 31.2);
//   &VREFP @WIRE {#XHCTL:VREFP (-70, 28) %v1:p};
//   %g2 = $GROUND @ATTACH &VREFN => @PLACE(-72, 16.8);
//   &VREFN @WIRE {#XHCTL:VREFN (-72, 20) %g2:p};
//   %g3 = $GROUND @ATTACH &VSS => @PLACE(-68, 16.8);
//   &VSS @WIRE {#XHCTL:VSS (-68, 20) %g3:p};
//   #XLCTL @PLACE(-70, -26);
//   #XLCTL @ORIENT("R0");
//   #XLCTL:IN @TEXT("${net}", key="netname", size=0.6, halign="end", valign="middle", dx=-0.4, dy=0);
//   #XLCTL:HI @TEXT("${net}", key="netname", size=0.6, halign="start", valign="middle", dx=0.4, dy=0);
//   %v4 = $SUPPLY @ATTACH &VREFP => @PLACE(-70, -18.8);
//   &VREFP @WIRE {#XLCTL:VREFP (-70, -22) %v4:p};
//   %g5 = $GROUND @ATTACH &VREFN => @PLACE(-72, -33.2);
//   &VREFN @WIRE {#XLCTL:VREFN (-72, -30) %g5:p};
//   %g6 = $GROUND @ATTACH &VSS => @PLACE(-68, -33.2);
//   &VSS @WIRE {#XLCTL:VSS (-68, -30) %g6:p};
//   #XDH @PLACE(-34, 24);
//   #XDH @ORIENT("R0");
//   #XDH:HI @TEXT("${net}", key="netname", size=0.6, halign="end", valign="middle", dx=-0.4, dy=0);
//   #XDH:EN @TEXT("${net}", key="netname", size=0.6, halign="end", valign="middle", dx=-0.4, dy=0);
//   #XDH:ENB @TEXT("${net}", key="netname", size=0.6, halign="end", valign="middle", dx=-0.4, dy=0);
//   #XDH:BP @TEXT("${net}", key="netname", size=0.6, halign="start", valign="middle", dx=0.4, dy=0);
//   %v7 = $SUPPLY @ATTACH &VREFP => @PLACE(-34, 32.2);
//   &VREFP @WIRE {#XDH:VREFP (-34, 29) %v7:p};
//   %g8 = $GROUND @ATTACH &VREFN => @PLACE(-36, 15.8);
//   &VREFN @WIRE {#XDH:VREFN (-36, 19) %g8:p};
//   %g9 = $GROUND @ATTACH &VSS => @PLACE(-32, 15.8);
//   &VSS @WIRE {#XDH:VSS (-32, 19) %g9:p};
//   #CH @PLACE(14, 24) => @ORIENT("R270");
//   #CH:1 @TEXT("${net}", key="netname", size=0.6, halign="start", valign="middle", dx=0.4, dy=0);
//   #CH:2 @TEXT("${net}", key="netname", size=0.6, halign="end", valign="middle", dx=-0.4, dy=0);
//   #CPH @PLACE(60, 20);
//   #CPH @ORIENT("R0");
//   #CPH:1 @TEXT("${net}", key="netname", size=0.6, halign="start", valign="middle", rotate=90, dx=0, dy=0.4);
//   %g10 = $GROUND @ATTACH &VSS => @PLACE(60, 14.8);
//   &VSS @WIRE {#CPH:2 (60, 18) %g10:p};
//   #MSH @PLACE(2, 8);
//   #MSH @ORIENT("R0");
//   #MSH:1 @TEXT("${net}", key="netname", size=0.6, halign="start", valign="middle", rotate=90, dx=0, dy=0.4);
//   #MSH:2 @TEXT("${net}", key="netname", size=0.6, halign="end", valign="middle", dx=-0.4, dy=0);
//   #MSH:3 @TEXT("${net}", key="netname", size=0.6, halign="end", valign="middle", rotate=90, dx=0, dy=-0.4);
//   %g11 = $GROUND @ATTACH &VSS => @PLACE(5, 4.8);
//   &VSS @WIRE {#MSH:4 (5, 8) %g11:p};
//   #XDL @PLACE(-34, -26);
//   #XDL @ORIENT("R0");
//   #XDL:HI @TEXT("${net}", key="netname", size=0.6, halign="end", valign="middle", dx=-0.4, dy=0);
//   #XDL:EN @TEXT("${net}", key="netname", size=0.6, halign="end", valign="middle", dx=-0.4, dy=0);
//   #XDL:ENB @TEXT("${net}", key="netname", size=0.6, halign="end", valign="middle", dx=-0.4, dy=0);
//   #XDL:BP @TEXT("${net}", key="netname", size=0.6, halign="start", valign="middle", dx=0.4, dy=0);
//   %v12 = $SUPPLY @ATTACH &VREFP => @PLACE(-34, -17.8);
//   &VREFP @WIRE {#XDL:VREFP (-34, -21) %v12:p};
//   %g13 = $GROUND @ATTACH &VREFN => @PLACE(-36, -34.2);
//   &VREFN @WIRE {#XDL:VREFN (-36, -31) %g13:p};
//   %g14 = $GROUND @ATTACH &VSS => @PLACE(-32, -34.2);
//   &VSS @WIRE {#XDL:VSS (-32, -31) %g14:p};
//   #CL @PLACE(14, -26) => @ORIENT("R270");
//   #CL:1 @TEXT("${net}", key="netname", size=0.6, halign="start", valign="middle", dx=0.4, dy=0);
//   #CL:2 @TEXT("${net}", key="netname", size=0.6, halign="end", valign="middle", dx=-0.4, dy=0);
//   #CPL @PLACE(60, -30);
//   #CPL @ORIENT("R0");
//   #CPL:1 @TEXT("${net}", key="netname", size=0.6, halign="start", valign="middle", rotate=90, dx=0, dy=0.4);
//   %g15 = $GROUND @ATTACH &VSS => @PLACE(60, -35.2);
//   &VSS @WIRE {#CPL:2 (60, -32) %g15:p};
//   #MSL @PLACE(2, -42);
//   #MSL @ORIENT("R0");
//   #MSL:1 @TEXT("${net}", key="netname", size=0.6, halign="start", valign="middle", rotate=90, dx=0, dy=0.4);
//   #MSL:2 @TEXT("${net}", key="netname", size=0.6, halign="end", valign="middle", dx=-0.4, dy=0);
//   #MSL:3 @TEXT("${net}", key="netname", size=0.6, halign="end", valign="middle", rotate=90, dx=0, dy=-0.4);
//   %g16 = $GROUND @ATTACH &VSS => @PLACE(5, -45.2);
//   &VSS @WIRE {#MSL:4 (5, -42) %g16:p};
//   &HHI @WIRE {#XHCTL:HI (-52, 24) (-52, 26) #XDH:HI};
//   %b_H = (-12, 24);
//   $JUNCTION @ATTACH %b_H;
//   &BH @WIRE {#XDH:BP %b_H};
//   &BH @WIRE {%b_H #CH:2};
//   &BH @WIRE {%b_H (-12, 10) #MSH:1};
//   &LHI @WIRE {#XLCTL:HI (-52, -26) (-52, -24) #XDL:HI};
//   %b_L = (-12, -26);
//   $JUNCTION @ATTACH %b_L;
//   &BL @WIRE {#XDL:BP %b_L};
//   &BL @WIRE {%b_L #CL:2};
//   &BL @WIRE {%b_L (-12, -40) #MSL:1};
//   &VIN @WIRE {#MSH:3 (6, 6) (6, -44) #MSL:3};
//   &VG @WIRE {#MSH:2 (-5, 8) (-5, -42) #MSL:2};
//   %top_H = (44, 24);
//   $JUNCTION @ATTACH %top_H;
//   %top_L = (44, -26);
//   $JUNCTION @ATTACH %top_L;
//   &TOP @WIRE {#CH:1 %top_H};
//   &TOP @WIRE {#CL:1 %top_L};
//   &TOP @WIRE {%top_H %top_L};
//   %p_vin = $IO_PORT @ATTACH &VIN => @PLACE(2, 2) => @ORIENT("R90");
//   &VIN @WIRE {%p_vin:p #MSH:3};
//   %p_vg = $IO_PORT @ATTACH &VG => @PLACE(-5, 8) => @ORIENT("R0");
//   &VG @WIRE {%p_vg:p #MSH:2};
//   %p_dh = $IO_PORT @ATTACH &DH => @PLACE(-81, 24) => @ORIENT("R0");
//   &DH @WIRE {%p_dh:p #XHCTL:IN};
//   %p_rl = $IO_PORT @ATTACH &RL => @PLACE(-81, -26) => @ORIENT("R0");
//   &RL @WIRE {%p_rl:p #XLCTL:IN};
//   %p_en = $IO_PORT @ATTACH &EN => @PLACE(-45, 24) => @ORIENT("R0");
//   &EN @WIRE {%p_en:p #XDH:EN};
//   %p_enb = $IO_PORT @ATTACH &ENB => @PLACE(-45, 22) => @ORIENT("R0");
//   &ENB @WIRE {%p_enb:p #XDH:ENB};
//   %p_top = $IO_PORT @ATTACH &TOP => @PLACE(20, 24) => @ORIENT("MY");
//   &TOP @WIRE {%p_top:p #CH:1};
//   (-10, 46) @TEXT("Matched half-capacitor pair j=11, weight 560") => @SET-STYLE $title_style
// }
ends mq_cdac_bit11

// Tristate nonoverlap driver j=10
subckt mq_cdac_drv10 (HI EN ENB BP VREFP VREFN VSS)
// GP = NAND(EN, HI, NOT(GN)); GN = NOR(ENB, HI, NOT(GP)).
// Feedback senses the opposite output-device gate; each turn-on waits for the opposite turn-off.
MPA0 (GP EN VREFP VREFP) pch_ulvt_mac w=1.3e-06 l=3e-08 nf=1
MNA0 (GP EN AN1 VSS) nch_ulvt_mac w=2.6e-06 l=3e-08 nf=2
MPA1 (GP HI VREFP VREFP) pch_ulvt_mac w=1.3e-06 l=3e-08 nf=1
MNA1 (AN1 HI AN2 VSS) nch_ulvt_mac w=2.6e-06 l=3e-08 nf=2
MPA2 (GP NOFF VREFP VREFP) pch_ulvt_mac w=1.3e-06 l=3e-08 nf=1
MNA2 (AN2 NOFF VREFN VSS) nch_ulvt_mac w=2.6e-06 l=3e-08 nf=2
MPB0 (BP1 ENB VREFP VREFP) pch_ulvt_mac w=3.89e-06 l=3e-08 nf=2
MNB0 (GN ENB VREFN VSS) nch_ulvt_mac w=1.3e-06 l=3e-08 nf=1
MPB1 (BP2 HI BP1 VREFP) pch_ulvt_mac w=3.89e-06 l=3e-08 nf=2
MNB1 (GN HI VREFN VSS) nch_ulvt_mac w=1.3e-06 l=3e-08 nf=1
MPB2 (GN PON BP2 VREFP) pch_ulvt_mac w=3.89e-06 l=3e-08 nf=2
MNB2 (GN PON VREFN VSS) nch_ulvt_mac w=1.3e-06 l=3e-08 nf=1
MFNN (NOFF GN VREFN VSS) nch_ulvt_mac w=1.3e-06 l=3e-08 nf=1
MFNP (NOFF GN VREFP VREFP) pch_ulvt_mac w=2.6e-06 l=3e-08 nf=2
MFPN (PON GP VREFN VSS) nch_ulvt_mac w=1.3e-06 l=3e-08 nf=1
MFPP (PON GP VREFP VREFP) pch_ulvt_mac w=2.6e-06 l=3e-08 nf=2
MNOUT (BP GN VREFN VSS) nch_ulvt_mac w=6.48e-06 l=3e-08 nf=4
MPOUT (BP GP VREFP VREFP) pch_ulvt_mac w=1.2985e-05 l=3e-08 nf=7
// @RNL {
//   /* pins connected by net name: the net-name label of rnl-std-fill on every unwired pin, placed below by its key netname */
//   $LABEL_TERMINAL_SET @TEXT("${net}", key="netname", size=0.6);
//   &VSS @ADD-TO $GROUND_NET_SET; &VREFN @ADD-TO $GROUND_NET_SET; &VREFP @ADD-TO $SUPPLY_NET_SET;
//   {#MFNN #MFNP} @GROUP;
//   {#MFPN #MFPP} @GROUP;
//   {#MPA0 #MPA1 #MPA2 #MNA0 #MNA1 #MNA2} @GROUP;
//   {#MPB0 #MPB1 #MPB2 #MNB0 #MNB1 #MNB2} @GROUP;
//   {#MNOUT #MPOUT} @GROUP;
//   #MPA0 @PLACE(0, 26);
//   #MPA0 @ORIENT("R0");
//   #MPA0:1 @TEXT("${net}", key="netname", size=0.6, halign="end", valign="middle", rotate=90, dx=0, dy=-0.4);
//   #MPA0:2 @TEXT("${net}", key="netname", size=0.6, halign="end", valign="middle", dx=-0.4, dy=0);
//   %v1 = $SUPPLY @ATTACH &VREFP => @PLACE(0, 31.2);
//   &VREFP @WIRE {#MPA0:3 (0, 28) %v1:p};
//   %v2 = $SUPPLY @ATTACH &VREFP => @PLACE(3, 29.2);
//   &VREFP @WIRE {#MPA0:4 (3, 26) %v2:p};
//   #MNA0 @PLACE(16, 12);
//   #MNA0 @ORIENT("R0");
//   #MNA0:1 @TEXT("${net}", key="netname", size=0.6, halign="start", valign="middle", rotate=90, dx=0, dy=0.4);
//   #MNA0:2 @TEXT("${net}", key="netname", size=0.6, halign="end", valign="middle", dx=-0.4, dy=0);
//   #MNA0:3 @TEXT("${net}", key="netname", size=0.6, halign="end", valign="middle", rotate=90, dx=0, dy=-0.4);
//   %g3 = $GROUND @ATTACH &VSS => @PLACE(19, 8.8);
//   &VSS @WIRE {#MNA0:4 (19, 12) %g3:p};
//   #MPA1 @PLACE(16, 26);
//   #MPA1 @ORIENT("R0");
//   #MPA1:1 @TEXT("${net}", key="netname", size=0.6, halign="end", valign="middle", rotate=90, dx=0, dy=-0.4);
//   #MPA1:2 @TEXT("${net}", key="netname", size=0.6, halign="end", valign="middle", dx=-0.4, dy=0);
//   %v4 = $SUPPLY @ATTACH &VREFP => @PLACE(16, 31.2);
//   &VREFP @WIRE {#MPA1:3 (16, 28) %v4:p};
//   %v5 = $SUPPLY @ATTACH &VREFP => @PLACE(19, 29.2);
//   &VREFP @WIRE {#MPA1:4 (19, 26) %v5:p};
//   #MNA1 @PLACE(16, 2);
//   #MNA1 @ORIENT("R0");
//   #MNA1:1 @TEXT("${net}", key="netname", size=0.6, halign="start", valign="middle", rotate=90, dx=0, dy=0.4);
//   #MNA1:2 @TEXT("${net}", key="netname", size=0.6, halign="end", valign="middle", dx=-0.4, dy=0);
//   #MNA1:3 @TEXT("${net}", key="netname", size=0.6, halign="end", valign="middle", rotate=90, dx=0, dy=-0.4);
//   %g6 = $GROUND @ATTACH &VSS => @PLACE(19, -1.2);
//   &VSS @WIRE {#MNA1:4 (19, 2) %g6:p};
//   #MPA2 @PLACE(32, 26);
//   #MPA2 @ORIENT("R0");
//   #MPA2:1 @TEXT("${net}", key="netname", size=0.6, halign="end", valign="middle", rotate=90, dx=0, dy=-0.4);
//   #MPA2:2 @TEXT("${net}", key="netname", size=0.6, halign="end", valign="middle", dx=-0.4, dy=0);
//   %v7 = $SUPPLY @ATTACH &VREFP => @PLACE(32, 31.2);
//   &VREFP @WIRE {#MPA2:3 (32, 28) %v7:p};
//   %v8 = $SUPPLY @ATTACH &VREFP => @PLACE(35, 29.2);
//   &VREFP @WIRE {#MPA2:4 (35, 26) %v8:p};
//   #MNA2 @PLACE(16, -8);
//   #MNA2 @ORIENT("R0");
//   #MNA2:1 @TEXT("${net}", key="netname", size=0.6, halign="start", valign="middle", rotate=90, dx=0, dy=0.4);
//   #MNA2:2 @TEXT("${net}", key="netname", size=0.6, halign="end", valign="middle", dx=-0.4, dy=0);
//   %g9 = $GROUND @ATTACH &VREFN => @PLACE(16, -13.2);
//   &VREFN @WIRE {#MNA2:3 (16, -10) %g9:p};
//   %g10 = $GROUND @ATTACH &VSS => @PLACE(19, -11.2);
//   &VSS @WIRE {#MNA2:4 (19, -8) %g10:p};
//   #MPB0 @PLACE(64, 26);
//   #MPB0 @ORIENT("R0");
//   #MPB0:1 @TEXT("${net}", key="netname", size=0.6, halign="end", valign="middle", rotate=90, dx=0, dy=-0.4);
//   #MPB0:2 @TEXT("${net}", key="netname", size=0.6, halign="end", valign="middle", dx=-0.4, dy=0);
//   %v11 = $SUPPLY @ATTACH &VREFP => @PLACE(64, 31.2);
//   &VREFP @WIRE {#MPB0:3 (64, 28) %v11:p};
//   %v12 = $SUPPLY @ATTACH &VREFP => @PLACE(67, 29.2);
//   &VREFP @WIRE {#MPB0:4 (67, 26) %v12:p};
//   #MNB0 @PLACE(48, -10);
//   #MNB0 @ORIENT("R0");
//   #MNB0:1 @TEXT("${net}", key="netname", size=0.6, halign="start", valign="middle", rotate=90, dx=0, dy=0.4);
//   #MNB0:2 @TEXT("${net}", key="netname", size=0.6, halign="end", valign="middle", dx=-0.4, dy=0);
//   %g13 = $GROUND @ATTACH &VREFN => @PLACE(48, -15.2);
//   &VREFN @WIRE {#MNB0:3 (48, -12) %g13:p};
//   %g14 = $GROUND @ATTACH &VSS => @PLACE(51, -13.2);
//   &VSS @WIRE {#MNB0:4 (51, -10) %g14:p};
//   #MPB1 @PLACE(64, 16);
//   #MPB1 @ORIENT("R0");
//   #MPB1:1 @TEXT("${net}", key="netname", size=0.6, halign="end", valign="middle", rotate=90, dx=0, dy=-0.4);
//   #MPB1:2 @TEXT("${net}", key="netname", size=0.6, halign="end", valign="middle", dx=-0.4, dy=0);
//   #MPB1:3 @TEXT("${net}", key="netname", size=0.6, halign="start", valign="middle", rotate=90, dx=0, dy=0.4);
//   %v15 = $SUPPLY @ATTACH &VREFP => @PLACE(67, 19.2);
//   &VREFP @WIRE {#MPB1:4 (67, 16) %v15:p};
//   #MNB1 @PLACE(64, -10);
//   #MNB1 @ORIENT("R0");
//   #MNB1:1 @TEXT("${net}", key="netname", size=0.6, halign="start", valign="middle", rotate=90, dx=0, dy=0.4);
//   #MNB1:2 @TEXT("${net}", key="netname", size=0.6, halign="end", valign="middle", dx=-0.4, dy=0);
//   %g16 = $GROUND @ATTACH &VREFN => @PLACE(64, -15.2);
//   &VREFN @WIRE {#MNB1:3 (64, -12) %g16:p};
//   %g17 = $GROUND @ATTACH &VSS => @PLACE(67, -13.2);
//   &VSS @WIRE {#MNB1:4 (67, -10) %g17:p};
//   #MPB2 @PLACE(64, 6);
//   #MPB2 @ORIENT("R0");
//   #MPB2:1 @TEXT("${net}", key="netname", size=0.6, halign="end", valign="middle", rotate=90, dx=0, dy=-0.4);
//   #MPB2:2 @TEXT("${net}", key="netname", size=0.6, halign="end", valign="middle", dx=-0.4, dy=0);
//   #MPB2:3 @TEXT("${net}", key="netname", size=0.6, halign="start", valign="middle", rotate=90, dx=0, dy=0.4);
//   %v18 = $SUPPLY @ATTACH &VREFP => @PLACE(67, 9.2);
//   &VREFP @WIRE {#MPB2:4 (67, 6) %v18:p};
//   #MNB2 @PLACE(80, -10);
//   #MNB2 @ORIENT("R0");
//   #MNB2:1 @TEXT("${net}", key="netname", size=0.6, halign="start", valign="middle", rotate=90, dx=0, dy=0.4);
//   #MNB2:2 @TEXT("${net}", key="netname", size=0.6, halign="end", valign="middle", dx=-0.4, dy=0);
//   %g19 = $GROUND @ATTACH &VREFN => @PLACE(80, -15.2);
//   &VREFN @WIRE {#MNB2:3 (80, -12) %g19:p};
//   %g20 = $GROUND @ATTACH &VSS => @PLACE(83, -13.2);
//   &VSS @WIRE {#MNB2:4 (83, -10) %g20:p};
//   #MFNN @PLACE(108, 12);
//   #MFNN @ORIENT("R0");
//   #MFNN:1 @TEXT("${net}", key="netname", size=0.6, halign="start", valign="middle", rotate=90, dx=0, dy=0.4);
//   #MFNN:2 @TEXT("${net}", key="netname", size=0.6, halign="end", valign="middle", dx=-0.4, dy=0);
//   %g21 = $GROUND @ATTACH &VREFN => @PLACE(108, 6.8);
//   &VREFN @WIRE {#MFNN:3 (108, 10) %g21:p};
//   %g22 = $GROUND @ATTACH &VSS => @PLACE(111, 8.8);
//   &VSS @WIRE {#MFNN:4 (111, 12) %g22:p};
//   #MFNP @PLACE(108, 22);
//   #MFNP @ORIENT("R0");
//   #MFNP:1 @TEXT("${net}", key="netname", size=0.6, halign="end", valign="middle", rotate=90, dx=0, dy=-0.4);
//   #MFNP:2 @TEXT("${net}", key="netname", size=0.6, halign="end", valign="middle", dx=-0.4, dy=0);
//   %v23 = $SUPPLY @ATTACH &VREFP => @PLACE(108, 27.2);
//   &VREFP @WIRE {#MFNP:3 (108, 24) %v23:p};
//   %v24 = $SUPPLY @ATTACH &VREFP => @PLACE(111, 25.2);
//   &VREFP @WIRE {#MFNP:4 (111, 22) %v24:p};
//   #MFPN @PLACE(136, 12);
//   #MFPN @ORIENT("R0");
//   #MFPN:1 @TEXT("${net}", key="netname", size=0.6, halign="start", valign="middle", rotate=90, dx=0, dy=0.4);
//   #MFPN:2 @TEXT("${net}", key="netname", size=0.6, halign="end", valign="middle", dx=-0.4, dy=0);
//   %g25 = $GROUND @ATTACH &VREFN => @PLACE(136, 6.8);
//   &VREFN @WIRE {#MFPN:3 (136, 10) %g25:p};
//   %g26 = $GROUND @ATTACH &VSS => @PLACE(139, 8.8);
//   &VSS @WIRE {#MFPN:4 (139, 12) %g26:p};
//   #MFPP @PLACE(136, 22);
//   #MFPP @ORIENT("R0");
//   #MFPP:1 @TEXT("${net}", key="netname", size=0.6, halign="end", valign="middle", rotate=90, dx=0, dy=-0.4);
//   #MFPP:2 @TEXT("${net}", key="netname", size=0.6, halign="end", valign="middle", dx=-0.4, dy=0);
//   %v27 = $SUPPLY @ATTACH &VREFP => @PLACE(136, 27.2);
//   &VREFP @WIRE {#MFPP:3 (136, 24) %v27:p};
//   %v28 = $SUPPLY @ATTACH &VREFP => @PLACE(139, 25.2);
//   &VREFP @WIRE {#MFPP:4 (139, 22) %v28:p};
//   #MNOUT @PLACE(168, 0);
//   #MNOUT @ORIENT("R0");
//   #MNOUT:1 @TEXT("${net}", key="netname", size=0.6, halign="start", valign="middle", rotate=90, dx=0, dy=0.4);
//   #MNOUT:2 @TEXT("${net}", key="netname", size=0.6, halign="end", valign="middle", dx=-0.4, dy=0);
//   %g29 = $GROUND @ATTACH &VREFN => @PLACE(168, -5.2);
//   &VREFN @WIRE {#MNOUT:3 (168, -2) %g29:p};
//   %g30 = $GROUND @ATTACH &VSS => @PLACE(171, -3.2);
//   &VSS @WIRE {#MNOUT:4 (171, 0) %g30:p};
//   #MPOUT @PLACE(168, 22);
//   #MPOUT @ORIENT("R0");
//   #MPOUT:1 @TEXT("${net}", key="netname", size=0.6, halign="end", valign="middle", rotate=90, dx=0, dy=-0.4);
//   #MPOUT:2 @TEXT("${net}", key="netname", size=0.6, halign="end", valign="middle", dx=-0.4, dy=0);
//   %v31 = $SUPPLY @ATTACH &VREFP => @PLACE(168, 27.2);
//   &VREFP @WIRE {#MPOUT:3 (168, 24) %v31:p};
//   %v32 = $SUPPLY @ATTACH &VREFP => @PLACE(171, 25.2);
//   &VREFP @WIRE {#MPOUT:4 (171, 22) %v32:p};
//   &NOFF @WIRE {#MFNN:1 #MFNP:1};
//   &GN @WIRE {#MFNN:2 (103, 12) (103, 22) #MFNP:2};
//   &PON @WIRE {#MFPN:1 #MFPP:1};
//   &GP @WIRE {#MFPN:2 (131, 12) (131, 22) #MFPP:2};
//   %gp_bus = (16, 22);
//   $JUNCTION @ATTACH %gp_bus;
//   &GP @WIRE {#MPA0:1 (0, 22) %gp_bus (32, 22) #MPA2:1};
//   &GP @WIRE {#MPA1:1 %gp_bus #MNA0:1};
//   &AN1 @WIRE {#MNA0:3 #MNA1:1};
//   &AN2 @WIRE {#MNA1:3 #MNA2:1};
//   &BP1 @WIRE {#MPB0:1 #MPB1:3};
//   &BP2 @WIRE {#MPB1:1 #MPB2:3};
//   %gn_bus = (64, -6);
//   $JUNCTION @ATTACH %gn_bus;
//   &GN @WIRE {#MNB0:1 (48, -6) %gn_bus (80, -6) #MNB2:1};
//   &GN @WIRE {#MNB1:1 %gn_bus #MPB2:1};
//   &BP @WIRE {#MNOUT:1 #MPOUT:1};
//   %p_hi = $IO_PORT @ATTACH &HI => @PLACE(9, 26) => @ORIENT("R0");
//   &HI @WIRE {%p_hi:p #MPA1:2};
//   %p_en = $IO_PORT @ATTACH &EN => @PLACE(-7, 26) => @ORIENT("R0");
//   &EN @WIRE {%p_en:p #MPA0:2};
//   %p_enb = $IO_PORT @ATTACH &ENB => @PLACE(57, 26) => @ORIENT("R0");
//   &ENB @WIRE {%p_enb:p #MPB0:2};
//   %p_bp = $IO_PORT @ATTACH &BP => @PLACE(168, 6) => @ORIENT("R270");
//   &BP @WIRE {%p_bp:p #MNOUT:1};
//   (-10, 48) @TEXT("Tristate nonoverlap driver j=10") => @SET-STYLE $title_style
// }
ends mq_cdac_drv10

// Matched half-capacitor pair j=10, weight 318
subckt mq_cdac_bit10 (VIN VG DH RL EN ENB TOP VREFP VREFN VSS)
// CP*: user-specified pre-layout estimate, 5% of each physical MOM unit to VSS.
// The second MOM terminal is its bottom plate; parallel multipliers are aggregated.
// Series tails add one unit parasitic at MID and one at B, not 5% of the equivalent half unit.
XHCTL (DH HHI VREFP VREFN VSS) mq_cdac_ctl_h
XLCTL (RL LHI VREFP VREFN VSS) mq_cdac_ctl_l
XDH (HHI EN ENB BH VREFP VREFN VSS) mq_cdac_drv10
CH (TOP BH) cfmom_2t w=5e-08 s=2.4e-07 nr=6 lr=1.69e-06 stm=2 spm=4 multi=159
CPH (BH VSS) capacitor c=7.9682055e-15
MSH (BH VG VIN VSS) nch_ulvt_mac w=3.71e-06 l=3e-08 nf=2
XDL (LHI EN ENB BL VREFP VREFN VSS) mq_cdac_drv10
CL (TOP BL) cfmom_2t w=5e-08 s=2.4e-07 nr=6 lr=1.69e-06 stm=2 spm=4 multi=159
CPL (BL VSS) capacitor c=7.9682055e-15
MSL (BL VG VIN VSS) nch_ulvt_mac w=3.71e-06 l=3e-08 nf=2
// @RNL {
//   /* pins connected by net name: the net-name label of rnl-std-fill on every unwired pin, placed below by its key netname */
//   $LABEL_TERMINAL_SET @TEXT("${net}", key="netname", size=0.6);
//   &VSS @ADD-TO $GROUND_NET_SET; &VREFN @ADD-TO $GROUND_NET_SET; &VREFP @ADD-TO $SUPPLY_NET_SET;
//   {#CH #CL} @AS $MATCHED;
//   {#MSH #MSL} @AS $MATCHED;
//   {#XDH #XDL} @AS $MATCHED;
//   #XHCTL @PLACE(-70, 24);
//   #XHCTL @ORIENT("R0");
//   #XHCTL:IN @TEXT("${net}", key="netname", size=0.6, halign="end", valign="middle", dx=-0.4, dy=0);
//   #XHCTL:HI @TEXT("${net}", key="netname", size=0.6, halign="start", valign="middle", dx=0.4, dy=0);
//   %v1 = $SUPPLY @ATTACH &VREFP => @PLACE(-70, 31.2);
//   &VREFP @WIRE {#XHCTL:VREFP (-70, 28) %v1:p};
//   %g2 = $GROUND @ATTACH &VREFN => @PLACE(-72, 16.8);
//   &VREFN @WIRE {#XHCTL:VREFN (-72, 20) %g2:p};
//   %g3 = $GROUND @ATTACH &VSS => @PLACE(-68, 16.8);
//   &VSS @WIRE {#XHCTL:VSS (-68, 20) %g3:p};
//   #XLCTL @PLACE(-70, -26);
//   #XLCTL @ORIENT("R0");
//   #XLCTL:IN @TEXT("${net}", key="netname", size=0.6, halign="end", valign="middle", dx=-0.4, dy=0);
//   #XLCTL:HI @TEXT("${net}", key="netname", size=0.6, halign="start", valign="middle", dx=0.4, dy=0);
//   %v4 = $SUPPLY @ATTACH &VREFP => @PLACE(-70, -18.8);
//   &VREFP @WIRE {#XLCTL:VREFP (-70, -22) %v4:p};
//   %g5 = $GROUND @ATTACH &VREFN => @PLACE(-72, -33.2);
//   &VREFN @WIRE {#XLCTL:VREFN (-72, -30) %g5:p};
//   %g6 = $GROUND @ATTACH &VSS => @PLACE(-68, -33.2);
//   &VSS @WIRE {#XLCTL:VSS (-68, -30) %g6:p};
//   #XDH @PLACE(-34, 24);
//   #XDH @ORIENT("R0");
//   #XDH:HI @TEXT("${net}", key="netname", size=0.6, halign="end", valign="middle", dx=-0.4, dy=0);
//   #XDH:EN @TEXT("${net}", key="netname", size=0.6, halign="end", valign="middle", dx=-0.4, dy=0);
//   #XDH:ENB @TEXT("${net}", key="netname", size=0.6, halign="end", valign="middle", dx=-0.4, dy=0);
//   #XDH:BP @TEXT("${net}", key="netname", size=0.6, halign="start", valign="middle", dx=0.4, dy=0);
//   %v7 = $SUPPLY @ATTACH &VREFP => @PLACE(-34, 32.2);
//   &VREFP @WIRE {#XDH:VREFP (-34, 29) %v7:p};
//   %g8 = $GROUND @ATTACH &VREFN => @PLACE(-36, 15.8);
//   &VREFN @WIRE {#XDH:VREFN (-36, 19) %g8:p};
//   %g9 = $GROUND @ATTACH &VSS => @PLACE(-32, 15.8);
//   &VSS @WIRE {#XDH:VSS (-32, 19) %g9:p};
//   #CH @PLACE(14, 24) => @ORIENT("R270");
//   #CH:1 @TEXT("${net}", key="netname", size=0.6, halign="start", valign="middle", dx=0.4, dy=0);
//   #CH:2 @TEXT("${net}", key="netname", size=0.6, halign="end", valign="middle", dx=-0.4, dy=0);
//   #CPH @PLACE(60, 20);
//   #CPH @ORIENT("R0");
//   #CPH:1 @TEXT("${net}", key="netname", size=0.6, halign="start", valign="middle", rotate=90, dx=0, dy=0.4);
//   %g10 = $GROUND @ATTACH &VSS => @PLACE(60, 14.8);
//   &VSS @WIRE {#CPH:2 (60, 18) %g10:p};
//   #MSH @PLACE(2, 8);
//   #MSH @ORIENT("R0");
//   #MSH:1 @TEXT("${net}", key="netname", size=0.6, halign="start", valign="middle", rotate=90, dx=0, dy=0.4);
//   #MSH:2 @TEXT("${net}", key="netname", size=0.6, halign="end", valign="middle", dx=-0.4, dy=0);
//   #MSH:3 @TEXT("${net}", key="netname", size=0.6, halign="end", valign="middle", rotate=90, dx=0, dy=-0.4);
//   %g11 = $GROUND @ATTACH &VSS => @PLACE(5, 4.8);
//   &VSS @WIRE {#MSH:4 (5, 8) %g11:p};
//   #XDL @PLACE(-34, -26);
//   #XDL @ORIENT("R0");
//   #XDL:HI @TEXT("${net}", key="netname", size=0.6, halign="end", valign="middle", dx=-0.4, dy=0);
//   #XDL:EN @TEXT("${net}", key="netname", size=0.6, halign="end", valign="middle", dx=-0.4, dy=0);
//   #XDL:ENB @TEXT("${net}", key="netname", size=0.6, halign="end", valign="middle", dx=-0.4, dy=0);
//   #XDL:BP @TEXT("${net}", key="netname", size=0.6, halign="start", valign="middle", dx=0.4, dy=0);
//   %v12 = $SUPPLY @ATTACH &VREFP => @PLACE(-34, -17.8);
//   &VREFP @WIRE {#XDL:VREFP (-34, -21) %v12:p};
//   %g13 = $GROUND @ATTACH &VREFN => @PLACE(-36, -34.2);
//   &VREFN @WIRE {#XDL:VREFN (-36, -31) %g13:p};
//   %g14 = $GROUND @ATTACH &VSS => @PLACE(-32, -34.2);
//   &VSS @WIRE {#XDL:VSS (-32, -31) %g14:p};
//   #CL @PLACE(14, -26) => @ORIENT("R270");
//   #CL:1 @TEXT("${net}", key="netname", size=0.6, halign="start", valign="middle", dx=0.4, dy=0);
//   #CL:2 @TEXT("${net}", key="netname", size=0.6, halign="end", valign="middle", dx=-0.4, dy=0);
//   #CPL @PLACE(60, -30);
//   #CPL @ORIENT("R0");
//   #CPL:1 @TEXT("${net}", key="netname", size=0.6, halign="start", valign="middle", rotate=90, dx=0, dy=0.4);
//   %g15 = $GROUND @ATTACH &VSS => @PLACE(60, -35.2);
//   &VSS @WIRE {#CPL:2 (60, -32) %g15:p};
//   #MSL @PLACE(2, -42);
//   #MSL @ORIENT("R0");
//   #MSL:1 @TEXT("${net}", key="netname", size=0.6, halign="start", valign="middle", rotate=90, dx=0, dy=0.4);
//   #MSL:2 @TEXT("${net}", key="netname", size=0.6, halign="end", valign="middle", dx=-0.4, dy=0);
//   #MSL:3 @TEXT("${net}", key="netname", size=0.6, halign="end", valign="middle", rotate=90, dx=0, dy=-0.4);
//   %g16 = $GROUND @ATTACH &VSS => @PLACE(5, -45.2);
//   &VSS @WIRE {#MSL:4 (5, -42) %g16:p};
//   &HHI @WIRE {#XHCTL:HI (-52, 24) (-52, 26) #XDH:HI};
//   %b_H = (-12, 24);
//   $JUNCTION @ATTACH %b_H;
//   &BH @WIRE {#XDH:BP %b_H};
//   &BH @WIRE {%b_H #CH:2};
//   &BH @WIRE {%b_H (-12, 10) #MSH:1};
//   &LHI @WIRE {#XLCTL:HI (-52, -26) (-52, -24) #XDL:HI};
//   %b_L = (-12, -26);
//   $JUNCTION @ATTACH %b_L;
//   &BL @WIRE {#XDL:BP %b_L};
//   &BL @WIRE {%b_L #CL:2};
//   &BL @WIRE {%b_L (-12, -40) #MSL:1};
//   &VIN @WIRE {#MSH:3 (6, 6) (6, -44) #MSL:3};
//   &VG @WIRE {#MSH:2 (-5, 8) (-5, -42) #MSL:2};
//   %top_H = (44, 24);
//   $JUNCTION @ATTACH %top_H;
//   %top_L = (44, -26);
//   $JUNCTION @ATTACH %top_L;
//   &TOP @WIRE {#CH:1 %top_H};
//   &TOP @WIRE {#CL:1 %top_L};
//   &TOP @WIRE {%top_H %top_L};
//   %p_vin = $IO_PORT @ATTACH &VIN => @PLACE(2, 2) => @ORIENT("R90");
//   &VIN @WIRE {%p_vin:p #MSH:3};
//   %p_vg = $IO_PORT @ATTACH &VG => @PLACE(-5, 8) => @ORIENT("R0");
//   &VG @WIRE {%p_vg:p #MSH:2};
//   %p_dh = $IO_PORT @ATTACH &DH => @PLACE(-81, 24) => @ORIENT("R0");
//   &DH @WIRE {%p_dh:p #XHCTL:IN};
//   %p_rl = $IO_PORT @ATTACH &RL => @PLACE(-81, -26) => @ORIENT("R0");
//   &RL @WIRE {%p_rl:p #XLCTL:IN};
//   %p_en = $IO_PORT @ATTACH &EN => @PLACE(-45, 24) => @ORIENT("R0");
//   &EN @WIRE {%p_en:p #XDH:EN};
//   %p_enb = $IO_PORT @ATTACH &ENB => @PLACE(-45, 22) => @ORIENT("R0");
//   &ENB @WIRE {%p_enb:p #XDH:ENB};
//   %p_top = $IO_PORT @ATTACH &TOP => @PLACE(20, 24) => @ORIENT("MY");
//   &TOP @WIRE {%p_top:p #CH:1};
//   (-10, 46) @TEXT("Matched half-capacitor pair j=10, weight 318") => @SET-STYLE $title_style
// }
ends mq_cdac_bit10

// Tristate nonoverlap driver j=9
subckt mq_cdac_drv9 (HI EN ENB BP VREFP VREFN VSS)
// GP = NAND(EN, HI, NOT(GN)); GN = NOR(ENB, HI, NOT(GP)).
// Feedback senses the opposite output-device gate; each turn-on waits for the opposite turn-off.
MPA0 (GP EN VREFP VREFP) pch_ulvt_mac w=7.35e-07 l=3e-08 nf=1
MNA0 (GP EN AN1 VSS) nch_ulvt_mac w=1.47e-06 l=3e-08 nf=1
MPA1 (GP HI VREFP VREFP) pch_ulvt_mac w=7.35e-07 l=3e-08 nf=1
MNA1 (AN1 HI AN2 VSS) nch_ulvt_mac w=1.47e-06 l=3e-08 nf=1
MPA2 (GP NOFF VREFP VREFP) pch_ulvt_mac w=7.35e-07 l=3e-08 nf=1
MNA2 (AN2 NOFF VREFN VSS) nch_ulvt_mac w=1.47e-06 l=3e-08 nf=1
MPB0 (BP1 ENB VREFP VREFP) pch_ulvt_mac w=2.2e-06 l=3e-08 nf=2
MNB0 (GN ENB VREFN VSS) nch_ulvt_mac w=7.35e-07 l=3e-08 nf=1
MPB1 (BP2 HI BP1 VREFP) pch_ulvt_mac w=2.2e-06 l=3e-08 nf=2
MNB1 (GN HI VREFN VSS) nch_ulvt_mac w=7.35e-07 l=3e-08 nf=1
MPB2 (GN PON BP2 VREFP) pch_ulvt_mac w=2.2e-06 l=3e-08 nf=2
MNB2 (GN PON VREFN VSS) nch_ulvt_mac w=7.35e-07 l=3e-08 nf=1
MFNN (NOFF GN VREFN VSS) nch_ulvt_mac w=7.35e-07 l=3e-08 nf=1
MFNP (NOFF GN VREFP VREFP) pch_ulvt_mac w=1.47e-06 l=3e-08 nf=1
MFPN (PON GP VREFN VSS) nch_ulvt_mac w=7.35e-07 l=3e-08 nf=1
MFPP (PON GP VREFP VREFP) pch_ulvt_mac w=1.47e-06 l=3e-08 nf=1
MNOUT (BP GN VREFN VSS) nch_ulvt_mac w=3.67e-06 l=3e-08 nf=2
MPOUT (BP GP VREFP VREFP) pch_ulvt_mac w=7.34e-06 l=3e-08 nf=4
// @RNL {
//   /* pins connected by net name: the net-name label of rnl-std-fill on every unwired pin, placed below by its key netname */
//   $LABEL_TERMINAL_SET @TEXT("${net}", key="netname", size=0.6);
//   &VSS @ADD-TO $GROUND_NET_SET; &VREFN @ADD-TO $GROUND_NET_SET; &VREFP @ADD-TO $SUPPLY_NET_SET;
//   {#MFNN #MFNP} @GROUP;
//   {#MFPN #MFPP} @GROUP;
//   {#MPA0 #MPA1 #MPA2 #MNA0 #MNA1 #MNA2} @GROUP;
//   {#MPB0 #MPB1 #MPB2 #MNB0 #MNB1 #MNB2} @GROUP;
//   {#MNOUT #MPOUT} @GROUP;
//   #MPA0 @PLACE(0, 26);
//   #MPA0 @ORIENT("R0");
//   #MPA0:1 @TEXT("${net}", key="netname", size=0.6, halign="end", valign="middle", rotate=90, dx=0, dy=-0.4);
//   #MPA0:2 @TEXT("${net}", key="netname", size=0.6, halign="end", valign="middle", dx=-0.4, dy=0);
//   %v1 = $SUPPLY @ATTACH &VREFP => @PLACE(0, 31.2);
//   &VREFP @WIRE {#MPA0:3 (0, 28) %v1:p};
//   %v2 = $SUPPLY @ATTACH &VREFP => @PLACE(3, 29.2);
//   &VREFP @WIRE {#MPA0:4 (3, 26) %v2:p};
//   #MNA0 @PLACE(16, 12);
//   #MNA0 @ORIENT("R0");
//   #MNA0:1 @TEXT("${net}", key="netname", size=0.6, halign="start", valign="middle", rotate=90, dx=0, dy=0.4);
//   #MNA0:2 @TEXT("${net}", key="netname", size=0.6, halign="end", valign="middle", dx=-0.4, dy=0);
//   #MNA0:3 @TEXT("${net}", key="netname", size=0.6, halign="end", valign="middle", rotate=90, dx=0, dy=-0.4);
//   %g3 = $GROUND @ATTACH &VSS => @PLACE(19, 8.8);
//   &VSS @WIRE {#MNA0:4 (19, 12) %g3:p};
//   #MPA1 @PLACE(16, 26);
//   #MPA1 @ORIENT("R0");
//   #MPA1:1 @TEXT("${net}", key="netname", size=0.6, halign="end", valign="middle", rotate=90, dx=0, dy=-0.4);
//   #MPA1:2 @TEXT("${net}", key="netname", size=0.6, halign="end", valign="middle", dx=-0.4, dy=0);
//   %v4 = $SUPPLY @ATTACH &VREFP => @PLACE(16, 31.2);
//   &VREFP @WIRE {#MPA1:3 (16, 28) %v4:p};
//   %v5 = $SUPPLY @ATTACH &VREFP => @PLACE(19, 29.2);
//   &VREFP @WIRE {#MPA1:4 (19, 26) %v5:p};
//   #MNA1 @PLACE(16, 2);
//   #MNA1 @ORIENT("R0");
//   #MNA1:1 @TEXT("${net}", key="netname", size=0.6, halign="start", valign="middle", rotate=90, dx=0, dy=0.4);
//   #MNA1:2 @TEXT("${net}", key="netname", size=0.6, halign="end", valign="middle", dx=-0.4, dy=0);
//   #MNA1:3 @TEXT("${net}", key="netname", size=0.6, halign="end", valign="middle", rotate=90, dx=0, dy=-0.4);
//   %g6 = $GROUND @ATTACH &VSS => @PLACE(19, -1.2);
//   &VSS @WIRE {#MNA1:4 (19, 2) %g6:p};
//   #MPA2 @PLACE(32, 26);
//   #MPA2 @ORIENT("R0");
//   #MPA2:1 @TEXT("${net}", key="netname", size=0.6, halign="end", valign="middle", rotate=90, dx=0, dy=-0.4);
//   #MPA2:2 @TEXT("${net}", key="netname", size=0.6, halign="end", valign="middle", dx=-0.4, dy=0);
//   %v7 = $SUPPLY @ATTACH &VREFP => @PLACE(32, 31.2);
//   &VREFP @WIRE {#MPA2:3 (32, 28) %v7:p};
//   %v8 = $SUPPLY @ATTACH &VREFP => @PLACE(35, 29.2);
//   &VREFP @WIRE {#MPA2:4 (35, 26) %v8:p};
//   #MNA2 @PLACE(16, -8);
//   #MNA2 @ORIENT("R0");
//   #MNA2:1 @TEXT("${net}", key="netname", size=0.6, halign="start", valign="middle", rotate=90, dx=0, dy=0.4);
//   #MNA2:2 @TEXT("${net}", key="netname", size=0.6, halign="end", valign="middle", dx=-0.4, dy=0);
//   %g9 = $GROUND @ATTACH &VREFN => @PLACE(16, -13.2);
//   &VREFN @WIRE {#MNA2:3 (16, -10) %g9:p};
//   %g10 = $GROUND @ATTACH &VSS => @PLACE(19, -11.2);
//   &VSS @WIRE {#MNA2:4 (19, -8) %g10:p};
//   #MPB0 @PLACE(64, 26);
//   #MPB0 @ORIENT("R0");
//   #MPB0:1 @TEXT("${net}", key="netname", size=0.6, halign="end", valign="middle", rotate=90, dx=0, dy=-0.4);
//   #MPB0:2 @TEXT("${net}", key="netname", size=0.6, halign="end", valign="middle", dx=-0.4, dy=0);
//   %v11 = $SUPPLY @ATTACH &VREFP => @PLACE(64, 31.2);
//   &VREFP @WIRE {#MPB0:3 (64, 28) %v11:p};
//   %v12 = $SUPPLY @ATTACH &VREFP => @PLACE(67, 29.2);
//   &VREFP @WIRE {#MPB0:4 (67, 26) %v12:p};
//   #MNB0 @PLACE(48, -10);
//   #MNB0 @ORIENT("R0");
//   #MNB0:1 @TEXT("${net}", key="netname", size=0.6, halign="start", valign="middle", rotate=90, dx=0, dy=0.4);
//   #MNB0:2 @TEXT("${net}", key="netname", size=0.6, halign="end", valign="middle", dx=-0.4, dy=0);
//   %g13 = $GROUND @ATTACH &VREFN => @PLACE(48, -15.2);
//   &VREFN @WIRE {#MNB0:3 (48, -12) %g13:p};
//   %g14 = $GROUND @ATTACH &VSS => @PLACE(51, -13.2);
//   &VSS @WIRE {#MNB0:4 (51, -10) %g14:p};
//   #MPB1 @PLACE(64, 16);
//   #MPB1 @ORIENT("R0");
//   #MPB1:1 @TEXT("${net}", key="netname", size=0.6, halign="end", valign="middle", rotate=90, dx=0, dy=-0.4);
//   #MPB1:2 @TEXT("${net}", key="netname", size=0.6, halign="end", valign="middle", dx=-0.4, dy=0);
//   #MPB1:3 @TEXT("${net}", key="netname", size=0.6, halign="start", valign="middle", rotate=90, dx=0, dy=0.4);
//   %v15 = $SUPPLY @ATTACH &VREFP => @PLACE(67, 19.2);
//   &VREFP @WIRE {#MPB1:4 (67, 16) %v15:p};
//   #MNB1 @PLACE(64, -10);
//   #MNB1 @ORIENT("R0");
//   #MNB1:1 @TEXT("${net}", key="netname", size=0.6, halign="start", valign="middle", rotate=90, dx=0, dy=0.4);
//   #MNB1:2 @TEXT("${net}", key="netname", size=0.6, halign="end", valign="middle", dx=-0.4, dy=0);
//   %g16 = $GROUND @ATTACH &VREFN => @PLACE(64, -15.2);
//   &VREFN @WIRE {#MNB1:3 (64, -12) %g16:p};
//   %g17 = $GROUND @ATTACH &VSS => @PLACE(67, -13.2);
//   &VSS @WIRE {#MNB1:4 (67, -10) %g17:p};
//   #MPB2 @PLACE(64, 6);
//   #MPB2 @ORIENT("R0");
//   #MPB2:1 @TEXT("${net}", key="netname", size=0.6, halign="end", valign="middle", rotate=90, dx=0, dy=-0.4);
//   #MPB2:2 @TEXT("${net}", key="netname", size=0.6, halign="end", valign="middle", dx=-0.4, dy=0);
//   #MPB2:3 @TEXT("${net}", key="netname", size=0.6, halign="start", valign="middle", rotate=90, dx=0, dy=0.4);
//   %v18 = $SUPPLY @ATTACH &VREFP => @PLACE(67, 9.2);
//   &VREFP @WIRE {#MPB2:4 (67, 6) %v18:p};
//   #MNB2 @PLACE(80, -10);
//   #MNB2 @ORIENT("R0");
//   #MNB2:1 @TEXT("${net}", key="netname", size=0.6, halign="start", valign="middle", rotate=90, dx=0, dy=0.4);
//   #MNB2:2 @TEXT("${net}", key="netname", size=0.6, halign="end", valign="middle", dx=-0.4, dy=0);
//   %g19 = $GROUND @ATTACH &VREFN => @PLACE(80, -15.2);
//   &VREFN @WIRE {#MNB2:3 (80, -12) %g19:p};
//   %g20 = $GROUND @ATTACH &VSS => @PLACE(83, -13.2);
//   &VSS @WIRE {#MNB2:4 (83, -10) %g20:p};
//   #MFNN @PLACE(108, 12);
//   #MFNN @ORIENT("R0");
//   #MFNN:1 @TEXT("${net}", key="netname", size=0.6, halign="start", valign="middle", rotate=90, dx=0, dy=0.4);
//   #MFNN:2 @TEXT("${net}", key="netname", size=0.6, halign="end", valign="middle", dx=-0.4, dy=0);
//   %g21 = $GROUND @ATTACH &VREFN => @PLACE(108, 6.8);
//   &VREFN @WIRE {#MFNN:3 (108, 10) %g21:p};
//   %g22 = $GROUND @ATTACH &VSS => @PLACE(111, 8.8);
//   &VSS @WIRE {#MFNN:4 (111, 12) %g22:p};
//   #MFNP @PLACE(108, 22);
//   #MFNP @ORIENT("R0");
//   #MFNP:1 @TEXT("${net}", key="netname", size=0.6, halign="end", valign="middle", rotate=90, dx=0, dy=-0.4);
//   #MFNP:2 @TEXT("${net}", key="netname", size=0.6, halign="end", valign="middle", dx=-0.4, dy=0);
//   %v23 = $SUPPLY @ATTACH &VREFP => @PLACE(108, 27.2);
//   &VREFP @WIRE {#MFNP:3 (108, 24) %v23:p};
//   %v24 = $SUPPLY @ATTACH &VREFP => @PLACE(111, 25.2);
//   &VREFP @WIRE {#MFNP:4 (111, 22) %v24:p};
//   #MFPN @PLACE(136, 12);
//   #MFPN @ORIENT("R0");
//   #MFPN:1 @TEXT("${net}", key="netname", size=0.6, halign="start", valign="middle", rotate=90, dx=0, dy=0.4);
//   #MFPN:2 @TEXT("${net}", key="netname", size=0.6, halign="end", valign="middle", dx=-0.4, dy=0);
//   %g25 = $GROUND @ATTACH &VREFN => @PLACE(136, 6.8);
//   &VREFN @WIRE {#MFPN:3 (136, 10) %g25:p};
//   %g26 = $GROUND @ATTACH &VSS => @PLACE(139, 8.8);
//   &VSS @WIRE {#MFPN:4 (139, 12) %g26:p};
//   #MFPP @PLACE(136, 22);
//   #MFPP @ORIENT("R0");
//   #MFPP:1 @TEXT("${net}", key="netname", size=0.6, halign="end", valign="middle", rotate=90, dx=0, dy=-0.4);
//   #MFPP:2 @TEXT("${net}", key="netname", size=0.6, halign="end", valign="middle", dx=-0.4, dy=0);
//   %v27 = $SUPPLY @ATTACH &VREFP => @PLACE(136, 27.2);
//   &VREFP @WIRE {#MFPP:3 (136, 24) %v27:p};
//   %v28 = $SUPPLY @ATTACH &VREFP => @PLACE(139, 25.2);
//   &VREFP @WIRE {#MFPP:4 (139, 22) %v28:p};
//   #MNOUT @PLACE(168, 0);
//   #MNOUT @ORIENT("R0");
//   #MNOUT:1 @TEXT("${net}", key="netname", size=0.6, halign="start", valign="middle", rotate=90, dx=0, dy=0.4);
//   #MNOUT:2 @TEXT("${net}", key="netname", size=0.6, halign="end", valign="middle", dx=-0.4, dy=0);
//   %g29 = $GROUND @ATTACH &VREFN => @PLACE(168, -5.2);
//   &VREFN @WIRE {#MNOUT:3 (168, -2) %g29:p};
//   %g30 = $GROUND @ATTACH &VSS => @PLACE(171, -3.2);
//   &VSS @WIRE {#MNOUT:4 (171, 0) %g30:p};
//   #MPOUT @PLACE(168, 22);
//   #MPOUT @ORIENT("R0");
//   #MPOUT:1 @TEXT("${net}", key="netname", size=0.6, halign="end", valign="middle", rotate=90, dx=0, dy=-0.4);
//   #MPOUT:2 @TEXT("${net}", key="netname", size=0.6, halign="end", valign="middle", dx=-0.4, dy=0);
//   %v31 = $SUPPLY @ATTACH &VREFP => @PLACE(168, 27.2);
//   &VREFP @WIRE {#MPOUT:3 (168, 24) %v31:p};
//   %v32 = $SUPPLY @ATTACH &VREFP => @PLACE(171, 25.2);
//   &VREFP @WIRE {#MPOUT:4 (171, 22) %v32:p};
//   &NOFF @WIRE {#MFNN:1 #MFNP:1};
//   &GN @WIRE {#MFNN:2 (103, 12) (103, 22) #MFNP:2};
//   &PON @WIRE {#MFPN:1 #MFPP:1};
//   &GP @WIRE {#MFPN:2 (131, 12) (131, 22) #MFPP:2};
//   %gp_bus = (16, 22);
//   $JUNCTION @ATTACH %gp_bus;
//   &GP @WIRE {#MPA0:1 (0, 22) %gp_bus (32, 22) #MPA2:1};
//   &GP @WIRE {#MPA1:1 %gp_bus #MNA0:1};
//   &AN1 @WIRE {#MNA0:3 #MNA1:1};
//   &AN2 @WIRE {#MNA1:3 #MNA2:1};
//   &BP1 @WIRE {#MPB0:1 #MPB1:3};
//   &BP2 @WIRE {#MPB1:1 #MPB2:3};
//   %gn_bus = (64, -6);
//   $JUNCTION @ATTACH %gn_bus;
//   &GN @WIRE {#MNB0:1 (48, -6) %gn_bus (80, -6) #MNB2:1};
//   &GN @WIRE {#MNB1:1 %gn_bus #MPB2:1};
//   &BP @WIRE {#MNOUT:1 #MPOUT:1};
//   %p_hi = $IO_PORT @ATTACH &HI => @PLACE(9, 26) => @ORIENT("R0");
//   &HI @WIRE {%p_hi:p #MPA1:2};
//   %p_en = $IO_PORT @ATTACH &EN => @PLACE(-7, 26) => @ORIENT("R0");
//   &EN @WIRE {%p_en:p #MPA0:2};
//   %p_enb = $IO_PORT @ATTACH &ENB => @PLACE(57, 26) => @ORIENT("R0");
//   &ENB @WIRE {%p_enb:p #MPB0:2};
//   %p_bp = $IO_PORT @ATTACH &BP => @PLACE(168, 6) => @ORIENT("R270");
//   &BP @WIRE {%p_bp:p #MNOUT:1};
//   (-10, 48) @TEXT("Tristate nonoverlap driver j=9") => @SET-STYLE $title_style
// }
ends mq_cdac_drv9

// Matched half-capacitor pair j=9, weight 180
subckt mq_cdac_bit9 (DH RL EN ENB TOP VREFP VREFN VSS)
// CP*: user-specified pre-layout estimate, 5% of each physical MOM unit to VSS.
// The second MOM terminal is its bottom plate; parallel multipliers are aggregated.
// Series tails add one unit parasitic at MID and one at B, not 5% of the equivalent half unit.
XHCTL (DH HHI VREFP VREFN VSS) mq_cdac_ctl_h
XLCTL (RL LHI VREFP VREFN VSS) mq_cdac_ctl_l
XDH (HHI EN ENB BH VREFP VREFN VSS) mq_cdac_drv9
CH (TOP BH) cfmom_2t w=5e-08 s=2.4e-07 nr=6 lr=1.69e-06 stm=2 spm=4 multi=90
CPH (BH VSS) capacitor c=4.5103050e-15
XDL (LHI EN ENB BL VREFP VREFN VSS) mq_cdac_drv9
CL (TOP BL) cfmom_2t w=5e-08 s=2.4e-07 nr=6 lr=1.69e-06 stm=2 spm=4 multi=90
CPL (BL VSS) capacitor c=4.5103050e-15
// @RNL {
//   /* pins connected by net name: the net-name label of rnl-std-fill on every unwired pin, placed below by its key netname */
//   $LABEL_TERMINAL_SET @TEXT("${net}", key="netname", size=0.6);
//   &VSS @ADD-TO $GROUND_NET_SET; &VREFN @ADD-TO $GROUND_NET_SET; &VREFP @ADD-TO $SUPPLY_NET_SET;
//   {#CH #CL} @AS $MATCHED;
//   {#XDH #XDL} @AS $MATCHED;
//   #XHCTL @PLACE(-70, 24);
//   #XHCTL @ORIENT("R0");
//   #XHCTL:IN @TEXT("${net}", key="netname", size=0.6, halign="end", valign="middle", dx=-0.4, dy=0);
//   #XHCTL:HI @TEXT("${net}", key="netname", size=0.6, halign="start", valign="middle", dx=0.4, dy=0);
//   %v1 = $SUPPLY @ATTACH &VREFP => @PLACE(-70, 31.2);
//   &VREFP @WIRE {#XHCTL:VREFP (-70, 28) %v1:p};
//   %g2 = $GROUND @ATTACH &VREFN => @PLACE(-72, 16.8);
//   &VREFN @WIRE {#XHCTL:VREFN (-72, 20) %g2:p};
//   %g3 = $GROUND @ATTACH &VSS => @PLACE(-68, 16.8);
//   &VSS @WIRE {#XHCTL:VSS (-68, 20) %g3:p};
//   #XLCTL @PLACE(-70, -26);
//   #XLCTL @ORIENT("R0");
//   #XLCTL:IN @TEXT("${net}", key="netname", size=0.6, halign="end", valign="middle", dx=-0.4, dy=0);
//   #XLCTL:HI @TEXT("${net}", key="netname", size=0.6, halign="start", valign="middle", dx=0.4, dy=0);
//   %v4 = $SUPPLY @ATTACH &VREFP => @PLACE(-70, -18.8);
//   &VREFP @WIRE {#XLCTL:VREFP (-70, -22) %v4:p};
//   %g5 = $GROUND @ATTACH &VREFN => @PLACE(-72, -33.2);
//   &VREFN @WIRE {#XLCTL:VREFN (-72, -30) %g5:p};
//   %g6 = $GROUND @ATTACH &VSS => @PLACE(-68, -33.2);
//   &VSS @WIRE {#XLCTL:VSS (-68, -30) %g6:p};
//   #XDH @PLACE(-34, 24);
//   #XDH @ORIENT("R0");
//   #XDH:HI @TEXT("${net}", key="netname", size=0.6, halign="end", valign="middle", dx=-0.4, dy=0);
//   #XDH:EN @TEXT("${net}", key="netname", size=0.6, halign="end", valign="middle", dx=-0.4, dy=0);
//   #XDH:ENB @TEXT("${net}", key="netname", size=0.6, halign="end", valign="middle", dx=-0.4, dy=0);
//   #XDH:BP @TEXT("${net}", key="netname", size=0.6, halign="start", valign="middle", dx=0.4, dy=0);
//   %v7 = $SUPPLY @ATTACH &VREFP => @PLACE(-34, 32.2);
//   &VREFP @WIRE {#XDH:VREFP (-34, 29) %v7:p};
//   %g8 = $GROUND @ATTACH &VREFN => @PLACE(-36, 15.8);
//   &VREFN @WIRE {#XDH:VREFN (-36, 19) %g8:p};
//   %g9 = $GROUND @ATTACH &VSS => @PLACE(-32, 15.8);
//   &VSS @WIRE {#XDH:VSS (-32, 19) %g9:p};
//   #CH @PLACE(14, 24) => @ORIENT("R270");
//   #CH:1 @TEXT("${net}", key="netname", size=0.6, halign="start", valign="middle", dx=0.4, dy=0);
//   #CH:2 @TEXT("${net}", key="netname", size=0.6, halign="end", valign="middle", dx=-0.4, dy=0);
//   #CPH @PLACE(60, 20);
//   #CPH @ORIENT("R0");
//   #CPH:1 @TEXT("${net}", key="netname", size=0.6, halign="start", valign="middle", rotate=90, dx=0, dy=0.4);
//   %g10 = $GROUND @ATTACH &VSS => @PLACE(60, 14.8);
//   &VSS @WIRE {#CPH:2 (60, 18) %g10:p};
//   #XDL @PLACE(-34, -26);
//   #XDL @ORIENT("R0");
//   #XDL:HI @TEXT("${net}", key="netname", size=0.6, halign="end", valign="middle", dx=-0.4, dy=0);
//   #XDL:EN @TEXT("${net}", key="netname", size=0.6, halign="end", valign="middle", dx=-0.4, dy=0);
//   #XDL:ENB @TEXT("${net}", key="netname", size=0.6, halign="end", valign="middle", dx=-0.4, dy=0);
//   #XDL:BP @TEXT("${net}", key="netname", size=0.6, halign="start", valign="middle", dx=0.4, dy=0);
//   %v11 = $SUPPLY @ATTACH &VREFP => @PLACE(-34, -17.8);
//   &VREFP @WIRE {#XDL:VREFP (-34, -21) %v11:p};
//   %g12 = $GROUND @ATTACH &VREFN => @PLACE(-36, -34.2);
//   &VREFN @WIRE {#XDL:VREFN (-36, -31) %g12:p};
//   %g13 = $GROUND @ATTACH &VSS => @PLACE(-32, -34.2);
//   &VSS @WIRE {#XDL:VSS (-32, -31) %g13:p};
//   #CL @PLACE(14, -26) => @ORIENT("R270");
//   #CL:1 @TEXT("${net}", key="netname", size=0.6, halign="start", valign="middle", dx=0.4, dy=0);
//   #CL:2 @TEXT("${net}", key="netname", size=0.6, halign="end", valign="middle", dx=-0.4, dy=0);
//   #CPL @PLACE(60, -30);
//   #CPL @ORIENT("R0");
//   #CPL:1 @TEXT("${net}", key="netname", size=0.6, halign="start", valign="middle", rotate=90, dx=0, dy=0.4);
//   %g14 = $GROUND @ATTACH &VSS => @PLACE(60, -35.2);
//   &VSS @WIRE {#CPL:2 (60, -32) %g14:p};
//   &HHI @WIRE {#XHCTL:HI (-52, 24) (-52, 26) #XDH:HI};
//   %b_H = (-12, 24);
//   $JUNCTION @ATTACH %b_H;
//   &BH @WIRE {#XDH:BP %b_H};
//   &BH @WIRE {%b_H #CH:2};
//   &LHI @WIRE {#XLCTL:HI (-52, -26) (-52, -24) #XDL:HI};
//   %b_L = (-12, -26);
//   $JUNCTION @ATTACH %b_L;
//   &BL @WIRE {#XDL:BP %b_L};
//   &BL @WIRE {%b_L #CL:2};
//   %top_H = (44, 24);
//   $JUNCTION @ATTACH %top_H;
//   %top_L = (44, -26);
//   $JUNCTION @ATTACH %top_L;
//   &TOP @WIRE {#CH:1 %top_H};
//   &TOP @WIRE {#CL:1 %top_L};
//   &TOP @WIRE {%top_H %top_L};
//   %p_dh = $IO_PORT @ATTACH &DH => @PLACE(-81, 24) => @ORIENT("R0");
//   &DH @WIRE {%p_dh:p #XHCTL:IN};
//   %p_rl = $IO_PORT @ATTACH &RL => @PLACE(-81, -26) => @ORIENT("R0");
//   &RL @WIRE {%p_rl:p #XLCTL:IN};
//   %p_en = $IO_PORT @ATTACH &EN => @PLACE(-45, 24) => @ORIENT("R0");
//   &EN @WIRE {%p_en:p #XDH:EN};
//   %p_enb = $IO_PORT @ATTACH &ENB => @PLACE(-45, 22) => @ORIENT("R0");
//   &ENB @WIRE {%p_enb:p #XDH:ENB};
//   %p_top = $IO_PORT @ATTACH &TOP => @PLACE(20, 24) => @ORIENT("MY");
//   &TOP @WIRE {%p_top:p #CH:1};
//   (-10, 46) @TEXT("Matched half-capacitor pair j=9, weight 180") => @SET-STYLE $title_style
// }
ends mq_cdac_bit9

// Tristate nonoverlap driver j=8
subckt mq_cdac_drv8 (HI EN ENB BP VREFP VREFN VSS)
// GP = NAND(EN, HI, NOT(GN)); GN = NOR(ENB, HI, NOT(GP)).
// Feedback senses the opposite output-device gate; each turn-on waits for the opposite turn-off.
MPA0 (GP EN VREFP VREFP) pch_ulvt_mac w=4.15e-07 l=3e-08 nf=1
MNA0 (GP EN AN1 VSS) nch_ulvt_mac w=8.35e-07 l=3e-08 nf=1
MPA1 (GP HI VREFP VREFP) pch_ulvt_mac w=4.15e-07 l=3e-08 nf=1
MNA1 (AN1 HI AN2 VSS) nch_ulvt_mac w=8.35e-07 l=3e-08 nf=1
MPA2 (GP NOFF VREFP VREFP) pch_ulvt_mac w=4.15e-07 l=3e-08 nf=1
MNA2 (AN2 NOFF VREFN VSS) nch_ulvt_mac w=8.35e-07 l=3e-08 nf=1
MPB0 (BP1 ENB VREFP VREFP) pch_ulvt_mac w=1.25e-06 l=3e-08 nf=1
MNB0 (GN ENB VREFN VSS) nch_ulvt_mac w=4.15e-07 l=3e-08 nf=1
MPB1 (BP2 HI BP1 VREFP) pch_ulvt_mac w=1.25e-06 l=3e-08 nf=1
MNB1 (GN HI VREFN VSS) nch_ulvt_mac w=4.15e-07 l=3e-08 nf=1
MPB2 (GN PON BP2 VREFP) pch_ulvt_mac w=1.25e-06 l=3e-08 nf=1
MNB2 (GN PON VREFN VSS) nch_ulvt_mac w=4.15e-07 l=3e-08 nf=1
MFNN (NOFF GN VREFN VSS) nch_ulvt_mac w=4.15e-07 l=3e-08 nf=1
MFNP (NOFF GN VREFP VREFP) pch_ulvt_mac w=8.35e-07 l=3e-08 nf=1
MFPN (PON GP VREFN VSS) nch_ulvt_mac w=4.15e-07 l=3e-08 nf=1
MFPP (PON GP VREFP VREFP) pch_ulvt_mac w=8.35e-07 l=3e-08 nf=1
MNOUT (BP GN VREFN VSS) nch_ulvt_mac w=2.08e-06 l=3e-08 nf=2
MPOUT (BP GP VREFP VREFP) pch_ulvt_mac w=4.17e-06 l=3e-08 nf=3
// @RNL {
//   /* pins connected by net name: the net-name label of rnl-std-fill on every unwired pin, placed below by its key netname */
//   $LABEL_TERMINAL_SET @TEXT("${net}", key="netname", size=0.6);
//   &VSS @ADD-TO $GROUND_NET_SET; &VREFN @ADD-TO $GROUND_NET_SET; &VREFP @ADD-TO $SUPPLY_NET_SET;
//   {#MFNN #MFNP} @GROUP;
//   {#MFPN #MFPP} @GROUP;
//   {#MPA0 #MPA1 #MPA2 #MNA0 #MNA1 #MNA2} @GROUP;
//   {#MPB0 #MPB1 #MPB2 #MNB0 #MNB1 #MNB2} @GROUP;
//   {#MNOUT #MPOUT} @GROUP;
//   #MPA0 @PLACE(0, 26);
//   #MPA0 @ORIENT("R0");
//   #MPA0:1 @TEXT("${net}", key="netname", size=0.6, halign="end", valign="middle", rotate=90, dx=0, dy=-0.4);
//   #MPA0:2 @TEXT("${net}", key="netname", size=0.6, halign="end", valign="middle", dx=-0.4, dy=0);
//   %v1 = $SUPPLY @ATTACH &VREFP => @PLACE(0, 31.2);
//   &VREFP @WIRE {#MPA0:3 (0, 28) %v1:p};
//   %v2 = $SUPPLY @ATTACH &VREFP => @PLACE(3, 29.2);
//   &VREFP @WIRE {#MPA0:4 (3, 26) %v2:p};
//   #MNA0 @PLACE(16, 12);
//   #MNA0 @ORIENT("R0");
//   #MNA0:1 @TEXT("${net}", key="netname", size=0.6, halign="start", valign="middle", rotate=90, dx=0, dy=0.4);
//   #MNA0:2 @TEXT("${net}", key="netname", size=0.6, halign="end", valign="middle", dx=-0.4, dy=0);
//   #MNA0:3 @TEXT("${net}", key="netname", size=0.6, halign="end", valign="middle", rotate=90, dx=0, dy=-0.4);
//   %g3 = $GROUND @ATTACH &VSS => @PLACE(19, 8.8);
//   &VSS @WIRE {#MNA0:4 (19, 12) %g3:p};
//   #MPA1 @PLACE(16, 26);
//   #MPA1 @ORIENT("R0");
//   #MPA1:1 @TEXT("${net}", key="netname", size=0.6, halign="end", valign="middle", rotate=90, dx=0, dy=-0.4);
//   #MPA1:2 @TEXT("${net}", key="netname", size=0.6, halign="end", valign="middle", dx=-0.4, dy=0);
//   %v4 = $SUPPLY @ATTACH &VREFP => @PLACE(16, 31.2);
//   &VREFP @WIRE {#MPA1:3 (16, 28) %v4:p};
//   %v5 = $SUPPLY @ATTACH &VREFP => @PLACE(19, 29.2);
//   &VREFP @WIRE {#MPA1:4 (19, 26) %v5:p};
//   #MNA1 @PLACE(16, 2);
//   #MNA1 @ORIENT("R0");
//   #MNA1:1 @TEXT("${net}", key="netname", size=0.6, halign="start", valign="middle", rotate=90, dx=0, dy=0.4);
//   #MNA1:2 @TEXT("${net}", key="netname", size=0.6, halign="end", valign="middle", dx=-0.4, dy=0);
//   #MNA1:3 @TEXT("${net}", key="netname", size=0.6, halign="end", valign="middle", rotate=90, dx=0, dy=-0.4);
//   %g6 = $GROUND @ATTACH &VSS => @PLACE(19, -1.2);
//   &VSS @WIRE {#MNA1:4 (19, 2) %g6:p};
//   #MPA2 @PLACE(32, 26);
//   #MPA2 @ORIENT("R0");
//   #MPA2:1 @TEXT("${net}", key="netname", size=0.6, halign="end", valign="middle", rotate=90, dx=0, dy=-0.4);
//   #MPA2:2 @TEXT("${net}", key="netname", size=0.6, halign="end", valign="middle", dx=-0.4, dy=0);
//   %v7 = $SUPPLY @ATTACH &VREFP => @PLACE(32, 31.2);
//   &VREFP @WIRE {#MPA2:3 (32, 28) %v7:p};
//   %v8 = $SUPPLY @ATTACH &VREFP => @PLACE(35, 29.2);
//   &VREFP @WIRE {#MPA2:4 (35, 26) %v8:p};
//   #MNA2 @PLACE(16, -8);
//   #MNA2 @ORIENT("R0");
//   #MNA2:1 @TEXT("${net}", key="netname", size=0.6, halign="start", valign="middle", rotate=90, dx=0, dy=0.4);
//   #MNA2:2 @TEXT("${net}", key="netname", size=0.6, halign="end", valign="middle", dx=-0.4, dy=0);
//   %g9 = $GROUND @ATTACH &VREFN => @PLACE(16, -13.2);
//   &VREFN @WIRE {#MNA2:3 (16, -10) %g9:p};
//   %g10 = $GROUND @ATTACH &VSS => @PLACE(19, -11.2);
//   &VSS @WIRE {#MNA2:4 (19, -8) %g10:p};
//   #MPB0 @PLACE(64, 26);
//   #MPB0 @ORIENT("R0");
//   #MPB0:1 @TEXT("${net}", key="netname", size=0.6, halign="end", valign="middle", rotate=90, dx=0, dy=-0.4);
//   #MPB0:2 @TEXT("${net}", key="netname", size=0.6, halign="end", valign="middle", dx=-0.4, dy=0);
//   %v11 = $SUPPLY @ATTACH &VREFP => @PLACE(64, 31.2);
//   &VREFP @WIRE {#MPB0:3 (64, 28) %v11:p};
//   %v12 = $SUPPLY @ATTACH &VREFP => @PLACE(67, 29.2);
//   &VREFP @WIRE {#MPB0:4 (67, 26) %v12:p};
//   #MNB0 @PLACE(48, -10);
//   #MNB0 @ORIENT("R0");
//   #MNB0:1 @TEXT("${net}", key="netname", size=0.6, halign="start", valign="middle", rotate=90, dx=0, dy=0.4);
//   #MNB0:2 @TEXT("${net}", key="netname", size=0.6, halign="end", valign="middle", dx=-0.4, dy=0);
//   %g13 = $GROUND @ATTACH &VREFN => @PLACE(48, -15.2);
//   &VREFN @WIRE {#MNB0:3 (48, -12) %g13:p};
//   %g14 = $GROUND @ATTACH &VSS => @PLACE(51, -13.2);
//   &VSS @WIRE {#MNB0:4 (51, -10) %g14:p};
//   #MPB1 @PLACE(64, 16);
//   #MPB1 @ORIENT("R0");
//   #MPB1:1 @TEXT("${net}", key="netname", size=0.6, halign="end", valign="middle", rotate=90, dx=0, dy=-0.4);
//   #MPB1:2 @TEXT("${net}", key="netname", size=0.6, halign="end", valign="middle", dx=-0.4, dy=0);
//   #MPB1:3 @TEXT("${net}", key="netname", size=0.6, halign="start", valign="middle", rotate=90, dx=0, dy=0.4);
//   %v15 = $SUPPLY @ATTACH &VREFP => @PLACE(67, 19.2);
//   &VREFP @WIRE {#MPB1:4 (67, 16) %v15:p};
//   #MNB1 @PLACE(64, -10);
//   #MNB1 @ORIENT("R0");
//   #MNB1:1 @TEXT("${net}", key="netname", size=0.6, halign="start", valign="middle", rotate=90, dx=0, dy=0.4);
//   #MNB1:2 @TEXT("${net}", key="netname", size=0.6, halign="end", valign="middle", dx=-0.4, dy=0);
//   %g16 = $GROUND @ATTACH &VREFN => @PLACE(64, -15.2);
//   &VREFN @WIRE {#MNB1:3 (64, -12) %g16:p};
//   %g17 = $GROUND @ATTACH &VSS => @PLACE(67, -13.2);
//   &VSS @WIRE {#MNB1:4 (67, -10) %g17:p};
//   #MPB2 @PLACE(64, 6);
//   #MPB2 @ORIENT("R0");
//   #MPB2:1 @TEXT("${net}", key="netname", size=0.6, halign="end", valign="middle", rotate=90, dx=0, dy=-0.4);
//   #MPB2:2 @TEXT("${net}", key="netname", size=0.6, halign="end", valign="middle", dx=-0.4, dy=0);
//   #MPB2:3 @TEXT("${net}", key="netname", size=0.6, halign="start", valign="middle", rotate=90, dx=0, dy=0.4);
//   %v18 = $SUPPLY @ATTACH &VREFP => @PLACE(67, 9.2);
//   &VREFP @WIRE {#MPB2:4 (67, 6) %v18:p};
//   #MNB2 @PLACE(80, -10);
//   #MNB2 @ORIENT("R0");
//   #MNB2:1 @TEXT("${net}", key="netname", size=0.6, halign="start", valign="middle", rotate=90, dx=0, dy=0.4);
//   #MNB2:2 @TEXT("${net}", key="netname", size=0.6, halign="end", valign="middle", dx=-0.4, dy=0);
//   %g19 = $GROUND @ATTACH &VREFN => @PLACE(80, -15.2);
//   &VREFN @WIRE {#MNB2:3 (80, -12) %g19:p};
//   %g20 = $GROUND @ATTACH &VSS => @PLACE(83, -13.2);
//   &VSS @WIRE {#MNB2:4 (83, -10) %g20:p};
//   #MFNN @PLACE(108, 12);
//   #MFNN @ORIENT("R0");
//   #MFNN:1 @TEXT("${net}", key="netname", size=0.6, halign="start", valign="middle", rotate=90, dx=0, dy=0.4);
//   #MFNN:2 @TEXT("${net}", key="netname", size=0.6, halign="end", valign="middle", dx=-0.4, dy=0);
//   %g21 = $GROUND @ATTACH &VREFN => @PLACE(108, 6.8);
//   &VREFN @WIRE {#MFNN:3 (108, 10) %g21:p};
//   %g22 = $GROUND @ATTACH &VSS => @PLACE(111, 8.8);
//   &VSS @WIRE {#MFNN:4 (111, 12) %g22:p};
//   #MFNP @PLACE(108, 22);
//   #MFNP @ORIENT("R0");
//   #MFNP:1 @TEXT("${net}", key="netname", size=0.6, halign="end", valign="middle", rotate=90, dx=0, dy=-0.4);
//   #MFNP:2 @TEXT("${net}", key="netname", size=0.6, halign="end", valign="middle", dx=-0.4, dy=0);
//   %v23 = $SUPPLY @ATTACH &VREFP => @PLACE(108, 27.2);
//   &VREFP @WIRE {#MFNP:3 (108, 24) %v23:p};
//   %v24 = $SUPPLY @ATTACH &VREFP => @PLACE(111, 25.2);
//   &VREFP @WIRE {#MFNP:4 (111, 22) %v24:p};
//   #MFPN @PLACE(136, 12);
//   #MFPN @ORIENT("R0");
//   #MFPN:1 @TEXT("${net}", key="netname", size=0.6, halign="start", valign="middle", rotate=90, dx=0, dy=0.4);
//   #MFPN:2 @TEXT("${net}", key="netname", size=0.6, halign="end", valign="middle", dx=-0.4, dy=0);
//   %g25 = $GROUND @ATTACH &VREFN => @PLACE(136, 6.8);
//   &VREFN @WIRE {#MFPN:3 (136, 10) %g25:p};
//   %g26 = $GROUND @ATTACH &VSS => @PLACE(139, 8.8);
//   &VSS @WIRE {#MFPN:4 (139, 12) %g26:p};
//   #MFPP @PLACE(136, 22);
//   #MFPP @ORIENT("R0");
//   #MFPP:1 @TEXT("${net}", key="netname", size=0.6, halign="end", valign="middle", rotate=90, dx=0, dy=-0.4);
//   #MFPP:2 @TEXT("${net}", key="netname", size=0.6, halign="end", valign="middle", dx=-0.4, dy=0);
//   %v27 = $SUPPLY @ATTACH &VREFP => @PLACE(136, 27.2);
//   &VREFP @WIRE {#MFPP:3 (136, 24) %v27:p};
//   %v28 = $SUPPLY @ATTACH &VREFP => @PLACE(139, 25.2);
//   &VREFP @WIRE {#MFPP:4 (139, 22) %v28:p};
//   #MNOUT @PLACE(168, 0);
//   #MNOUT @ORIENT("R0");
//   #MNOUT:1 @TEXT("${net}", key="netname", size=0.6, halign="start", valign="middle", rotate=90, dx=0, dy=0.4);
//   #MNOUT:2 @TEXT("${net}", key="netname", size=0.6, halign="end", valign="middle", dx=-0.4, dy=0);
//   %g29 = $GROUND @ATTACH &VREFN => @PLACE(168, -5.2);
//   &VREFN @WIRE {#MNOUT:3 (168, -2) %g29:p};
//   %g30 = $GROUND @ATTACH &VSS => @PLACE(171, -3.2);
//   &VSS @WIRE {#MNOUT:4 (171, 0) %g30:p};
//   #MPOUT @PLACE(168, 22);
//   #MPOUT @ORIENT("R0");
//   #MPOUT:1 @TEXT("${net}", key="netname", size=0.6, halign="end", valign="middle", rotate=90, dx=0, dy=-0.4);
//   #MPOUT:2 @TEXT("${net}", key="netname", size=0.6, halign="end", valign="middle", dx=-0.4, dy=0);
//   %v31 = $SUPPLY @ATTACH &VREFP => @PLACE(168, 27.2);
//   &VREFP @WIRE {#MPOUT:3 (168, 24) %v31:p};
//   %v32 = $SUPPLY @ATTACH &VREFP => @PLACE(171, 25.2);
//   &VREFP @WIRE {#MPOUT:4 (171, 22) %v32:p};
//   &NOFF @WIRE {#MFNN:1 #MFNP:1};
//   &GN @WIRE {#MFNN:2 (103, 12) (103, 22) #MFNP:2};
//   &PON @WIRE {#MFPN:1 #MFPP:1};
//   &GP @WIRE {#MFPN:2 (131, 12) (131, 22) #MFPP:2};
//   %gp_bus = (16, 22);
//   $JUNCTION @ATTACH %gp_bus;
//   &GP @WIRE {#MPA0:1 (0, 22) %gp_bus (32, 22) #MPA2:1};
//   &GP @WIRE {#MPA1:1 %gp_bus #MNA0:1};
//   &AN1 @WIRE {#MNA0:3 #MNA1:1};
//   &AN2 @WIRE {#MNA1:3 #MNA2:1};
//   &BP1 @WIRE {#MPB0:1 #MPB1:3};
//   &BP2 @WIRE {#MPB1:1 #MPB2:3};
//   %gn_bus = (64, -6);
//   $JUNCTION @ATTACH %gn_bus;
//   &GN @WIRE {#MNB0:1 (48, -6) %gn_bus (80, -6) #MNB2:1};
//   &GN @WIRE {#MNB1:1 %gn_bus #MPB2:1};
//   &BP @WIRE {#MNOUT:1 #MPOUT:1};
//   %p_hi = $IO_PORT @ATTACH &HI => @PLACE(9, 26) => @ORIENT("R0");
//   &HI @WIRE {%p_hi:p #MPA1:2};
//   %p_en = $IO_PORT @ATTACH &EN => @PLACE(-7, 26) => @ORIENT("R0");
//   &EN @WIRE {%p_en:p #MPA0:2};
//   %p_enb = $IO_PORT @ATTACH &ENB => @PLACE(57, 26) => @ORIENT("R0");
//   &ENB @WIRE {%p_enb:p #MPB0:2};
//   %p_bp = $IO_PORT @ATTACH &BP => @PLACE(168, 6) => @ORIENT("R270");
//   &BP @WIRE {%p_bp:p #MNOUT:1};
//   (-10, 48) @TEXT("Tristate nonoverlap driver j=8") => @SET-STYLE $title_style
// }
ends mq_cdac_drv8

// Matched half-capacitor pair j=8, weight 102
subckt mq_cdac_bit8 (VIN VG DH RL EN ENB TOP VREFP VREFN VSS)
// CP*: user-specified pre-layout estimate, 5% of each physical MOM unit to VSS.
// The second MOM terminal is its bottom plate; parallel multipliers are aggregated.
// Series tails add one unit parasitic at MID and one at B, not 5% of the equivalent half unit.
XHCTL (DH HHI VREFP VREFN VSS) mq_cdac_ctl_h
XLCTL (RL LHI VREFP VREFN VSS) mq_cdac_ctl_l
XDH (HHI EN ENB BH VREFP VREFN VSS) mq_cdac_drv8
CH (TOP BH) cfmom_2t w=5e-08 s=2.4e-07 nr=6 lr=1.69e-06 stm=2 spm=4 multi=51
CPH (BH VSS) capacitor c=2.5558395e-15
MSH (BH VG VIN VSS) nch_ulvt_mac w=1.19e-06 l=3e-08 nf=1
XDL (LHI EN ENB BL VREFP VREFN VSS) mq_cdac_drv8
CL (TOP BL) cfmom_2t w=5e-08 s=2.4e-07 nr=6 lr=1.69e-06 stm=2 spm=4 multi=51
CPL (BL VSS) capacitor c=2.5558395e-15
MSL (BL VG VIN VSS) nch_ulvt_mac w=1.19e-06 l=3e-08 nf=1
// @RNL {
//   /* pins connected by net name: the net-name label of rnl-std-fill on every unwired pin, placed below by its key netname */
//   $LABEL_TERMINAL_SET @TEXT("${net}", key="netname", size=0.6);
//   &VSS @ADD-TO $GROUND_NET_SET; &VREFN @ADD-TO $GROUND_NET_SET; &VREFP @ADD-TO $SUPPLY_NET_SET;
//   {#CH #CL} @AS $MATCHED;
//   {#MSH #MSL} @AS $MATCHED;
//   {#XDH #XDL} @AS $MATCHED;
//   #XHCTL @PLACE(-70, 24);
//   #XHCTL @ORIENT("R0");
//   #XHCTL:IN @TEXT("${net}", key="netname", size=0.6, halign="end", valign="middle", dx=-0.4, dy=0);
//   #XHCTL:HI @TEXT("${net}", key="netname", size=0.6, halign="start", valign="middle", dx=0.4, dy=0);
//   %v1 = $SUPPLY @ATTACH &VREFP => @PLACE(-70, 31.2);
//   &VREFP @WIRE {#XHCTL:VREFP (-70, 28) %v1:p};
//   %g2 = $GROUND @ATTACH &VREFN => @PLACE(-72, 16.8);
//   &VREFN @WIRE {#XHCTL:VREFN (-72, 20) %g2:p};
//   %g3 = $GROUND @ATTACH &VSS => @PLACE(-68, 16.8);
//   &VSS @WIRE {#XHCTL:VSS (-68, 20) %g3:p};
//   #XLCTL @PLACE(-70, -26);
//   #XLCTL @ORIENT("R0");
//   #XLCTL:IN @TEXT("${net}", key="netname", size=0.6, halign="end", valign="middle", dx=-0.4, dy=0);
//   #XLCTL:HI @TEXT("${net}", key="netname", size=0.6, halign="start", valign="middle", dx=0.4, dy=0);
//   %v4 = $SUPPLY @ATTACH &VREFP => @PLACE(-70, -18.8);
//   &VREFP @WIRE {#XLCTL:VREFP (-70, -22) %v4:p};
//   %g5 = $GROUND @ATTACH &VREFN => @PLACE(-72, -33.2);
//   &VREFN @WIRE {#XLCTL:VREFN (-72, -30) %g5:p};
//   %g6 = $GROUND @ATTACH &VSS => @PLACE(-68, -33.2);
//   &VSS @WIRE {#XLCTL:VSS (-68, -30) %g6:p};
//   #XDH @PLACE(-34, 24);
//   #XDH @ORIENT("R0");
//   #XDH:HI @TEXT("${net}", key="netname", size=0.6, halign="end", valign="middle", dx=-0.4, dy=0);
//   #XDH:EN @TEXT("${net}", key="netname", size=0.6, halign="end", valign="middle", dx=-0.4, dy=0);
//   #XDH:ENB @TEXT("${net}", key="netname", size=0.6, halign="end", valign="middle", dx=-0.4, dy=0);
//   #XDH:BP @TEXT("${net}", key="netname", size=0.6, halign="start", valign="middle", dx=0.4, dy=0);
//   %v7 = $SUPPLY @ATTACH &VREFP => @PLACE(-34, 32.2);
//   &VREFP @WIRE {#XDH:VREFP (-34, 29) %v7:p};
//   %g8 = $GROUND @ATTACH &VREFN => @PLACE(-36, 15.8);
//   &VREFN @WIRE {#XDH:VREFN (-36, 19) %g8:p};
//   %g9 = $GROUND @ATTACH &VSS => @PLACE(-32, 15.8);
//   &VSS @WIRE {#XDH:VSS (-32, 19) %g9:p};
//   #CH @PLACE(14, 24) => @ORIENT("R270");
//   #CH:1 @TEXT("${net}", key="netname", size=0.6, halign="start", valign="middle", dx=0.4, dy=0);
//   #CH:2 @TEXT("${net}", key="netname", size=0.6, halign="end", valign="middle", dx=-0.4, dy=0);
//   #CPH @PLACE(60, 20);
//   #CPH @ORIENT("R0");
//   #CPH:1 @TEXT("${net}", key="netname", size=0.6, halign="start", valign="middle", rotate=90, dx=0, dy=0.4);
//   %g10 = $GROUND @ATTACH &VSS => @PLACE(60, 14.8);
//   &VSS @WIRE {#CPH:2 (60, 18) %g10:p};
//   #MSH @PLACE(2, 8);
//   #MSH @ORIENT("R0");
//   #MSH:1 @TEXT("${net}", key="netname", size=0.6, halign="start", valign="middle", rotate=90, dx=0, dy=0.4);
//   #MSH:2 @TEXT("${net}", key="netname", size=0.6, halign="end", valign="middle", dx=-0.4, dy=0);
//   #MSH:3 @TEXT("${net}", key="netname", size=0.6, halign="end", valign="middle", rotate=90, dx=0, dy=-0.4);
//   %g11 = $GROUND @ATTACH &VSS => @PLACE(5, 4.8);
//   &VSS @WIRE {#MSH:4 (5, 8) %g11:p};
//   #XDL @PLACE(-34, -26);
//   #XDL @ORIENT("R0");
//   #XDL:HI @TEXT("${net}", key="netname", size=0.6, halign="end", valign="middle", dx=-0.4, dy=0);
//   #XDL:EN @TEXT("${net}", key="netname", size=0.6, halign="end", valign="middle", dx=-0.4, dy=0);
//   #XDL:ENB @TEXT("${net}", key="netname", size=0.6, halign="end", valign="middle", dx=-0.4, dy=0);
//   #XDL:BP @TEXT("${net}", key="netname", size=0.6, halign="start", valign="middle", dx=0.4, dy=0);
//   %v12 = $SUPPLY @ATTACH &VREFP => @PLACE(-34, -17.8);
//   &VREFP @WIRE {#XDL:VREFP (-34, -21) %v12:p};
//   %g13 = $GROUND @ATTACH &VREFN => @PLACE(-36, -34.2);
//   &VREFN @WIRE {#XDL:VREFN (-36, -31) %g13:p};
//   %g14 = $GROUND @ATTACH &VSS => @PLACE(-32, -34.2);
//   &VSS @WIRE {#XDL:VSS (-32, -31) %g14:p};
//   #CL @PLACE(14, -26) => @ORIENT("R270");
//   #CL:1 @TEXT("${net}", key="netname", size=0.6, halign="start", valign="middle", dx=0.4, dy=0);
//   #CL:2 @TEXT("${net}", key="netname", size=0.6, halign="end", valign="middle", dx=-0.4, dy=0);
//   #CPL @PLACE(60, -30);
//   #CPL @ORIENT("R0");
//   #CPL:1 @TEXT("${net}", key="netname", size=0.6, halign="start", valign="middle", rotate=90, dx=0, dy=0.4);
//   %g15 = $GROUND @ATTACH &VSS => @PLACE(60, -35.2);
//   &VSS @WIRE {#CPL:2 (60, -32) %g15:p};
//   #MSL @PLACE(2, -42);
//   #MSL @ORIENT("R0");
//   #MSL:1 @TEXT("${net}", key="netname", size=0.6, halign="start", valign="middle", rotate=90, dx=0, dy=0.4);
//   #MSL:2 @TEXT("${net}", key="netname", size=0.6, halign="end", valign="middle", dx=-0.4, dy=0);
//   #MSL:3 @TEXT("${net}", key="netname", size=0.6, halign="end", valign="middle", rotate=90, dx=0, dy=-0.4);
//   %g16 = $GROUND @ATTACH &VSS => @PLACE(5, -45.2);
//   &VSS @WIRE {#MSL:4 (5, -42) %g16:p};
//   &HHI @WIRE {#XHCTL:HI (-52, 24) (-52, 26) #XDH:HI};
//   %b_H = (-12, 24);
//   $JUNCTION @ATTACH %b_H;
//   &BH @WIRE {#XDH:BP %b_H};
//   &BH @WIRE {%b_H #CH:2};
//   &BH @WIRE {%b_H (-12, 10) #MSH:1};
//   &LHI @WIRE {#XLCTL:HI (-52, -26) (-52, -24) #XDL:HI};
//   %b_L = (-12, -26);
//   $JUNCTION @ATTACH %b_L;
//   &BL @WIRE {#XDL:BP %b_L};
//   &BL @WIRE {%b_L #CL:2};
//   &BL @WIRE {%b_L (-12, -40) #MSL:1};
//   &VIN @WIRE {#MSH:3 (6, 6) (6, -44) #MSL:3};
//   &VG @WIRE {#MSH:2 (-5, 8) (-5, -42) #MSL:2};
//   %top_H = (44, 24);
//   $JUNCTION @ATTACH %top_H;
//   %top_L = (44, -26);
//   $JUNCTION @ATTACH %top_L;
//   &TOP @WIRE {#CH:1 %top_H};
//   &TOP @WIRE {#CL:1 %top_L};
//   &TOP @WIRE {%top_H %top_L};
//   %p_vin = $IO_PORT @ATTACH &VIN => @PLACE(2, 2) => @ORIENT("R90");
//   &VIN @WIRE {%p_vin:p #MSH:3};
//   %p_vg = $IO_PORT @ATTACH &VG => @PLACE(-5, 8) => @ORIENT("R0");
//   &VG @WIRE {%p_vg:p #MSH:2};
//   %p_dh = $IO_PORT @ATTACH &DH => @PLACE(-81, 24) => @ORIENT("R0");
//   &DH @WIRE {%p_dh:p #XHCTL:IN};
//   %p_rl = $IO_PORT @ATTACH &RL => @PLACE(-81, -26) => @ORIENT("R0");
//   &RL @WIRE {%p_rl:p #XLCTL:IN};
//   %p_en = $IO_PORT @ATTACH &EN => @PLACE(-45, 24) => @ORIENT("R0");
//   &EN @WIRE {%p_en:p #XDH:EN};
//   %p_enb = $IO_PORT @ATTACH &ENB => @PLACE(-45, 22) => @ORIENT("R0");
//   &ENB @WIRE {%p_enb:p #XDH:ENB};
//   %p_top = $IO_PORT @ATTACH &TOP => @PLACE(20, 24) => @ORIENT("MY");
//   &TOP @WIRE {%p_top:p #CH:1};
//   (-10, 46) @TEXT("Matched half-capacitor pair j=8, weight 102") => @SET-STYLE $title_style
// }
ends mq_cdac_bit8

// Tristate nonoverlap driver j=7
subckt mq_cdac_drv7 (HI EN ENB BP VREFP VREFN VSS)
// GP = NAND(EN, HI, NOT(GN)); GN = NOR(ENB, HI, NOT(GP)).
// Feedback senses the opposite output-device gate; each turn-on waits for the opposite turn-off.
MPA0 (GP EN VREFP VREFP) pch_ulvt_mac w=2.35e-07 l=3e-08 nf=1
MNA0 (GP EN AN1 VSS) nch_ulvt_mac w=4.65e-07 l=3e-08 nf=1
MPA1 (GP HI VREFP VREFP) pch_ulvt_mac w=2.35e-07 l=3e-08 nf=1
MNA1 (AN1 HI AN2 VSS) nch_ulvt_mac w=4.65e-07 l=3e-08 nf=1
MPA2 (GP NOFF VREFP VREFP) pch_ulvt_mac w=2.35e-07 l=3e-08 nf=1
MNA2 (AN2 NOFF VREFN VSS) nch_ulvt_mac w=4.65e-07 l=3e-08 nf=1
MPB0 (BP1 ENB VREFP VREFP) pch_ulvt_mac w=7e-07 l=3e-08 nf=1
MNB0 (GN ENB VREFN VSS) nch_ulvt_mac w=2.35e-07 l=3e-08 nf=1
MPB1 (BP2 HI BP1 VREFP) pch_ulvt_mac w=7e-07 l=3e-08 nf=1
MNB1 (GN HI VREFN VSS) nch_ulvt_mac w=2.35e-07 l=3e-08 nf=1
MPB2 (GN PON BP2 VREFP) pch_ulvt_mac w=7e-07 l=3e-08 nf=1
MNB2 (GN PON VREFN VSS) nch_ulvt_mac w=2.35e-07 l=3e-08 nf=1
MFNN (NOFF GN VREFN VSS) nch_ulvt_mac w=2.35e-07 l=3e-08 nf=1
MFNP (NOFF GN VREFP VREFP) pch_ulvt_mac w=4.65e-07 l=3e-08 nf=1
MFPN (PON GP VREFN VSS) nch_ulvt_mac w=2.35e-07 l=3e-08 nf=1
MFPP (PON GP VREFP VREFP) pch_ulvt_mac w=4.65e-07 l=3e-08 nf=1
MNOUT (BP GN VREFN VSS) nch_ulvt_mac w=1.165e-06 l=3e-08 nf=1
MPOUT (BP GP VREFP VREFP) pch_ulvt_mac w=2.33e-06 l=3e-08 nf=2
// @RNL {
//   /* pins connected by net name: the net-name label of rnl-std-fill on every unwired pin, placed below by its key netname */
//   $LABEL_TERMINAL_SET @TEXT("${net}", key="netname", size=0.6);
//   &VSS @ADD-TO $GROUND_NET_SET; &VREFN @ADD-TO $GROUND_NET_SET; &VREFP @ADD-TO $SUPPLY_NET_SET;
//   {#MFNN #MFNP} @GROUP;
//   {#MFPN #MFPP} @GROUP;
//   {#MPA0 #MPA1 #MPA2 #MNA0 #MNA1 #MNA2} @GROUP;
//   {#MPB0 #MPB1 #MPB2 #MNB0 #MNB1 #MNB2} @GROUP;
//   {#MNOUT #MPOUT} @GROUP;
//   #MPA0 @PLACE(0, 26);
//   #MPA0 @ORIENT("R0");
//   #MPA0:1 @TEXT("${net}", key="netname", size=0.6, halign="end", valign="middle", rotate=90, dx=0, dy=-0.4);
//   #MPA0:2 @TEXT("${net}", key="netname", size=0.6, halign="end", valign="middle", dx=-0.4, dy=0);
//   %v1 = $SUPPLY @ATTACH &VREFP => @PLACE(0, 31.2);
//   &VREFP @WIRE {#MPA0:3 (0, 28) %v1:p};
//   %v2 = $SUPPLY @ATTACH &VREFP => @PLACE(3, 29.2);
//   &VREFP @WIRE {#MPA0:4 (3, 26) %v2:p};
//   #MNA0 @PLACE(16, 12);
//   #MNA0 @ORIENT("R0");
//   #MNA0:1 @TEXT("${net}", key="netname", size=0.6, halign="start", valign="middle", rotate=90, dx=0, dy=0.4);
//   #MNA0:2 @TEXT("${net}", key="netname", size=0.6, halign="end", valign="middle", dx=-0.4, dy=0);
//   #MNA0:3 @TEXT("${net}", key="netname", size=0.6, halign="end", valign="middle", rotate=90, dx=0, dy=-0.4);
//   %g3 = $GROUND @ATTACH &VSS => @PLACE(19, 8.8);
//   &VSS @WIRE {#MNA0:4 (19, 12) %g3:p};
//   #MPA1 @PLACE(16, 26);
//   #MPA1 @ORIENT("R0");
//   #MPA1:1 @TEXT("${net}", key="netname", size=0.6, halign="end", valign="middle", rotate=90, dx=0, dy=-0.4);
//   #MPA1:2 @TEXT("${net}", key="netname", size=0.6, halign="end", valign="middle", dx=-0.4, dy=0);
//   %v4 = $SUPPLY @ATTACH &VREFP => @PLACE(16, 31.2);
//   &VREFP @WIRE {#MPA1:3 (16, 28) %v4:p};
//   %v5 = $SUPPLY @ATTACH &VREFP => @PLACE(19, 29.2);
//   &VREFP @WIRE {#MPA1:4 (19, 26) %v5:p};
//   #MNA1 @PLACE(16, 2);
//   #MNA1 @ORIENT("R0");
//   #MNA1:1 @TEXT("${net}", key="netname", size=0.6, halign="start", valign="middle", rotate=90, dx=0, dy=0.4);
//   #MNA1:2 @TEXT("${net}", key="netname", size=0.6, halign="end", valign="middle", dx=-0.4, dy=0);
//   #MNA1:3 @TEXT("${net}", key="netname", size=0.6, halign="end", valign="middle", rotate=90, dx=0, dy=-0.4);
//   %g6 = $GROUND @ATTACH &VSS => @PLACE(19, -1.2);
//   &VSS @WIRE {#MNA1:4 (19, 2) %g6:p};
//   #MPA2 @PLACE(32, 26);
//   #MPA2 @ORIENT("R0");
//   #MPA2:1 @TEXT("${net}", key="netname", size=0.6, halign="end", valign="middle", rotate=90, dx=0, dy=-0.4);
//   #MPA2:2 @TEXT("${net}", key="netname", size=0.6, halign="end", valign="middle", dx=-0.4, dy=0);
//   %v7 = $SUPPLY @ATTACH &VREFP => @PLACE(32, 31.2);
//   &VREFP @WIRE {#MPA2:3 (32, 28) %v7:p};
//   %v8 = $SUPPLY @ATTACH &VREFP => @PLACE(35, 29.2);
//   &VREFP @WIRE {#MPA2:4 (35, 26) %v8:p};
//   #MNA2 @PLACE(16, -8);
//   #MNA2 @ORIENT("R0");
//   #MNA2:1 @TEXT("${net}", key="netname", size=0.6, halign="start", valign="middle", rotate=90, dx=0, dy=0.4);
//   #MNA2:2 @TEXT("${net}", key="netname", size=0.6, halign="end", valign="middle", dx=-0.4, dy=0);
//   %g9 = $GROUND @ATTACH &VREFN => @PLACE(16, -13.2);
//   &VREFN @WIRE {#MNA2:3 (16, -10) %g9:p};
//   %g10 = $GROUND @ATTACH &VSS => @PLACE(19, -11.2);
//   &VSS @WIRE {#MNA2:4 (19, -8) %g10:p};
//   #MPB0 @PLACE(64, 26);
//   #MPB0 @ORIENT("R0");
//   #MPB0:1 @TEXT("${net}", key="netname", size=0.6, halign="end", valign="middle", rotate=90, dx=0, dy=-0.4);
//   #MPB0:2 @TEXT("${net}", key="netname", size=0.6, halign="end", valign="middle", dx=-0.4, dy=0);
//   %v11 = $SUPPLY @ATTACH &VREFP => @PLACE(64, 31.2);
//   &VREFP @WIRE {#MPB0:3 (64, 28) %v11:p};
//   %v12 = $SUPPLY @ATTACH &VREFP => @PLACE(67, 29.2);
//   &VREFP @WIRE {#MPB0:4 (67, 26) %v12:p};
//   #MNB0 @PLACE(48, -10);
//   #MNB0 @ORIENT("R0");
//   #MNB0:1 @TEXT("${net}", key="netname", size=0.6, halign="start", valign="middle", rotate=90, dx=0, dy=0.4);
//   #MNB0:2 @TEXT("${net}", key="netname", size=0.6, halign="end", valign="middle", dx=-0.4, dy=0);
//   %g13 = $GROUND @ATTACH &VREFN => @PLACE(48, -15.2);
//   &VREFN @WIRE {#MNB0:3 (48, -12) %g13:p};
//   %g14 = $GROUND @ATTACH &VSS => @PLACE(51, -13.2);
//   &VSS @WIRE {#MNB0:4 (51, -10) %g14:p};
//   #MPB1 @PLACE(64, 16);
//   #MPB1 @ORIENT("R0");
//   #MPB1:1 @TEXT("${net}", key="netname", size=0.6, halign="end", valign="middle", rotate=90, dx=0, dy=-0.4);
//   #MPB1:2 @TEXT("${net}", key="netname", size=0.6, halign="end", valign="middle", dx=-0.4, dy=0);
//   #MPB1:3 @TEXT("${net}", key="netname", size=0.6, halign="start", valign="middle", rotate=90, dx=0, dy=0.4);
//   %v15 = $SUPPLY @ATTACH &VREFP => @PLACE(67, 19.2);
//   &VREFP @WIRE {#MPB1:4 (67, 16) %v15:p};
//   #MNB1 @PLACE(64, -10);
//   #MNB1 @ORIENT("R0");
//   #MNB1:1 @TEXT("${net}", key="netname", size=0.6, halign="start", valign="middle", rotate=90, dx=0, dy=0.4);
//   #MNB1:2 @TEXT("${net}", key="netname", size=0.6, halign="end", valign="middle", dx=-0.4, dy=0);
//   %g16 = $GROUND @ATTACH &VREFN => @PLACE(64, -15.2);
//   &VREFN @WIRE {#MNB1:3 (64, -12) %g16:p};
//   %g17 = $GROUND @ATTACH &VSS => @PLACE(67, -13.2);
//   &VSS @WIRE {#MNB1:4 (67, -10) %g17:p};
//   #MPB2 @PLACE(64, 6);
//   #MPB2 @ORIENT("R0");
//   #MPB2:1 @TEXT("${net}", key="netname", size=0.6, halign="end", valign="middle", rotate=90, dx=0, dy=-0.4);
//   #MPB2:2 @TEXT("${net}", key="netname", size=0.6, halign="end", valign="middle", dx=-0.4, dy=0);
//   #MPB2:3 @TEXT("${net}", key="netname", size=0.6, halign="start", valign="middle", rotate=90, dx=0, dy=0.4);
//   %v18 = $SUPPLY @ATTACH &VREFP => @PLACE(67, 9.2);
//   &VREFP @WIRE {#MPB2:4 (67, 6) %v18:p};
//   #MNB2 @PLACE(80, -10);
//   #MNB2 @ORIENT("R0");
//   #MNB2:1 @TEXT("${net}", key="netname", size=0.6, halign="start", valign="middle", rotate=90, dx=0, dy=0.4);
//   #MNB2:2 @TEXT("${net}", key="netname", size=0.6, halign="end", valign="middle", dx=-0.4, dy=0);
//   %g19 = $GROUND @ATTACH &VREFN => @PLACE(80, -15.2);
//   &VREFN @WIRE {#MNB2:3 (80, -12) %g19:p};
//   %g20 = $GROUND @ATTACH &VSS => @PLACE(83, -13.2);
//   &VSS @WIRE {#MNB2:4 (83, -10) %g20:p};
//   #MFNN @PLACE(108, 12);
//   #MFNN @ORIENT("R0");
//   #MFNN:1 @TEXT("${net}", key="netname", size=0.6, halign="start", valign="middle", rotate=90, dx=0, dy=0.4);
//   #MFNN:2 @TEXT("${net}", key="netname", size=0.6, halign="end", valign="middle", dx=-0.4, dy=0);
//   %g21 = $GROUND @ATTACH &VREFN => @PLACE(108, 6.8);
//   &VREFN @WIRE {#MFNN:3 (108, 10) %g21:p};
//   %g22 = $GROUND @ATTACH &VSS => @PLACE(111, 8.8);
//   &VSS @WIRE {#MFNN:4 (111, 12) %g22:p};
//   #MFNP @PLACE(108, 22);
//   #MFNP @ORIENT("R0");
//   #MFNP:1 @TEXT("${net}", key="netname", size=0.6, halign="end", valign="middle", rotate=90, dx=0, dy=-0.4);
//   #MFNP:2 @TEXT("${net}", key="netname", size=0.6, halign="end", valign="middle", dx=-0.4, dy=0);
//   %v23 = $SUPPLY @ATTACH &VREFP => @PLACE(108, 27.2);
//   &VREFP @WIRE {#MFNP:3 (108, 24) %v23:p};
//   %v24 = $SUPPLY @ATTACH &VREFP => @PLACE(111, 25.2);
//   &VREFP @WIRE {#MFNP:4 (111, 22) %v24:p};
//   #MFPN @PLACE(136, 12);
//   #MFPN @ORIENT("R0");
//   #MFPN:1 @TEXT("${net}", key="netname", size=0.6, halign="start", valign="middle", rotate=90, dx=0, dy=0.4);
//   #MFPN:2 @TEXT("${net}", key="netname", size=0.6, halign="end", valign="middle", dx=-0.4, dy=0);
//   %g25 = $GROUND @ATTACH &VREFN => @PLACE(136, 6.8);
//   &VREFN @WIRE {#MFPN:3 (136, 10) %g25:p};
//   %g26 = $GROUND @ATTACH &VSS => @PLACE(139, 8.8);
//   &VSS @WIRE {#MFPN:4 (139, 12) %g26:p};
//   #MFPP @PLACE(136, 22);
//   #MFPP @ORIENT("R0");
//   #MFPP:1 @TEXT("${net}", key="netname", size=0.6, halign="end", valign="middle", rotate=90, dx=0, dy=-0.4);
//   #MFPP:2 @TEXT("${net}", key="netname", size=0.6, halign="end", valign="middle", dx=-0.4, dy=0);
//   %v27 = $SUPPLY @ATTACH &VREFP => @PLACE(136, 27.2);
//   &VREFP @WIRE {#MFPP:3 (136, 24) %v27:p};
//   %v28 = $SUPPLY @ATTACH &VREFP => @PLACE(139, 25.2);
//   &VREFP @WIRE {#MFPP:4 (139, 22) %v28:p};
//   #MNOUT @PLACE(168, 0);
//   #MNOUT @ORIENT("R0");
//   #MNOUT:1 @TEXT("${net}", key="netname", size=0.6, halign="start", valign="middle", rotate=90, dx=0, dy=0.4);
//   #MNOUT:2 @TEXT("${net}", key="netname", size=0.6, halign="end", valign="middle", dx=-0.4, dy=0);
//   %g29 = $GROUND @ATTACH &VREFN => @PLACE(168, -5.2);
//   &VREFN @WIRE {#MNOUT:3 (168, -2) %g29:p};
//   %g30 = $GROUND @ATTACH &VSS => @PLACE(171, -3.2);
//   &VSS @WIRE {#MNOUT:4 (171, 0) %g30:p};
//   #MPOUT @PLACE(168, 22);
//   #MPOUT @ORIENT("R0");
//   #MPOUT:1 @TEXT("${net}", key="netname", size=0.6, halign="end", valign="middle", rotate=90, dx=0, dy=-0.4);
//   #MPOUT:2 @TEXT("${net}", key="netname", size=0.6, halign="end", valign="middle", dx=-0.4, dy=0);
//   %v31 = $SUPPLY @ATTACH &VREFP => @PLACE(168, 27.2);
//   &VREFP @WIRE {#MPOUT:3 (168, 24) %v31:p};
//   %v32 = $SUPPLY @ATTACH &VREFP => @PLACE(171, 25.2);
//   &VREFP @WIRE {#MPOUT:4 (171, 22) %v32:p};
//   &NOFF @WIRE {#MFNN:1 #MFNP:1};
//   &GN @WIRE {#MFNN:2 (103, 12) (103, 22) #MFNP:2};
//   &PON @WIRE {#MFPN:1 #MFPP:1};
//   &GP @WIRE {#MFPN:2 (131, 12) (131, 22) #MFPP:2};
//   %gp_bus = (16, 22);
//   $JUNCTION @ATTACH %gp_bus;
//   &GP @WIRE {#MPA0:1 (0, 22) %gp_bus (32, 22) #MPA2:1};
//   &GP @WIRE {#MPA1:1 %gp_bus #MNA0:1};
//   &AN1 @WIRE {#MNA0:3 #MNA1:1};
//   &AN2 @WIRE {#MNA1:3 #MNA2:1};
//   &BP1 @WIRE {#MPB0:1 #MPB1:3};
//   &BP2 @WIRE {#MPB1:1 #MPB2:3};
//   %gn_bus = (64, -6);
//   $JUNCTION @ATTACH %gn_bus;
//   &GN @WIRE {#MNB0:1 (48, -6) %gn_bus (80, -6) #MNB2:1};
//   &GN @WIRE {#MNB1:1 %gn_bus #MPB2:1};
//   &BP @WIRE {#MNOUT:1 #MPOUT:1};
//   %p_hi = $IO_PORT @ATTACH &HI => @PLACE(9, 26) => @ORIENT("R0");
//   &HI @WIRE {%p_hi:p #MPA1:2};
//   %p_en = $IO_PORT @ATTACH &EN => @PLACE(-7, 26) => @ORIENT("R0");
//   &EN @WIRE {%p_en:p #MPA0:2};
//   %p_enb = $IO_PORT @ATTACH &ENB => @PLACE(57, 26) => @ORIENT("R0");
//   &ENB @WIRE {%p_enb:p #MPB0:2};
//   %p_bp = $IO_PORT @ATTACH &BP => @PLACE(168, 6) => @ORIENT("R270");
//   &BP @WIRE {%p_bp:p #MNOUT:1};
//   (-10, 48) @TEXT("Tristate nonoverlap driver j=7") => @SET-STYLE $title_style
// }
ends mq_cdac_drv7

// Matched half-capacitor pair j=7, weight 57
subckt mq_cdac_bit7 (VIN VG DH RL EN ENB TOP VREFP VREFN VSS)
// CP*: user-specified pre-layout estimate, 5% of each physical MOM unit to VSS.
// The second MOM terminal is its bottom plate; parallel multipliers are aggregated.
// Series tails add one unit parasitic at MID and one at B, not 5% of the equivalent half unit.
XHCTL (DH HHI VREFP VREFN VSS) mq_cdac_ctl_h
XLCTL (RL LHI VREFP VREFN VSS) mq_cdac_ctl_l
XDH (HHI EN ENB BH VREFP VREFN VSS) mq_cdac_drv7
CH (TOP BH) cfmom_2t w=5e-08 s=2.4e-07 nr=6 lr=1.69e-06 stm=2 spm=4 multi=28
CPH (BH VSS) capacitor c=1.4032060e-15
CHA (TOP MIDH) cfmom_2t w=5e-08 s=2.4e-07 nr=6 lr=1.69e-06 stm=2 spm=4 multi=1
CPHA (MIDH VSS) capacitor c=5.01145e-17
CHB (MIDH BH) cfmom_2t w=5e-08 s=2.4e-07 nr=6 lr=1.69e-06 stm=2 spm=4 multi=1
CPHB (BH VSS) capacitor c=5.01145e-17
MSH (BH VG VIN VSS) nch_ulvt_mac w=6.65e-07 l=3e-08 nf=1
XDL (LHI EN ENB BL VREFP VREFN VSS) mq_cdac_drv7
CL (TOP BL) cfmom_2t w=5e-08 s=2.4e-07 nr=6 lr=1.69e-06 stm=2 spm=4 multi=28
CPL (BL VSS) capacitor c=1.4032060e-15
CLA (TOP MIDL) cfmom_2t w=5e-08 s=2.4e-07 nr=6 lr=1.69e-06 stm=2 spm=4 multi=1
CPLA (MIDL VSS) capacitor c=5.01145e-17
CLB (MIDL BL) cfmom_2t w=5e-08 s=2.4e-07 nr=6 lr=1.69e-06 stm=2 spm=4 multi=1
CPLB (BL VSS) capacitor c=5.01145e-17
MSL (BL VG VIN VSS) nch_ulvt_mac w=6.65e-07 l=3e-08 nf=1
// @RNL {
//   /* pins connected by net name: the net-name label of rnl-std-fill on every unwired pin, placed below by its key netname */
//   $LABEL_TERMINAL_SET @TEXT("${net}", key="netname", size=0.6);
//   &VSS @ADD-TO $GROUND_NET_SET; &VREFN @ADD-TO $GROUND_NET_SET; &VREFP @ADD-TO $SUPPLY_NET_SET;
//   {#CH #CL} @AS $MATCHED;
//   {#CHA #CHB #CLA #CLB} @AS $MATCHED;
//   {#CHA #CHB #CLA #CLB} @GROUP;
//   {#MSH #MSL} @AS $MATCHED;
//   {#XDH #XDL} @AS $MATCHED;
//   #XHCTL @PLACE(-70, 24);
//   #XHCTL @ORIENT("R0");
//   #XHCTL:IN @TEXT("${net}", key="netname", size=0.6, halign="end", valign="middle", dx=-0.4, dy=0);
//   #XHCTL:HI @TEXT("${net}", key="netname", size=0.6, halign="start", valign="middle", dx=0.4, dy=0);
//   %v1 = $SUPPLY @ATTACH &VREFP => @PLACE(-70, 31.2);
//   &VREFP @WIRE {#XHCTL:VREFP (-70, 28) %v1:p};
//   %g2 = $GROUND @ATTACH &VREFN => @PLACE(-72, 16.8);
//   &VREFN @WIRE {#XHCTL:VREFN (-72, 20) %g2:p};
//   %g3 = $GROUND @ATTACH &VSS => @PLACE(-68, 16.8);
//   &VSS @WIRE {#XHCTL:VSS (-68, 20) %g3:p};
//   #XLCTL @PLACE(-70, -26);
//   #XLCTL @ORIENT("R0");
//   #XLCTL:IN @TEXT("${net}", key="netname", size=0.6, halign="end", valign="middle", dx=-0.4, dy=0);
//   #XLCTL:HI @TEXT("${net}", key="netname", size=0.6, halign="start", valign="middle", dx=0.4, dy=0);
//   %v4 = $SUPPLY @ATTACH &VREFP => @PLACE(-70, -18.8);
//   &VREFP @WIRE {#XLCTL:VREFP (-70, -22) %v4:p};
//   %g5 = $GROUND @ATTACH &VREFN => @PLACE(-72, -33.2);
//   &VREFN @WIRE {#XLCTL:VREFN (-72, -30) %g5:p};
//   %g6 = $GROUND @ATTACH &VSS => @PLACE(-68, -33.2);
//   &VSS @WIRE {#XLCTL:VSS (-68, -30) %g6:p};
//   #XDH @PLACE(-34, 24);
//   #XDH @ORIENT("R0");
//   #XDH:HI @TEXT("${net}", key="netname", size=0.6, halign="end", valign="middle", dx=-0.4, dy=0);
//   #XDH:EN @TEXT("${net}", key="netname", size=0.6, halign="end", valign="middle", dx=-0.4, dy=0);
//   #XDH:ENB @TEXT("${net}", key="netname", size=0.6, halign="end", valign="middle", dx=-0.4, dy=0);
//   #XDH:BP @TEXT("${net}", key="netname", size=0.6, halign="start", valign="middle", dx=0.4, dy=0);
//   %v7 = $SUPPLY @ATTACH &VREFP => @PLACE(-34, 32.2);
//   &VREFP @WIRE {#XDH:VREFP (-34, 29) %v7:p};
//   %g8 = $GROUND @ATTACH &VREFN => @PLACE(-36, 15.8);
//   &VREFN @WIRE {#XDH:VREFN (-36, 19) %g8:p};
//   %g9 = $GROUND @ATTACH &VSS => @PLACE(-32, 15.8);
//   &VSS @WIRE {#XDH:VSS (-32, 19) %g9:p};
//   #CH @PLACE(14, 24) => @ORIENT("R270");
//   #CH:1 @TEXT("${net}", key="netname", size=0.6, halign="start", valign="middle", dx=0.4, dy=0);
//   #CH:2 @TEXT("${net}", key="netname", size=0.6, halign="end", valign="middle", dx=-0.4, dy=0);
//   #CPH @PLACE(60, 20);
//   #CPH @ORIENT("R0");
//   #CPH:1 @TEXT("${net}", key="netname", size=0.6, halign="start", valign="middle", rotate=90, dx=0, dy=0.4);
//   %g10 = $GROUND @ATTACH &VSS => @PLACE(60, 14.8);
//   &VSS @WIRE {#CPH:2 (60, 18) %g10:p};
//   #CHA @PLACE(30, 38) => @ORIENT("R270");
//   #CHA:1 @TEXT("${net}", key="netname", size=0.6, halign="start", valign="middle", dx=0.4, dy=0);
//   #CHA:2 @TEXT("${net}", key="netname", size=0.6, halign="end", valign="middle", dx=-0.4, dy=0);
//   #CPHA @PLACE(76, 20);
//   #CPHA @ORIENT("R0");
//   #CPHA:1 @TEXT("${net}", key="netname", size=0.6, halign="start", valign="middle", rotate=90, dx=0, dy=0.4);
//   %g11 = $GROUND @ATTACH &VSS => @PLACE(76, 14.8);
//   &VSS @WIRE {#CPHA:2 (76, 18) %g11:p};
//   #CHB @PLACE(10, 38) => @ORIENT("R270");
//   #CHB:1 @TEXT("${net}", key="netname", size=0.6, halign="start", valign="middle", dx=0.4, dy=0);
//   #CHB:2 @TEXT("${net}", key="netname", size=0.6, halign="end", valign="middle", dx=-0.4, dy=0);
//   #CPHB @PLACE(92, 20);
//   #CPHB @ORIENT("R0");
//   #CPHB:1 @TEXT("${net}", key="netname", size=0.6, halign="start", valign="middle", rotate=90, dx=0, dy=0.4);
//   %g12 = $GROUND @ATTACH &VSS => @PLACE(92, 14.8);
//   &VSS @WIRE {#CPHB:2 (92, 18) %g12:p};
//   #MSH @PLACE(2, 8);
//   #MSH @ORIENT("R0");
//   #MSH:1 @TEXT("${net}", key="netname", size=0.6, halign="start", valign="middle", rotate=90, dx=0, dy=0.4);
//   #MSH:2 @TEXT("${net}", key="netname", size=0.6, halign="end", valign="middle", dx=-0.4, dy=0);
//   #MSH:3 @TEXT("${net}", key="netname", size=0.6, halign="end", valign="middle", rotate=90, dx=0, dy=-0.4);
//   %g13 = $GROUND @ATTACH &VSS => @PLACE(5, 4.8);
//   &VSS @WIRE {#MSH:4 (5, 8) %g13:p};
//   #XDL @PLACE(-34, -26);
//   #XDL @ORIENT("R0");
//   #XDL:HI @TEXT("${net}", key="netname", size=0.6, halign="end", valign="middle", dx=-0.4, dy=0);
//   #XDL:EN @TEXT("${net}", key="netname", size=0.6, halign="end", valign="middle", dx=-0.4, dy=0);
//   #XDL:ENB @TEXT("${net}", key="netname", size=0.6, halign="end", valign="middle", dx=-0.4, dy=0);
//   #XDL:BP @TEXT("${net}", key="netname", size=0.6, halign="start", valign="middle", dx=0.4, dy=0);
//   %v14 = $SUPPLY @ATTACH &VREFP => @PLACE(-34, -17.8);
//   &VREFP @WIRE {#XDL:VREFP (-34, -21) %v14:p};
//   %g15 = $GROUND @ATTACH &VREFN => @PLACE(-36, -34.2);
//   &VREFN @WIRE {#XDL:VREFN (-36, -31) %g15:p};
//   %g16 = $GROUND @ATTACH &VSS => @PLACE(-32, -34.2);
//   &VSS @WIRE {#XDL:VSS (-32, -31) %g16:p};
//   #CL @PLACE(14, -26) => @ORIENT("R270");
//   #CL:1 @TEXT("${net}", key="netname", size=0.6, halign="start", valign="middle", dx=0.4, dy=0);
//   #CL:2 @TEXT("${net}", key="netname", size=0.6, halign="end", valign="middle", dx=-0.4, dy=0);
//   #CPL @PLACE(60, -30);
//   #CPL @ORIENT("R0");
//   #CPL:1 @TEXT("${net}", key="netname", size=0.6, halign="start", valign="middle", rotate=90, dx=0, dy=0.4);
//   %g17 = $GROUND @ATTACH &VSS => @PLACE(60, -35.2);
//   &VSS @WIRE {#CPL:2 (60, -32) %g17:p};
//   #CLA @PLACE(30, -12) => @ORIENT("R270");
//   #CLA:1 @TEXT("${net}", key="netname", size=0.6, halign="start", valign="middle", dx=0.4, dy=0);
//   #CLA:2 @TEXT("${net}", key="netname", size=0.6, halign="end", valign="middle", dx=-0.4, dy=0);
//   #CPLA @PLACE(76, -30);
//   #CPLA @ORIENT("R0");
//   #CPLA:1 @TEXT("${net}", key="netname", size=0.6, halign="start", valign="middle", rotate=90, dx=0, dy=0.4);
//   %g18 = $GROUND @ATTACH &VSS => @PLACE(76, -35.2);
//   &VSS @WIRE {#CPLA:2 (76, -32) %g18:p};
//   #CLB @PLACE(10, -12) => @ORIENT("R270");
//   #CLB:1 @TEXT("${net}", key="netname", size=0.6, halign="start", valign="middle", dx=0.4, dy=0);
//   #CLB:2 @TEXT("${net}", key="netname", size=0.6, halign="end", valign="middle", dx=-0.4, dy=0);
//   #CPLB @PLACE(92, -30);
//   #CPLB @ORIENT("R0");
//   #CPLB:1 @TEXT("${net}", key="netname", size=0.6, halign="start", valign="middle", rotate=90, dx=0, dy=0.4);
//   %g19 = $GROUND @ATTACH &VSS => @PLACE(92, -35.2);
//   &VSS @WIRE {#CPLB:2 (92, -32) %g19:p};
//   #MSL @PLACE(2, -42);
//   #MSL @ORIENT("R0");
//   #MSL:1 @TEXT("${net}", key="netname", size=0.6, halign="start", valign="middle", rotate=90, dx=0, dy=0.4);
//   #MSL:2 @TEXT("${net}", key="netname", size=0.6, halign="end", valign="middle", dx=-0.4, dy=0);
//   #MSL:3 @TEXT("${net}", key="netname", size=0.6, halign="end", valign="middle", rotate=90, dx=0, dy=-0.4);
//   %g20 = $GROUND @ATTACH &VSS => @PLACE(5, -45.2);
//   &VSS @WIRE {#MSL:4 (5, -42) %g20:p};
//   &HHI @WIRE {#XHCTL:HI (-52, 24) (-52, 26) #XDH:HI};
//   %b_H = (-12, 24);
//   $JUNCTION @ATTACH %b_H;
//   &BH @WIRE {#XDH:BP %b_H};
//   &BH @WIRE {%b_H #CH:2};
//   &MIDH @WIRE {#CHB:1 #CHA:2};
//   &BH @WIRE {%b_H (-12, 38) #CHB:2};
//   &BH @WIRE {%b_H (-12, 10) #MSH:1};
//   &LHI @WIRE {#XLCTL:HI (-52, -26) (-52, -24) #XDL:HI};
//   %b_L = (-12, -26);
//   $JUNCTION @ATTACH %b_L;
//   &BL @WIRE {#XDL:BP %b_L};
//   &BL @WIRE {%b_L #CL:2};
//   &MIDL @WIRE {#CLB:1 #CLA:2};
//   &BL @WIRE {%b_L (-12, -12) #CLB:2};
//   &BL @WIRE {%b_L (-12, -40) #MSL:1};
//   &VIN @WIRE {#MSH:3 (6, 6) (6, -44) #MSL:3};
//   &VG @WIRE {#MSH:2 (-5, 8) (-5, -42) #MSL:2};
//   %top_H = (44, 24);
//   $JUNCTION @ATTACH %top_H;
//   %top_L = (44, -26);
//   $JUNCTION @ATTACH %top_L;
//   &TOP @WIRE {#CHA:1 (44, 38) %top_H};
//   &TOP @WIRE {#CH:1 %top_H};
//   &TOP @WIRE {#CLA:1 (44, -12) %top_L};
//   &TOP @WIRE {#CL:1 %top_L};
//   &TOP @WIRE {%top_H %top_L};
//   %p_vin = $IO_PORT @ATTACH &VIN => @PLACE(2, 2) => @ORIENT("R90");
//   &VIN @WIRE {%p_vin:p #MSH:3};
//   %p_vg = $IO_PORT @ATTACH &VG => @PLACE(-5, 8) => @ORIENT("R0");
//   &VG @WIRE {%p_vg:p #MSH:2};
//   %p_dh = $IO_PORT @ATTACH &DH => @PLACE(-81, 24) => @ORIENT("R0");
//   &DH @WIRE {%p_dh:p #XHCTL:IN};
//   %p_rl = $IO_PORT @ATTACH &RL => @PLACE(-81, -26) => @ORIENT("R0");
//   &RL @WIRE {%p_rl:p #XLCTL:IN};
//   %p_en = $IO_PORT @ATTACH &EN => @PLACE(-45, 24) => @ORIENT("R0");
//   &EN @WIRE {%p_en:p #XDH:EN};
//   %p_enb = $IO_PORT @ATTACH &ENB => @PLACE(-45, 22) => @ORIENT("R0");
//   &ENB @WIRE {%p_enb:p #XDH:ENB};
//   %p_top = $IO_PORT @ATTACH &TOP => @PLACE(20, 24) => @ORIENT("MY");
//   &TOP @WIRE {%p_top:p #CH:1};
//   (-10, 60) @TEXT("Matched half-capacitor pair j=7, weight 57") => @SET-STYLE $title_style
// }
ends mq_cdac_bit7

// Tristate nonoverlap driver j=6
subckt mq_cdac_drv6 (HI EN ENB BP VREFP VREFN VSS)
// GP = NAND(EN, HI, NOT(GN)); GN = NOR(ENB, HI, NOT(GP)).
// Feedback senses the opposite output-device gate; each turn-on waits for the opposite turn-off.
MPA0 (GP EN VREFP VREFP) pch_ulvt_mac w=1.3e-07 l=3e-08 nf=1
MNA0 (GP EN AN1 VSS) nch_ulvt_mac w=2.6e-07 l=3e-08 nf=1
MPA1 (GP HI VREFP VREFP) pch_ulvt_mac w=1.3e-07 l=3e-08 nf=1
MNA1 (AN1 HI AN2 VSS) nch_ulvt_mac w=2.6e-07 l=3e-08 nf=1
MPA2 (GP NOFF VREFP VREFP) pch_ulvt_mac w=1.3e-07 l=3e-08 nf=1
MNA2 (AN2 NOFF VREFN VSS) nch_ulvt_mac w=2.6e-07 l=3e-08 nf=1
MPB0 (BP1 ENB VREFP VREFP) pch_ulvt_mac w=3.9e-07 l=3e-08 nf=1
MNB0 (GN ENB VREFN VSS) nch_ulvt_mac w=1.3e-07 l=3e-08 nf=1
MPB1 (BP2 HI BP1 VREFP) pch_ulvt_mac w=3.9e-07 l=3e-08 nf=1
MNB1 (GN HI VREFN VSS) nch_ulvt_mac w=1.3e-07 l=3e-08 nf=1
MPB2 (GN PON BP2 VREFP) pch_ulvt_mac w=3.9e-07 l=3e-08 nf=1
MNB2 (GN PON VREFN VSS) nch_ulvt_mac w=1.3e-07 l=3e-08 nf=1
MFNN (NOFF GN VREFN VSS) nch_ulvt_mac w=1.3e-07 l=3e-08 nf=1
MFNP (NOFF GN VREFP VREFP) pch_ulvt_mac w=2.6e-07 l=3e-08 nf=1
MFPN (PON GP VREFN VSS) nch_ulvt_mac w=1.3e-07 l=3e-08 nf=1
MFPP (PON GP VREFP VREFP) pch_ulvt_mac w=2.6e-07 l=3e-08 nf=1
MNOUT (BP GN VREFN VSS) nch_ulvt_mac w=6.55e-07 l=3e-08 nf=1
MPOUT (BP GP VREFP VREFP) pch_ulvt_mac w=1.305e-06 l=3e-08 nf=1
// @RNL {
//   /* pins connected by net name: the net-name label of rnl-std-fill on every unwired pin, placed below by its key netname */
//   $LABEL_TERMINAL_SET @TEXT("${net}", key="netname", size=0.6);
//   &VSS @ADD-TO $GROUND_NET_SET; &VREFN @ADD-TO $GROUND_NET_SET; &VREFP @ADD-TO $SUPPLY_NET_SET;
//   {#MFNN #MFNP} @GROUP;
//   {#MFPN #MFPP} @GROUP;
//   {#MPA0 #MPA1 #MPA2 #MNA0 #MNA1 #MNA2} @GROUP;
//   {#MPB0 #MPB1 #MPB2 #MNB0 #MNB1 #MNB2} @GROUP;
//   {#MNOUT #MPOUT} @GROUP;
//   #MPA0 @PLACE(0, 26);
//   #MPA0 @ORIENT("R0");
//   #MPA0:1 @TEXT("${net}", key="netname", size=0.6, halign="end", valign="middle", rotate=90, dx=0, dy=-0.4);
//   #MPA0:2 @TEXT("${net}", key="netname", size=0.6, halign="end", valign="middle", dx=-0.4, dy=0);
//   %v1 = $SUPPLY @ATTACH &VREFP => @PLACE(0, 31.2);
//   &VREFP @WIRE {#MPA0:3 (0, 28) %v1:p};
//   %v2 = $SUPPLY @ATTACH &VREFP => @PLACE(3, 29.2);
//   &VREFP @WIRE {#MPA0:4 (3, 26) %v2:p};
//   #MNA0 @PLACE(16, 12);
//   #MNA0 @ORIENT("R0");
//   #MNA0:1 @TEXT("${net}", key="netname", size=0.6, halign="start", valign="middle", rotate=90, dx=0, dy=0.4);
//   #MNA0:2 @TEXT("${net}", key="netname", size=0.6, halign="end", valign="middle", dx=-0.4, dy=0);
//   #MNA0:3 @TEXT("${net}", key="netname", size=0.6, halign="end", valign="middle", rotate=90, dx=0, dy=-0.4);
//   %g3 = $GROUND @ATTACH &VSS => @PLACE(19, 8.8);
//   &VSS @WIRE {#MNA0:4 (19, 12) %g3:p};
//   #MPA1 @PLACE(16, 26);
//   #MPA1 @ORIENT("R0");
//   #MPA1:1 @TEXT("${net}", key="netname", size=0.6, halign="end", valign="middle", rotate=90, dx=0, dy=-0.4);
//   #MPA1:2 @TEXT("${net}", key="netname", size=0.6, halign="end", valign="middle", dx=-0.4, dy=0);
//   %v4 = $SUPPLY @ATTACH &VREFP => @PLACE(16, 31.2);
//   &VREFP @WIRE {#MPA1:3 (16, 28) %v4:p};
//   %v5 = $SUPPLY @ATTACH &VREFP => @PLACE(19, 29.2);
//   &VREFP @WIRE {#MPA1:4 (19, 26) %v5:p};
//   #MNA1 @PLACE(16, 2);
//   #MNA1 @ORIENT("R0");
//   #MNA1:1 @TEXT("${net}", key="netname", size=0.6, halign="start", valign="middle", rotate=90, dx=0, dy=0.4);
//   #MNA1:2 @TEXT("${net}", key="netname", size=0.6, halign="end", valign="middle", dx=-0.4, dy=0);
//   #MNA1:3 @TEXT("${net}", key="netname", size=0.6, halign="end", valign="middle", rotate=90, dx=0, dy=-0.4);
//   %g6 = $GROUND @ATTACH &VSS => @PLACE(19, -1.2);
//   &VSS @WIRE {#MNA1:4 (19, 2) %g6:p};
//   #MPA2 @PLACE(32, 26);
//   #MPA2 @ORIENT("R0");
//   #MPA2:1 @TEXT("${net}", key="netname", size=0.6, halign="end", valign="middle", rotate=90, dx=0, dy=-0.4);
//   #MPA2:2 @TEXT("${net}", key="netname", size=0.6, halign="end", valign="middle", dx=-0.4, dy=0);
//   %v7 = $SUPPLY @ATTACH &VREFP => @PLACE(32, 31.2);
//   &VREFP @WIRE {#MPA2:3 (32, 28) %v7:p};
//   %v8 = $SUPPLY @ATTACH &VREFP => @PLACE(35, 29.2);
//   &VREFP @WIRE {#MPA2:4 (35, 26) %v8:p};
//   #MNA2 @PLACE(16, -8);
//   #MNA2 @ORIENT("R0");
//   #MNA2:1 @TEXT("${net}", key="netname", size=0.6, halign="start", valign="middle", rotate=90, dx=0, dy=0.4);
//   #MNA2:2 @TEXT("${net}", key="netname", size=0.6, halign="end", valign="middle", dx=-0.4, dy=0);
//   %g9 = $GROUND @ATTACH &VREFN => @PLACE(16, -13.2);
//   &VREFN @WIRE {#MNA2:3 (16, -10) %g9:p};
//   %g10 = $GROUND @ATTACH &VSS => @PLACE(19, -11.2);
//   &VSS @WIRE {#MNA2:4 (19, -8) %g10:p};
//   #MPB0 @PLACE(64, 26);
//   #MPB0 @ORIENT("R0");
//   #MPB0:1 @TEXT("${net}", key="netname", size=0.6, halign="end", valign="middle", rotate=90, dx=0, dy=-0.4);
//   #MPB0:2 @TEXT("${net}", key="netname", size=0.6, halign="end", valign="middle", dx=-0.4, dy=0);
//   %v11 = $SUPPLY @ATTACH &VREFP => @PLACE(64, 31.2);
//   &VREFP @WIRE {#MPB0:3 (64, 28) %v11:p};
//   %v12 = $SUPPLY @ATTACH &VREFP => @PLACE(67, 29.2);
//   &VREFP @WIRE {#MPB0:4 (67, 26) %v12:p};
//   #MNB0 @PLACE(48, -10);
//   #MNB0 @ORIENT("R0");
//   #MNB0:1 @TEXT("${net}", key="netname", size=0.6, halign="start", valign="middle", rotate=90, dx=0, dy=0.4);
//   #MNB0:2 @TEXT("${net}", key="netname", size=0.6, halign="end", valign="middle", dx=-0.4, dy=0);
//   %g13 = $GROUND @ATTACH &VREFN => @PLACE(48, -15.2);
//   &VREFN @WIRE {#MNB0:3 (48, -12) %g13:p};
//   %g14 = $GROUND @ATTACH &VSS => @PLACE(51, -13.2);
//   &VSS @WIRE {#MNB0:4 (51, -10) %g14:p};
//   #MPB1 @PLACE(64, 16);
//   #MPB1 @ORIENT("R0");
//   #MPB1:1 @TEXT("${net}", key="netname", size=0.6, halign="end", valign="middle", rotate=90, dx=0, dy=-0.4);
//   #MPB1:2 @TEXT("${net}", key="netname", size=0.6, halign="end", valign="middle", dx=-0.4, dy=0);
//   #MPB1:3 @TEXT("${net}", key="netname", size=0.6, halign="start", valign="middle", rotate=90, dx=0, dy=0.4);
//   %v15 = $SUPPLY @ATTACH &VREFP => @PLACE(67, 19.2);
//   &VREFP @WIRE {#MPB1:4 (67, 16) %v15:p};
//   #MNB1 @PLACE(64, -10);
//   #MNB1 @ORIENT("R0");
//   #MNB1:1 @TEXT("${net}", key="netname", size=0.6, halign="start", valign="middle", rotate=90, dx=0, dy=0.4);
//   #MNB1:2 @TEXT("${net}", key="netname", size=0.6, halign="end", valign="middle", dx=-0.4, dy=0);
//   %g16 = $GROUND @ATTACH &VREFN => @PLACE(64, -15.2);
//   &VREFN @WIRE {#MNB1:3 (64, -12) %g16:p};
//   %g17 = $GROUND @ATTACH &VSS => @PLACE(67, -13.2);
//   &VSS @WIRE {#MNB1:4 (67, -10) %g17:p};
//   #MPB2 @PLACE(64, 6);
//   #MPB2 @ORIENT("R0");
//   #MPB2:1 @TEXT("${net}", key="netname", size=0.6, halign="end", valign="middle", rotate=90, dx=0, dy=-0.4);
//   #MPB2:2 @TEXT("${net}", key="netname", size=0.6, halign="end", valign="middle", dx=-0.4, dy=0);
//   #MPB2:3 @TEXT("${net}", key="netname", size=0.6, halign="start", valign="middle", rotate=90, dx=0, dy=0.4);
//   %v18 = $SUPPLY @ATTACH &VREFP => @PLACE(67, 9.2);
//   &VREFP @WIRE {#MPB2:4 (67, 6) %v18:p};
//   #MNB2 @PLACE(80, -10);
//   #MNB2 @ORIENT("R0");
//   #MNB2:1 @TEXT("${net}", key="netname", size=0.6, halign="start", valign="middle", rotate=90, dx=0, dy=0.4);
//   #MNB2:2 @TEXT("${net}", key="netname", size=0.6, halign="end", valign="middle", dx=-0.4, dy=0);
//   %g19 = $GROUND @ATTACH &VREFN => @PLACE(80, -15.2);
//   &VREFN @WIRE {#MNB2:3 (80, -12) %g19:p};
//   %g20 = $GROUND @ATTACH &VSS => @PLACE(83, -13.2);
//   &VSS @WIRE {#MNB2:4 (83, -10) %g20:p};
//   #MFNN @PLACE(108, 12);
//   #MFNN @ORIENT("R0");
//   #MFNN:1 @TEXT("${net}", key="netname", size=0.6, halign="start", valign="middle", rotate=90, dx=0, dy=0.4);
//   #MFNN:2 @TEXT("${net}", key="netname", size=0.6, halign="end", valign="middle", dx=-0.4, dy=0);
//   %g21 = $GROUND @ATTACH &VREFN => @PLACE(108, 6.8);
//   &VREFN @WIRE {#MFNN:3 (108, 10) %g21:p};
//   %g22 = $GROUND @ATTACH &VSS => @PLACE(111, 8.8);
//   &VSS @WIRE {#MFNN:4 (111, 12) %g22:p};
//   #MFNP @PLACE(108, 22);
//   #MFNP @ORIENT("R0");
//   #MFNP:1 @TEXT("${net}", key="netname", size=0.6, halign="end", valign="middle", rotate=90, dx=0, dy=-0.4);
//   #MFNP:2 @TEXT("${net}", key="netname", size=0.6, halign="end", valign="middle", dx=-0.4, dy=0);
//   %v23 = $SUPPLY @ATTACH &VREFP => @PLACE(108, 27.2);
//   &VREFP @WIRE {#MFNP:3 (108, 24) %v23:p};
//   %v24 = $SUPPLY @ATTACH &VREFP => @PLACE(111, 25.2);
//   &VREFP @WIRE {#MFNP:4 (111, 22) %v24:p};
//   #MFPN @PLACE(136, 12);
//   #MFPN @ORIENT("R0");
//   #MFPN:1 @TEXT("${net}", key="netname", size=0.6, halign="start", valign="middle", rotate=90, dx=0, dy=0.4);
//   #MFPN:2 @TEXT("${net}", key="netname", size=0.6, halign="end", valign="middle", dx=-0.4, dy=0);
//   %g25 = $GROUND @ATTACH &VREFN => @PLACE(136, 6.8);
//   &VREFN @WIRE {#MFPN:3 (136, 10) %g25:p};
//   %g26 = $GROUND @ATTACH &VSS => @PLACE(139, 8.8);
//   &VSS @WIRE {#MFPN:4 (139, 12) %g26:p};
//   #MFPP @PLACE(136, 22);
//   #MFPP @ORIENT("R0");
//   #MFPP:1 @TEXT("${net}", key="netname", size=0.6, halign="end", valign="middle", rotate=90, dx=0, dy=-0.4);
//   #MFPP:2 @TEXT("${net}", key="netname", size=0.6, halign="end", valign="middle", dx=-0.4, dy=0);
//   %v27 = $SUPPLY @ATTACH &VREFP => @PLACE(136, 27.2);
//   &VREFP @WIRE {#MFPP:3 (136, 24) %v27:p};
//   %v28 = $SUPPLY @ATTACH &VREFP => @PLACE(139, 25.2);
//   &VREFP @WIRE {#MFPP:4 (139, 22) %v28:p};
//   #MNOUT @PLACE(168, 0);
//   #MNOUT @ORIENT("R0");
//   #MNOUT:1 @TEXT("${net}", key="netname", size=0.6, halign="start", valign="middle", rotate=90, dx=0, dy=0.4);
//   #MNOUT:2 @TEXT("${net}", key="netname", size=0.6, halign="end", valign="middle", dx=-0.4, dy=0);
//   %g29 = $GROUND @ATTACH &VREFN => @PLACE(168, -5.2);
//   &VREFN @WIRE {#MNOUT:3 (168, -2) %g29:p};
//   %g30 = $GROUND @ATTACH &VSS => @PLACE(171, -3.2);
//   &VSS @WIRE {#MNOUT:4 (171, 0) %g30:p};
//   #MPOUT @PLACE(168, 22);
//   #MPOUT @ORIENT("R0");
//   #MPOUT:1 @TEXT("${net}", key="netname", size=0.6, halign="end", valign="middle", rotate=90, dx=0, dy=-0.4);
//   #MPOUT:2 @TEXT("${net}", key="netname", size=0.6, halign="end", valign="middle", dx=-0.4, dy=0);
//   %v31 = $SUPPLY @ATTACH &VREFP => @PLACE(168, 27.2);
//   &VREFP @WIRE {#MPOUT:3 (168, 24) %v31:p};
//   %v32 = $SUPPLY @ATTACH &VREFP => @PLACE(171, 25.2);
//   &VREFP @WIRE {#MPOUT:4 (171, 22) %v32:p};
//   &NOFF @WIRE {#MFNN:1 #MFNP:1};
//   &GN @WIRE {#MFNN:2 (103, 12) (103, 22) #MFNP:2};
//   &PON @WIRE {#MFPN:1 #MFPP:1};
//   &GP @WIRE {#MFPN:2 (131, 12) (131, 22) #MFPP:2};
//   %gp_bus = (16, 22);
//   $JUNCTION @ATTACH %gp_bus;
//   &GP @WIRE {#MPA0:1 (0, 22) %gp_bus (32, 22) #MPA2:1};
//   &GP @WIRE {#MPA1:1 %gp_bus #MNA0:1};
//   &AN1 @WIRE {#MNA0:3 #MNA1:1};
//   &AN2 @WIRE {#MNA1:3 #MNA2:1};
//   &BP1 @WIRE {#MPB0:1 #MPB1:3};
//   &BP2 @WIRE {#MPB1:1 #MPB2:3};
//   %gn_bus = (64, -6);
//   $JUNCTION @ATTACH %gn_bus;
//   &GN @WIRE {#MNB0:1 (48, -6) %gn_bus (80, -6) #MNB2:1};
//   &GN @WIRE {#MNB1:1 %gn_bus #MPB2:1};
//   &BP @WIRE {#MNOUT:1 #MPOUT:1};
//   %p_hi = $IO_PORT @ATTACH &HI => @PLACE(9, 26) => @ORIENT("R0");
//   &HI @WIRE {%p_hi:p #MPA1:2};
//   %p_en = $IO_PORT @ATTACH &EN => @PLACE(-7, 26) => @ORIENT("R0");
//   &EN @WIRE {%p_en:p #MPA0:2};
//   %p_enb = $IO_PORT @ATTACH &ENB => @PLACE(57, 26) => @ORIENT("R0");
//   &ENB @WIRE {%p_enb:p #MPB0:2};
//   %p_bp = $IO_PORT @ATTACH &BP => @PLACE(168, 6) => @ORIENT("R270");
//   &BP @WIRE {%p_bp:p #MNOUT:1};
//   (-10, 48) @TEXT("Tristate nonoverlap driver j=6") => @SET-STYLE $title_style
// }
ends mq_cdac_drv6

// Matched half-capacitor pair j=6, weight 32
subckt mq_cdac_bit6 (DH RL EN ENB TOP VREFP VREFN VSS)
// CP*: user-specified pre-layout estimate, 5% of each physical MOM unit to VSS.
// The second MOM terminal is its bottom plate; parallel multipliers are aggregated.
// Series tails add one unit parasitic at MID and one at B, not 5% of the equivalent half unit.
XHCTL (DH HHI VREFP VREFN VSS) mq_cdac_ctl_h
XLCTL (RL LHI VREFP VREFN VSS) mq_cdac_ctl_l
XDH (HHI EN ENB BH VREFP VREFN VSS) mq_cdac_drv6
CH (TOP BH) cfmom_2t w=5e-08 s=2.4e-07 nr=6 lr=1.69e-06 stm=2 spm=4 multi=16
CPH (BH VSS) capacitor c=8.018320e-16
XDL (LHI EN ENB BL VREFP VREFN VSS) mq_cdac_drv6
CL (TOP BL) cfmom_2t w=5e-08 s=2.4e-07 nr=6 lr=1.69e-06 stm=2 spm=4 multi=16
CPL (BL VSS) capacitor c=8.018320e-16
// @RNL {
//   /* pins connected by net name: the net-name label of rnl-std-fill on every unwired pin, placed below by its key netname */
//   $LABEL_TERMINAL_SET @TEXT("${net}", key="netname", size=0.6);
//   &VSS @ADD-TO $GROUND_NET_SET; &VREFN @ADD-TO $GROUND_NET_SET; &VREFP @ADD-TO $SUPPLY_NET_SET;
//   {#CH #CL} @AS $MATCHED;
//   {#XDH #XDL} @AS $MATCHED;
//   #XHCTL @PLACE(-70, 24);
//   #XHCTL @ORIENT("R0");
//   #XHCTL:IN @TEXT("${net}", key="netname", size=0.6, halign="end", valign="middle", dx=-0.4, dy=0);
//   #XHCTL:HI @TEXT("${net}", key="netname", size=0.6, halign="start", valign="middle", dx=0.4, dy=0);
//   %v1 = $SUPPLY @ATTACH &VREFP => @PLACE(-70, 31.2);
//   &VREFP @WIRE {#XHCTL:VREFP (-70, 28) %v1:p};
//   %g2 = $GROUND @ATTACH &VREFN => @PLACE(-72, 16.8);
//   &VREFN @WIRE {#XHCTL:VREFN (-72, 20) %g2:p};
//   %g3 = $GROUND @ATTACH &VSS => @PLACE(-68, 16.8);
//   &VSS @WIRE {#XHCTL:VSS (-68, 20) %g3:p};
//   #XLCTL @PLACE(-70, -26);
//   #XLCTL @ORIENT("R0");
//   #XLCTL:IN @TEXT("${net}", key="netname", size=0.6, halign="end", valign="middle", dx=-0.4, dy=0);
//   #XLCTL:HI @TEXT("${net}", key="netname", size=0.6, halign="start", valign="middle", dx=0.4, dy=0);
//   %v4 = $SUPPLY @ATTACH &VREFP => @PLACE(-70, -18.8);
//   &VREFP @WIRE {#XLCTL:VREFP (-70, -22) %v4:p};
//   %g5 = $GROUND @ATTACH &VREFN => @PLACE(-72, -33.2);
//   &VREFN @WIRE {#XLCTL:VREFN (-72, -30) %g5:p};
//   %g6 = $GROUND @ATTACH &VSS => @PLACE(-68, -33.2);
//   &VSS @WIRE {#XLCTL:VSS (-68, -30) %g6:p};
//   #XDH @PLACE(-34, 24);
//   #XDH @ORIENT("R0");
//   #XDH:HI @TEXT("${net}", key="netname", size=0.6, halign="end", valign="middle", dx=-0.4, dy=0);
//   #XDH:EN @TEXT("${net}", key="netname", size=0.6, halign="end", valign="middle", dx=-0.4, dy=0);
//   #XDH:ENB @TEXT("${net}", key="netname", size=0.6, halign="end", valign="middle", dx=-0.4, dy=0);
//   #XDH:BP @TEXT("${net}", key="netname", size=0.6, halign="start", valign="middle", dx=0.4, dy=0);
//   %v7 = $SUPPLY @ATTACH &VREFP => @PLACE(-34, 32.2);
//   &VREFP @WIRE {#XDH:VREFP (-34, 29) %v7:p};
//   %g8 = $GROUND @ATTACH &VREFN => @PLACE(-36, 15.8);
//   &VREFN @WIRE {#XDH:VREFN (-36, 19) %g8:p};
//   %g9 = $GROUND @ATTACH &VSS => @PLACE(-32, 15.8);
//   &VSS @WIRE {#XDH:VSS (-32, 19) %g9:p};
//   #CH @PLACE(14, 24) => @ORIENT("R270");
//   #CH:1 @TEXT("${net}", key="netname", size=0.6, halign="start", valign="middle", dx=0.4, dy=0);
//   #CH:2 @TEXT("${net}", key="netname", size=0.6, halign="end", valign="middle", dx=-0.4, dy=0);
//   #CPH @PLACE(60, 20);
//   #CPH @ORIENT("R0");
//   #CPH:1 @TEXT("${net}", key="netname", size=0.6, halign="start", valign="middle", rotate=90, dx=0, dy=0.4);
//   %g10 = $GROUND @ATTACH &VSS => @PLACE(60, 14.8);
//   &VSS @WIRE {#CPH:2 (60, 18) %g10:p};
//   #XDL @PLACE(-34, -26);
//   #XDL @ORIENT("R0");
//   #XDL:HI @TEXT("${net}", key="netname", size=0.6, halign="end", valign="middle", dx=-0.4, dy=0);
//   #XDL:EN @TEXT("${net}", key="netname", size=0.6, halign="end", valign="middle", dx=-0.4, dy=0);
//   #XDL:ENB @TEXT("${net}", key="netname", size=0.6, halign="end", valign="middle", dx=-0.4, dy=0);
//   #XDL:BP @TEXT("${net}", key="netname", size=0.6, halign="start", valign="middle", dx=0.4, dy=0);
//   %v11 = $SUPPLY @ATTACH &VREFP => @PLACE(-34, -17.8);
//   &VREFP @WIRE {#XDL:VREFP (-34, -21) %v11:p};
//   %g12 = $GROUND @ATTACH &VREFN => @PLACE(-36, -34.2);
//   &VREFN @WIRE {#XDL:VREFN (-36, -31) %g12:p};
//   %g13 = $GROUND @ATTACH &VSS => @PLACE(-32, -34.2);
//   &VSS @WIRE {#XDL:VSS (-32, -31) %g13:p};
//   #CL @PLACE(14, -26) => @ORIENT("R270");
//   #CL:1 @TEXT("${net}", key="netname", size=0.6, halign="start", valign="middle", dx=0.4, dy=0);
//   #CL:2 @TEXT("${net}", key="netname", size=0.6, halign="end", valign="middle", dx=-0.4, dy=0);
//   #CPL @PLACE(60, -30);
//   #CPL @ORIENT("R0");
//   #CPL:1 @TEXT("${net}", key="netname", size=0.6, halign="start", valign="middle", rotate=90, dx=0, dy=0.4);
//   %g14 = $GROUND @ATTACH &VSS => @PLACE(60, -35.2);
//   &VSS @WIRE {#CPL:2 (60, -32) %g14:p};
//   &HHI @WIRE {#XHCTL:HI (-52, 24) (-52, 26) #XDH:HI};
//   %b_H = (-12, 24);
//   $JUNCTION @ATTACH %b_H;
//   &BH @WIRE {#XDH:BP %b_H};
//   &BH @WIRE {%b_H #CH:2};
//   &LHI @WIRE {#XLCTL:HI (-52, -26) (-52, -24) #XDL:HI};
//   %b_L = (-12, -26);
//   $JUNCTION @ATTACH %b_L;
//   &BL @WIRE {#XDL:BP %b_L};
//   &BL @WIRE {%b_L #CL:2};
//   %top_H = (44, 24);
//   $JUNCTION @ATTACH %top_H;
//   %top_L = (44, -26);
//   $JUNCTION @ATTACH %top_L;
//   &TOP @WIRE {#CH:1 %top_H};
//   &TOP @WIRE {#CL:1 %top_L};
//   &TOP @WIRE {%top_H %top_L};
//   %p_dh = $IO_PORT @ATTACH &DH => @PLACE(-81, 24) => @ORIENT("R0");
//   &DH @WIRE {%p_dh:p #XHCTL:IN};
//   %p_rl = $IO_PORT @ATTACH &RL => @PLACE(-81, -26) => @ORIENT("R0");
//   &RL @WIRE {%p_rl:p #XLCTL:IN};
//   %p_en = $IO_PORT @ATTACH &EN => @PLACE(-45, 24) => @ORIENT("R0");
//   &EN @WIRE {%p_en:p #XDH:EN};
//   %p_enb = $IO_PORT @ATTACH &ENB => @PLACE(-45, 22) => @ORIENT("R0");
//   &ENB @WIRE {%p_enb:p #XDH:ENB};
//   %p_top = $IO_PORT @ATTACH &TOP => @PLACE(20, 24) => @ORIENT("MY");
//   &TOP @WIRE {%p_top:p #CH:1};
//   (-10, 46) @TEXT("Matched half-capacitor pair j=6, weight 32") => @SET-STYLE $title_style
// }
ends mq_cdac_bit6

// Tristate nonoverlap driver j=5
subckt mq_cdac_drv5 (HI EN ENB BP VREFP VREFN VSS)
// GP = NAND(EN, HI, NOT(GN)); GN = NOR(ENB, HI, NOT(GP)).
// Feedback senses the opposite output-device gate; each turn-on waits for the opposite turn-off.
MPA0 (GP EN VREFP VREFP) pch_ulvt_mac w=1.2e-07 l=3e-08 nf=1
MNA0 (GP EN AN1 VSS) nch_ulvt_mac w=2.4e-07 l=3e-08 nf=1
MPA1 (GP HI VREFP VREFP) pch_ulvt_mac w=1.2e-07 l=3e-08 nf=1
MNA1 (AN1 HI AN2 VSS) nch_ulvt_mac w=2.4e-07 l=3e-08 nf=1
MPA2 (GP NOFF VREFP VREFP) pch_ulvt_mac w=1.2e-07 l=3e-08 nf=1
MNA2 (AN2 NOFF VREFN VSS) nch_ulvt_mac w=2.4e-07 l=3e-08 nf=1
MPB0 (BP1 ENB VREFP VREFP) pch_ulvt_mac w=3.6e-07 l=3e-08 nf=1
MNB0 (GN ENB VREFN VSS) nch_ulvt_mac w=1.2e-07 l=3e-08 nf=1
MPB1 (BP2 HI BP1 VREFP) pch_ulvt_mac w=3.6e-07 l=3e-08 nf=1
MNB1 (GN HI VREFN VSS) nch_ulvt_mac w=1.2e-07 l=3e-08 nf=1
MPB2 (GN PON BP2 VREFP) pch_ulvt_mac w=3.6e-07 l=3e-08 nf=1
MNB2 (GN PON VREFN VSS) nch_ulvt_mac w=1.2e-07 l=3e-08 nf=1
MFNN (NOFF GN VREFN VSS) nch_ulvt_mac w=1.2e-07 l=3e-08 nf=1
MFNP (NOFF GN VREFP VREFP) pch_ulvt_mac w=2.4e-07 l=3e-08 nf=1
MFPN (PON GP VREFN VSS) nch_ulvt_mac w=1.2e-07 l=3e-08 nf=1
MFPP (PON GP VREFP VREFP) pch_ulvt_mac w=2.4e-07 l=3e-08 nf=1
MNOUT (BP GN VREFN VSS) nch_ulvt_mac w=6e-07 l=3e-08 nf=1
MPOUT (BP GP VREFP VREFP) pch_ulvt_mac w=1.2e-06 l=3e-08 nf=1
// @RNL {
//   /* pins connected by net name: the net-name label of rnl-std-fill on every unwired pin, placed below by its key netname */
//   $LABEL_TERMINAL_SET @TEXT("${net}", key="netname", size=0.6);
//   &VSS @ADD-TO $GROUND_NET_SET; &VREFN @ADD-TO $GROUND_NET_SET; &VREFP @ADD-TO $SUPPLY_NET_SET;
//   {#MFNN #MFNP} @GROUP;
//   {#MFPN #MFPP} @GROUP;
//   {#MPA0 #MPA1 #MPA2 #MNA0 #MNA1 #MNA2} @GROUP;
//   {#MPB0 #MPB1 #MPB2 #MNB0 #MNB1 #MNB2} @GROUP;
//   {#MNOUT #MPOUT} @GROUP;
//   #MPA0 @PLACE(0, 26);
//   #MPA0 @ORIENT("R0");
//   #MPA0:1 @TEXT("${net}", key="netname", size=0.6, halign="end", valign="middle", rotate=90, dx=0, dy=-0.4);
//   #MPA0:2 @TEXT("${net}", key="netname", size=0.6, halign="end", valign="middle", dx=-0.4, dy=0);
//   %v1 = $SUPPLY @ATTACH &VREFP => @PLACE(0, 31.2);
//   &VREFP @WIRE {#MPA0:3 (0, 28) %v1:p};
//   %v2 = $SUPPLY @ATTACH &VREFP => @PLACE(3, 29.2);
//   &VREFP @WIRE {#MPA0:4 (3, 26) %v2:p};
//   #MNA0 @PLACE(16, 12);
//   #MNA0 @ORIENT("R0");
//   #MNA0:1 @TEXT("${net}", key="netname", size=0.6, halign="start", valign="middle", rotate=90, dx=0, dy=0.4);
//   #MNA0:2 @TEXT("${net}", key="netname", size=0.6, halign="end", valign="middle", dx=-0.4, dy=0);
//   #MNA0:3 @TEXT("${net}", key="netname", size=0.6, halign="end", valign="middle", rotate=90, dx=0, dy=-0.4);
//   %g3 = $GROUND @ATTACH &VSS => @PLACE(19, 8.8);
//   &VSS @WIRE {#MNA0:4 (19, 12) %g3:p};
//   #MPA1 @PLACE(16, 26);
//   #MPA1 @ORIENT("R0");
//   #MPA1:1 @TEXT("${net}", key="netname", size=0.6, halign="end", valign="middle", rotate=90, dx=0, dy=-0.4);
//   #MPA1:2 @TEXT("${net}", key="netname", size=0.6, halign="end", valign="middle", dx=-0.4, dy=0);
//   %v4 = $SUPPLY @ATTACH &VREFP => @PLACE(16, 31.2);
//   &VREFP @WIRE {#MPA1:3 (16, 28) %v4:p};
//   %v5 = $SUPPLY @ATTACH &VREFP => @PLACE(19, 29.2);
//   &VREFP @WIRE {#MPA1:4 (19, 26) %v5:p};
//   #MNA1 @PLACE(16, 2);
//   #MNA1 @ORIENT("R0");
//   #MNA1:1 @TEXT("${net}", key="netname", size=0.6, halign="start", valign="middle", rotate=90, dx=0, dy=0.4);
//   #MNA1:2 @TEXT("${net}", key="netname", size=0.6, halign="end", valign="middle", dx=-0.4, dy=0);
//   #MNA1:3 @TEXT("${net}", key="netname", size=0.6, halign="end", valign="middle", rotate=90, dx=0, dy=-0.4);
//   %g6 = $GROUND @ATTACH &VSS => @PLACE(19, -1.2);
//   &VSS @WIRE {#MNA1:4 (19, 2) %g6:p};
//   #MPA2 @PLACE(32, 26);
//   #MPA2 @ORIENT("R0");
//   #MPA2:1 @TEXT("${net}", key="netname", size=0.6, halign="end", valign="middle", rotate=90, dx=0, dy=-0.4);
//   #MPA2:2 @TEXT("${net}", key="netname", size=0.6, halign="end", valign="middle", dx=-0.4, dy=0);
//   %v7 = $SUPPLY @ATTACH &VREFP => @PLACE(32, 31.2);
//   &VREFP @WIRE {#MPA2:3 (32, 28) %v7:p};
//   %v8 = $SUPPLY @ATTACH &VREFP => @PLACE(35, 29.2);
//   &VREFP @WIRE {#MPA2:4 (35, 26) %v8:p};
//   #MNA2 @PLACE(16, -8);
//   #MNA2 @ORIENT("R0");
//   #MNA2:1 @TEXT("${net}", key="netname", size=0.6, halign="start", valign="middle", rotate=90, dx=0, dy=0.4);
//   #MNA2:2 @TEXT("${net}", key="netname", size=0.6, halign="end", valign="middle", dx=-0.4, dy=0);
//   %g9 = $GROUND @ATTACH &VREFN => @PLACE(16, -13.2);
//   &VREFN @WIRE {#MNA2:3 (16, -10) %g9:p};
//   %g10 = $GROUND @ATTACH &VSS => @PLACE(19, -11.2);
//   &VSS @WIRE {#MNA2:4 (19, -8) %g10:p};
//   #MPB0 @PLACE(64, 26);
//   #MPB0 @ORIENT("R0");
//   #MPB0:1 @TEXT("${net}", key="netname", size=0.6, halign="end", valign="middle", rotate=90, dx=0, dy=-0.4);
//   #MPB0:2 @TEXT("${net}", key="netname", size=0.6, halign="end", valign="middle", dx=-0.4, dy=0);
//   %v11 = $SUPPLY @ATTACH &VREFP => @PLACE(64, 31.2);
//   &VREFP @WIRE {#MPB0:3 (64, 28) %v11:p};
//   %v12 = $SUPPLY @ATTACH &VREFP => @PLACE(67, 29.2);
//   &VREFP @WIRE {#MPB0:4 (67, 26) %v12:p};
//   #MNB0 @PLACE(48, -10);
//   #MNB0 @ORIENT("R0");
//   #MNB0:1 @TEXT("${net}", key="netname", size=0.6, halign="start", valign="middle", rotate=90, dx=0, dy=0.4);
//   #MNB0:2 @TEXT("${net}", key="netname", size=0.6, halign="end", valign="middle", dx=-0.4, dy=0);
//   %g13 = $GROUND @ATTACH &VREFN => @PLACE(48, -15.2);
//   &VREFN @WIRE {#MNB0:3 (48, -12) %g13:p};
//   %g14 = $GROUND @ATTACH &VSS => @PLACE(51, -13.2);
//   &VSS @WIRE {#MNB0:4 (51, -10) %g14:p};
//   #MPB1 @PLACE(64, 16);
//   #MPB1 @ORIENT("R0");
//   #MPB1:1 @TEXT("${net}", key="netname", size=0.6, halign="end", valign="middle", rotate=90, dx=0, dy=-0.4);
//   #MPB1:2 @TEXT("${net}", key="netname", size=0.6, halign="end", valign="middle", dx=-0.4, dy=0);
//   #MPB1:3 @TEXT("${net}", key="netname", size=0.6, halign="start", valign="middle", rotate=90, dx=0, dy=0.4);
//   %v15 = $SUPPLY @ATTACH &VREFP => @PLACE(67, 19.2);
//   &VREFP @WIRE {#MPB1:4 (67, 16) %v15:p};
//   #MNB1 @PLACE(64, -10);
//   #MNB1 @ORIENT("R0");
//   #MNB1:1 @TEXT("${net}", key="netname", size=0.6, halign="start", valign="middle", rotate=90, dx=0, dy=0.4);
//   #MNB1:2 @TEXT("${net}", key="netname", size=0.6, halign="end", valign="middle", dx=-0.4, dy=0);
//   %g16 = $GROUND @ATTACH &VREFN => @PLACE(64, -15.2);
//   &VREFN @WIRE {#MNB1:3 (64, -12) %g16:p};
//   %g17 = $GROUND @ATTACH &VSS => @PLACE(67, -13.2);
//   &VSS @WIRE {#MNB1:4 (67, -10) %g17:p};
//   #MPB2 @PLACE(64, 6);
//   #MPB2 @ORIENT("R0");
//   #MPB2:1 @TEXT("${net}", key="netname", size=0.6, halign="end", valign="middle", rotate=90, dx=0, dy=-0.4);
//   #MPB2:2 @TEXT("${net}", key="netname", size=0.6, halign="end", valign="middle", dx=-0.4, dy=0);
//   #MPB2:3 @TEXT("${net}", key="netname", size=0.6, halign="start", valign="middle", rotate=90, dx=0, dy=0.4);
//   %v18 = $SUPPLY @ATTACH &VREFP => @PLACE(67, 9.2);
//   &VREFP @WIRE {#MPB2:4 (67, 6) %v18:p};
//   #MNB2 @PLACE(80, -10);
//   #MNB2 @ORIENT("R0");
//   #MNB2:1 @TEXT("${net}", key="netname", size=0.6, halign="start", valign="middle", rotate=90, dx=0, dy=0.4);
//   #MNB2:2 @TEXT("${net}", key="netname", size=0.6, halign="end", valign="middle", dx=-0.4, dy=0);
//   %g19 = $GROUND @ATTACH &VREFN => @PLACE(80, -15.2);
//   &VREFN @WIRE {#MNB2:3 (80, -12) %g19:p};
//   %g20 = $GROUND @ATTACH &VSS => @PLACE(83, -13.2);
//   &VSS @WIRE {#MNB2:4 (83, -10) %g20:p};
//   #MFNN @PLACE(108, 12);
//   #MFNN @ORIENT("R0");
//   #MFNN:1 @TEXT("${net}", key="netname", size=0.6, halign="start", valign="middle", rotate=90, dx=0, dy=0.4);
//   #MFNN:2 @TEXT("${net}", key="netname", size=0.6, halign="end", valign="middle", dx=-0.4, dy=0);
//   %g21 = $GROUND @ATTACH &VREFN => @PLACE(108, 6.8);
//   &VREFN @WIRE {#MFNN:3 (108, 10) %g21:p};
//   %g22 = $GROUND @ATTACH &VSS => @PLACE(111, 8.8);
//   &VSS @WIRE {#MFNN:4 (111, 12) %g22:p};
//   #MFNP @PLACE(108, 22);
//   #MFNP @ORIENT("R0");
//   #MFNP:1 @TEXT("${net}", key="netname", size=0.6, halign="end", valign="middle", rotate=90, dx=0, dy=-0.4);
//   #MFNP:2 @TEXT("${net}", key="netname", size=0.6, halign="end", valign="middle", dx=-0.4, dy=0);
//   %v23 = $SUPPLY @ATTACH &VREFP => @PLACE(108, 27.2);
//   &VREFP @WIRE {#MFNP:3 (108, 24) %v23:p};
//   %v24 = $SUPPLY @ATTACH &VREFP => @PLACE(111, 25.2);
//   &VREFP @WIRE {#MFNP:4 (111, 22) %v24:p};
//   #MFPN @PLACE(136, 12);
//   #MFPN @ORIENT("R0");
//   #MFPN:1 @TEXT("${net}", key="netname", size=0.6, halign="start", valign="middle", rotate=90, dx=0, dy=0.4);
//   #MFPN:2 @TEXT("${net}", key="netname", size=0.6, halign="end", valign="middle", dx=-0.4, dy=0);
//   %g25 = $GROUND @ATTACH &VREFN => @PLACE(136, 6.8);
//   &VREFN @WIRE {#MFPN:3 (136, 10) %g25:p};
//   %g26 = $GROUND @ATTACH &VSS => @PLACE(139, 8.8);
//   &VSS @WIRE {#MFPN:4 (139, 12) %g26:p};
//   #MFPP @PLACE(136, 22);
//   #MFPP @ORIENT("R0");
//   #MFPP:1 @TEXT("${net}", key="netname", size=0.6, halign="end", valign="middle", rotate=90, dx=0, dy=-0.4);
//   #MFPP:2 @TEXT("${net}", key="netname", size=0.6, halign="end", valign="middle", dx=-0.4, dy=0);
//   %v27 = $SUPPLY @ATTACH &VREFP => @PLACE(136, 27.2);
//   &VREFP @WIRE {#MFPP:3 (136, 24) %v27:p};
//   %v28 = $SUPPLY @ATTACH &VREFP => @PLACE(139, 25.2);
//   &VREFP @WIRE {#MFPP:4 (139, 22) %v28:p};
//   #MNOUT @PLACE(168, 0);
//   #MNOUT @ORIENT("R0");
//   #MNOUT:1 @TEXT("${net}", key="netname", size=0.6, halign="start", valign="middle", rotate=90, dx=0, dy=0.4);
//   #MNOUT:2 @TEXT("${net}", key="netname", size=0.6, halign="end", valign="middle", dx=-0.4, dy=0);
//   %g29 = $GROUND @ATTACH &VREFN => @PLACE(168, -5.2);
//   &VREFN @WIRE {#MNOUT:3 (168, -2) %g29:p};
//   %g30 = $GROUND @ATTACH &VSS => @PLACE(171, -3.2);
//   &VSS @WIRE {#MNOUT:4 (171, 0) %g30:p};
//   #MPOUT @PLACE(168, 22);
//   #MPOUT @ORIENT("R0");
//   #MPOUT:1 @TEXT("${net}", key="netname", size=0.6, halign="end", valign="middle", rotate=90, dx=0, dy=-0.4);
//   #MPOUT:2 @TEXT("${net}", key="netname", size=0.6, halign="end", valign="middle", dx=-0.4, dy=0);
//   %v31 = $SUPPLY @ATTACH &VREFP => @PLACE(168, 27.2);
//   &VREFP @WIRE {#MPOUT:3 (168, 24) %v31:p};
//   %v32 = $SUPPLY @ATTACH &VREFP => @PLACE(171, 25.2);
//   &VREFP @WIRE {#MPOUT:4 (171, 22) %v32:p};
//   &NOFF @WIRE {#MFNN:1 #MFNP:1};
//   &GN @WIRE {#MFNN:2 (103, 12) (103, 22) #MFNP:2};
//   &PON @WIRE {#MFPN:1 #MFPP:1};
//   &GP @WIRE {#MFPN:2 (131, 12) (131, 22) #MFPP:2};
//   %gp_bus = (16, 22);
//   $JUNCTION @ATTACH %gp_bus;
//   &GP @WIRE {#MPA0:1 (0, 22) %gp_bus (32, 22) #MPA2:1};
//   &GP @WIRE {#MPA1:1 %gp_bus #MNA0:1};
//   &AN1 @WIRE {#MNA0:3 #MNA1:1};
//   &AN2 @WIRE {#MNA1:3 #MNA2:1};
//   &BP1 @WIRE {#MPB0:1 #MPB1:3};
//   &BP2 @WIRE {#MPB1:1 #MPB2:3};
//   %gn_bus = (64, -6);
//   $JUNCTION @ATTACH %gn_bus;
//   &GN @WIRE {#MNB0:1 (48, -6) %gn_bus (80, -6) #MNB2:1};
//   &GN @WIRE {#MNB1:1 %gn_bus #MPB2:1};
//   &BP @WIRE {#MNOUT:1 #MPOUT:1};
//   %p_hi = $IO_PORT @ATTACH &HI => @PLACE(9, 26) => @ORIENT("R0");
//   &HI @WIRE {%p_hi:p #MPA1:2};
//   %p_en = $IO_PORT @ATTACH &EN => @PLACE(-7, 26) => @ORIENT("R0");
//   &EN @WIRE {%p_en:p #MPA0:2};
//   %p_enb = $IO_PORT @ATTACH &ENB => @PLACE(57, 26) => @ORIENT("R0");
//   &ENB @WIRE {%p_enb:p #MPB0:2};
//   %p_bp = $IO_PORT @ATTACH &BP => @PLACE(168, 6) => @ORIENT("R270");
//   &BP @WIRE {%p_bp:p #MNOUT:1};
//   (-10, 48) @TEXT("Tristate nonoverlap driver j=5") => @SET-STYLE $title_style
// }
ends mq_cdac_drv5

// Matched half-capacitor pair j=5, weight 18
subckt mq_cdac_bit5 (VIN VG DH RL EN ENB TOP VREFP VREFN VSS)
// CP*: user-specified pre-layout estimate, 5% of each physical MOM unit to VSS.
// The second MOM terminal is its bottom plate; parallel multipliers are aggregated.
// Series tails add one unit parasitic at MID and one at B, not 5% of the equivalent half unit.
XHCTL (DH HHI VREFP VREFN VSS) mq_cdac_ctl_h
XLCTL (RL LHI VREFP VREFN VSS) mq_cdac_ctl_l
XDH (HHI EN ENB BH VREFP VREFN VSS) mq_cdac_drv5
CH (TOP BH) cfmom_2t w=5e-08 s=2.4e-07 nr=6 lr=1.69e-06 stm=2 spm=4 multi=9
CPH (BH VSS) capacitor c=4.510305e-16
MSH (BH VG VIN VSS) nch_ulvt_mac w=2.1e-07 l=3e-08 nf=1
XDL (LHI EN ENB BL VREFP VREFN VSS) mq_cdac_drv5
CL (TOP BL) cfmom_2t w=5e-08 s=2.4e-07 nr=6 lr=1.69e-06 stm=2 spm=4 multi=9
CPL (BL VSS) capacitor c=4.510305e-16
MSL (BL VG VIN VSS) nch_ulvt_mac w=2.1e-07 l=3e-08 nf=1
// @RNL {
//   /* pins connected by net name: the net-name label of rnl-std-fill on every unwired pin, placed below by its key netname */
//   $LABEL_TERMINAL_SET @TEXT("${net}", key="netname", size=0.6);
//   &VSS @ADD-TO $GROUND_NET_SET; &VREFN @ADD-TO $GROUND_NET_SET; &VREFP @ADD-TO $SUPPLY_NET_SET;
//   {#CH #CL} @AS $MATCHED;
//   {#MSH #MSL} @AS $MATCHED;
//   {#XDH #XDL} @AS $MATCHED;
//   #XHCTL @PLACE(-70, 24);
//   #XHCTL @ORIENT("R0");
//   #XHCTL:IN @TEXT("${net}", key="netname", size=0.6, halign="end", valign="middle", dx=-0.4, dy=0);
//   #XHCTL:HI @TEXT("${net}", key="netname", size=0.6, halign="start", valign="middle", dx=0.4, dy=0);
//   %v1 = $SUPPLY @ATTACH &VREFP => @PLACE(-70, 31.2);
//   &VREFP @WIRE {#XHCTL:VREFP (-70, 28) %v1:p};
//   %g2 = $GROUND @ATTACH &VREFN => @PLACE(-72, 16.8);
//   &VREFN @WIRE {#XHCTL:VREFN (-72, 20) %g2:p};
//   %g3 = $GROUND @ATTACH &VSS => @PLACE(-68, 16.8);
//   &VSS @WIRE {#XHCTL:VSS (-68, 20) %g3:p};
//   #XLCTL @PLACE(-70, -26);
//   #XLCTL @ORIENT("R0");
//   #XLCTL:IN @TEXT("${net}", key="netname", size=0.6, halign="end", valign="middle", dx=-0.4, dy=0);
//   #XLCTL:HI @TEXT("${net}", key="netname", size=0.6, halign="start", valign="middle", dx=0.4, dy=0);
//   %v4 = $SUPPLY @ATTACH &VREFP => @PLACE(-70, -18.8);
//   &VREFP @WIRE {#XLCTL:VREFP (-70, -22) %v4:p};
//   %g5 = $GROUND @ATTACH &VREFN => @PLACE(-72, -33.2);
//   &VREFN @WIRE {#XLCTL:VREFN (-72, -30) %g5:p};
//   %g6 = $GROUND @ATTACH &VSS => @PLACE(-68, -33.2);
//   &VSS @WIRE {#XLCTL:VSS (-68, -30) %g6:p};
//   #XDH @PLACE(-34, 24);
//   #XDH @ORIENT("R0");
//   #XDH:HI @TEXT("${net}", key="netname", size=0.6, halign="end", valign="middle", dx=-0.4, dy=0);
//   #XDH:EN @TEXT("${net}", key="netname", size=0.6, halign="end", valign="middle", dx=-0.4, dy=0);
//   #XDH:ENB @TEXT("${net}", key="netname", size=0.6, halign="end", valign="middle", dx=-0.4, dy=0);
//   #XDH:BP @TEXT("${net}", key="netname", size=0.6, halign="start", valign="middle", dx=0.4, dy=0);
//   %v7 = $SUPPLY @ATTACH &VREFP => @PLACE(-34, 32.2);
//   &VREFP @WIRE {#XDH:VREFP (-34, 29) %v7:p};
//   %g8 = $GROUND @ATTACH &VREFN => @PLACE(-36, 15.8);
//   &VREFN @WIRE {#XDH:VREFN (-36, 19) %g8:p};
//   %g9 = $GROUND @ATTACH &VSS => @PLACE(-32, 15.8);
//   &VSS @WIRE {#XDH:VSS (-32, 19) %g9:p};
//   #CH @PLACE(14, 24) => @ORIENT("R270");
//   #CH:1 @TEXT("${net}", key="netname", size=0.6, halign="start", valign="middle", dx=0.4, dy=0);
//   #CH:2 @TEXT("${net}", key="netname", size=0.6, halign="end", valign="middle", dx=-0.4, dy=0);
//   #CPH @PLACE(60, 20);
//   #CPH @ORIENT("R0");
//   #CPH:1 @TEXT("${net}", key="netname", size=0.6, halign="start", valign="middle", rotate=90, dx=0, dy=0.4);
//   %g10 = $GROUND @ATTACH &VSS => @PLACE(60, 14.8);
//   &VSS @WIRE {#CPH:2 (60, 18) %g10:p};
//   #MSH @PLACE(2, 8);
//   #MSH @ORIENT("R0");
//   #MSH:1 @TEXT("${net}", key="netname", size=0.6, halign="start", valign="middle", rotate=90, dx=0, dy=0.4);
//   #MSH:2 @TEXT("${net}", key="netname", size=0.6, halign="end", valign="middle", dx=-0.4, dy=0);
//   #MSH:3 @TEXT("${net}", key="netname", size=0.6, halign="end", valign="middle", rotate=90, dx=0, dy=-0.4);
//   %g11 = $GROUND @ATTACH &VSS => @PLACE(5, 4.8);
//   &VSS @WIRE {#MSH:4 (5, 8) %g11:p};
//   #XDL @PLACE(-34, -26);
//   #XDL @ORIENT("R0");
//   #XDL:HI @TEXT("${net}", key="netname", size=0.6, halign="end", valign="middle", dx=-0.4, dy=0);
//   #XDL:EN @TEXT("${net}", key="netname", size=0.6, halign="end", valign="middle", dx=-0.4, dy=0);
//   #XDL:ENB @TEXT("${net}", key="netname", size=0.6, halign="end", valign="middle", dx=-0.4, dy=0);
//   #XDL:BP @TEXT("${net}", key="netname", size=0.6, halign="start", valign="middle", dx=0.4, dy=0);
//   %v12 = $SUPPLY @ATTACH &VREFP => @PLACE(-34, -17.8);
//   &VREFP @WIRE {#XDL:VREFP (-34, -21) %v12:p};
//   %g13 = $GROUND @ATTACH &VREFN => @PLACE(-36, -34.2);
//   &VREFN @WIRE {#XDL:VREFN (-36, -31) %g13:p};
//   %g14 = $GROUND @ATTACH &VSS => @PLACE(-32, -34.2);
//   &VSS @WIRE {#XDL:VSS (-32, -31) %g14:p};
//   #CL @PLACE(14, -26) => @ORIENT("R270");
//   #CL:1 @TEXT("${net}", key="netname", size=0.6, halign="start", valign="middle", dx=0.4, dy=0);
//   #CL:2 @TEXT("${net}", key="netname", size=0.6, halign="end", valign="middle", dx=-0.4, dy=0);
//   #CPL @PLACE(60, -30);
//   #CPL @ORIENT("R0");
//   #CPL:1 @TEXT("${net}", key="netname", size=0.6, halign="start", valign="middle", rotate=90, dx=0, dy=0.4);
//   %g15 = $GROUND @ATTACH &VSS => @PLACE(60, -35.2);
//   &VSS @WIRE {#CPL:2 (60, -32) %g15:p};
//   #MSL @PLACE(2, -42);
//   #MSL @ORIENT("R0");
//   #MSL:1 @TEXT("${net}", key="netname", size=0.6, halign="start", valign="middle", rotate=90, dx=0, dy=0.4);
//   #MSL:2 @TEXT("${net}", key="netname", size=0.6, halign="end", valign="middle", dx=-0.4, dy=0);
//   #MSL:3 @TEXT("${net}", key="netname", size=0.6, halign="end", valign="middle", rotate=90, dx=0, dy=-0.4);
//   %g16 = $GROUND @ATTACH &VSS => @PLACE(5, -45.2);
//   &VSS @WIRE {#MSL:4 (5, -42) %g16:p};
//   &HHI @WIRE {#XHCTL:HI (-52, 24) (-52, 26) #XDH:HI};
//   %b_H = (-12, 24);
//   $JUNCTION @ATTACH %b_H;
//   &BH @WIRE {#XDH:BP %b_H};
//   &BH @WIRE {%b_H #CH:2};
//   &BH @WIRE {%b_H (-12, 10) #MSH:1};
//   &LHI @WIRE {#XLCTL:HI (-52, -26) (-52, -24) #XDL:HI};
//   %b_L = (-12, -26);
//   $JUNCTION @ATTACH %b_L;
//   &BL @WIRE {#XDL:BP %b_L};
//   &BL @WIRE {%b_L #CL:2};
//   &BL @WIRE {%b_L (-12, -40) #MSL:1};
//   &VIN @WIRE {#MSH:3 (6, 6) (6, -44) #MSL:3};
//   &VG @WIRE {#MSH:2 (-5, 8) (-5, -42) #MSL:2};
//   %top_H = (44, 24);
//   $JUNCTION @ATTACH %top_H;
//   %top_L = (44, -26);
//   $JUNCTION @ATTACH %top_L;
//   &TOP @WIRE {#CH:1 %top_H};
//   &TOP @WIRE {#CL:1 %top_L};
//   &TOP @WIRE {%top_H %top_L};
//   %p_vin = $IO_PORT @ATTACH &VIN => @PLACE(2, 2) => @ORIENT("R90");
//   &VIN @WIRE {%p_vin:p #MSH:3};
//   %p_vg = $IO_PORT @ATTACH &VG => @PLACE(-5, 8) => @ORIENT("R0");
//   &VG @WIRE {%p_vg:p #MSH:2};
//   %p_dh = $IO_PORT @ATTACH &DH => @PLACE(-81, 24) => @ORIENT("R0");
//   &DH @WIRE {%p_dh:p #XHCTL:IN};
//   %p_rl = $IO_PORT @ATTACH &RL => @PLACE(-81, -26) => @ORIENT("R0");
//   &RL @WIRE {%p_rl:p #XLCTL:IN};
//   %p_en = $IO_PORT @ATTACH &EN => @PLACE(-45, 24) => @ORIENT("R0");
//   &EN @WIRE {%p_en:p #XDH:EN};
//   %p_enb = $IO_PORT @ATTACH &ENB => @PLACE(-45, 22) => @ORIENT("R0");
//   &ENB @WIRE {%p_enb:p #XDH:ENB};
//   %p_top = $IO_PORT @ATTACH &TOP => @PLACE(20, 24) => @ORIENT("MY");
//   &TOP @WIRE {%p_top:p #CH:1};
//   (-10, 46) @TEXT("Matched half-capacitor pair j=5, weight 18") => @SET-STYLE $title_style
// }
ends mq_cdac_bit5

// Tristate nonoverlap driver j=4
subckt mq_cdac_drv4 (HI EN ENB BP VREFP VREFN VSS)
// GP = NAND(EN, HI, NOT(GN)); GN = NOR(ENB, HI, NOT(GP)).
// Feedback senses the opposite output-device gate; each turn-on waits for the opposite turn-off.
MPA0 (GP EN VREFP VREFP) pch_ulvt_mac w=1.2e-07 l=3e-08 nf=1
MNA0 (GP EN AN1 VSS) nch_ulvt_mac w=2.4e-07 l=3e-08 nf=1
MPA1 (GP HI VREFP VREFP) pch_ulvt_mac w=1.2e-07 l=3e-08 nf=1
MNA1 (AN1 HI AN2 VSS) nch_ulvt_mac w=2.4e-07 l=3e-08 nf=1
MPA2 (GP NOFF VREFP VREFP) pch_ulvt_mac w=1.2e-07 l=3e-08 nf=1
MNA2 (AN2 NOFF VREFN VSS) nch_ulvt_mac w=2.4e-07 l=3e-08 nf=1
MPB0 (BP1 ENB VREFP VREFP) pch_ulvt_mac w=3.6e-07 l=3e-08 nf=1
MNB0 (GN ENB VREFN VSS) nch_ulvt_mac w=1.2e-07 l=3e-08 nf=1
MPB1 (BP2 HI BP1 VREFP) pch_ulvt_mac w=3.6e-07 l=3e-08 nf=1
MNB1 (GN HI VREFN VSS) nch_ulvt_mac w=1.2e-07 l=3e-08 nf=1
MPB2 (GN PON BP2 VREFP) pch_ulvt_mac w=3.6e-07 l=3e-08 nf=1
MNB2 (GN PON VREFN VSS) nch_ulvt_mac w=1.2e-07 l=3e-08 nf=1
MFNN (NOFF GN VREFN VSS) nch_ulvt_mac w=1.2e-07 l=3e-08 nf=1
MFNP (NOFF GN VREFP VREFP) pch_ulvt_mac w=2.4e-07 l=3e-08 nf=1
MFPN (PON GP VREFN VSS) nch_ulvt_mac w=1.2e-07 l=3e-08 nf=1
MFPP (PON GP VREFP VREFP) pch_ulvt_mac w=2.4e-07 l=3e-08 nf=1
MNOUT (BP GN VREFN VSS) nch_ulvt_mac w=6e-07 l=3e-08 nf=1
MPOUT (BP GP VREFP VREFP) pch_ulvt_mac w=1.2e-06 l=3e-08 nf=1
// @RNL {
//   /* pins connected by net name: the net-name label of rnl-std-fill on every unwired pin, placed below by its key netname */
//   $LABEL_TERMINAL_SET @TEXT("${net}", key="netname", size=0.6);
//   &VSS @ADD-TO $GROUND_NET_SET; &VREFN @ADD-TO $GROUND_NET_SET; &VREFP @ADD-TO $SUPPLY_NET_SET;
//   {#MFNN #MFNP} @GROUP;
//   {#MFPN #MFPP} @GROUP;
//   {#MPA0 #MPA1 #MPA2 #MNA0 #MNA1 #MNA2} @GROUP;
//   {#MPB0 #MPB1 #MPB2 #MNB0 #MNB1 #MNB2} @GROUP;
//   {#MNOUT #MPOUT} @GROUP;
//   #MPA0 @PLACE(0, 26);
//   #MPA0 @ORIENT("R0");
//   #MPA0:1 @TEXT("${net}", key="netname", size=0.6, halign="end", valign="middle", rotate=90, dx=0, dy=-0.4);
//   #MPA0:2 @TEXT("${net}", key="netname", size=0.6, halign="end", valign="middle", dx=-0.4, dy=0);
//   %v1 = $SUPPLY @ATTACH &VREFP => @PLACE(0, 31.2);
//   &VREFP @WIRE {#MPA0:3 (0, 28) %v1:p};
//   %v2 = $SUPPLY @ATTACH &VREFP => @PLACE(3, 29.2);
//   &VREFP @WIRE {#MPA0:4 (3, 26) %v2:p};
//   #MNA0 @PLACE(16, 12);
//   #MNA0 @ORIENT("R0");
//   #MNA0:1 @TEXT("${net}", key="netname", size=0.6, halign="start", valign="middle", rotate=90, dx=0, dy=0.4);
//   #MNA0:2 @TEXT("${net}", key="netname", size=0.6, halign="end", valign="middle", dx=-0.4, dy=0);
//   #MNA0:3 @TEXT("${net}", key="netname", size=0.6, halign="end", valign="middle", rotate=90, dx=0, dy=-0.4);
//   %g3 = $GROUND @ATTACH &VSS => @PLACE(19, 8.8);
//   &VSS @WIRE {#MNA0:4 (19, 12) %g3:p};
//   #MPA1 @PLACE(16, 26);
//   #MPA1 @ORIENT("R0");
//   #MPA1:1 @TEXT("${net}", key="netname", size=0.6, halign="end", valign="middle", rotate=90, dx=0, dy=-0.4);
//   #MPA1:2 @TEXT("${net}", key="netname", size=0.6, halign="end", valign="middle", dx=-0.4, dy=0);
//   %v4 = $SUPPLY @ATTACH &VREFP => @PLACE(16, 31.2);
//   &VREFP @WIRE {#MPA1:3 (16, 28) %v4:p};
//   %v5 = $SUPPLY @ATTACH &VREFP => @PLACE(19, 29.2);
//   &VREFP @WIRE {#MPA1:4 (19, 26) %v5:p};
//   #MNA1 @PLACE(16, 2);
//   #MNA1 @ORIENT("R0");
//   #MNA1:1 @TEXT("${net}", key="netname", size=0.6, halign="start", valign="middle", rotate=90, dx=0, dy=0.4);
//   #MNA1:2 @TEXT("${net}", key="netname", size=0.6, halign="end", valign="middle", dx=-0.4, dy=0);
//   #MNA1:3 @TEXT("${net}", key="netname", size=0.6, halign="end", valign="middle", rotate=90, dx=0, dy=-0.4);
//   %g6 = $GROUND @ATTACH &VSS => @PLACE(19, -1.2);
//   &VSS @WIRE {#MNA1:4 (19, 2) %g6:p};
//   #MPA2 @PLACE(32, 26);
//   #MPA2 @ORIENT("R0");
//   #MPA2:1 @TEXT("${net}", key="netname", size=0.6, halign="end", valign="middle", rotate=90, dx=0, dy=-0.4);
//   #MPA2:2 @TEXT("${net}", key="netname", size=0.6, halign="end", valign="middle", dx=-0.4, dy=0);
//   %v7 = $SUPPLY @ATTACH &VREFP => @PLACE(32, 31.2);
//   &VREFP @WIRE {#MPA2:3 (32, 28) %v7:p};
//   %v8 = $SUPPLY @ATTACH &VREFP => @PLACE(35, 29.2);
//   &VREFP @WIRE {#MPA2:4 (35, 26) %v8:p};
//   #MNA2 @PLACE(16, -8);
//   #MNA2 @ORIENT("R0");
//   #MNA2:1 @TEXT("${net}", key="netname", size=0.6, halign="start", valign="middle", rotate=90, dx=0, dy=0.4);
//   #MNA2:2 @TEXT("${net}", key="netname", size=0.6, halign="end", valign="middle", dx=-0.4, dy=0);
//   %g9 = $GROUND @ATTACH &VREFN => @PLACE(16, -13.2);
//   &VREFN @WIRE {#MNA2:3 (16, -10) %g9:p};
//   %g10 = $GROUND @ATTACH &VSS => @PLACE(19, -11.2);
//   &VSS @WIRE {#MNA2:4 (19, -8) %g10:p};
//   #MPB0 @PLACE(64, 26);
//   #MPB0 @ORIENT("R0");
//   #MPB0:1 @TEXT("${net}", key="netname", size=0.6, halign="end", valign="middle", rotate=90, dx=0, dy=-0.4);
//   #MPB0:2 @TEXT("${net}", key="netname", size=0.6, halign="end", valign="middle", dx=-0.4, dy=0);
//   %v11 = $SUPPLY @ATTACH &VREFP => @PLACE(64, 31.2);
//   &VREFP @WIRE {#MPB0:3 (64, 28) %v11:p};
//   %v12 = $SUPPLY @ATTACH &VREFP => @PLACE(67, 29.2);
//   &VREFP @WIRE {#MPB0:4 (67, 26) %v12:p};
//   #MNB0 @PLACE(48, -10);
//   #MNB0 @ORIENT("R0");
//   #MNB0:1 @TEXT("${net}", key="netname", size=0.6, halign="start", valign="middle", rotate=90, dx=0, dy=0.4);
//   #MNB0:2 @TEXT("${net}", key="netname", size=0.6, halign="end", valign="middle", dx=-0.4, dy=0);
//   %g13 = $GROUND @ATTACH &VREFN => @PLACE(48, -15.2);
//   &VREFN @WIRE {#MNB0:3 (48, -12) %g13:p};
//   %g14 = $GROUND @ATTACH &VSS => @PLACE(51, -13.2);
//   &VSS @WIRE {#MNB0:4 (51, -10) %g14:p};
//   #MPB1 @PLACE(64, 16);
//   #MPB1 @ORIENT("R0");
//   #MPB1:1 @TEXT("${net}", key="netname", size=0.6, halign="end", valign="middle", rotate=90, dx=0, dy=-0.4);
//   #MPB1:2 @TEXT("${net}", key="netname", size=0.6, halign="end", valign="middle", dx=-0.4, dy=0);
//   #MPB1:3 @TEXT("${net}", key="netname", size=0.6, halign="start", valign="middle", rotate=90, dx=0, dy=0.4);
//   %v15 = $SUPPLY @ATTACH &VREFP => @PLACE(67, 19.2);
//   &VREFP @WIRE {#MPB1:4 (67, 16) %v15:p};
//   #MNB1 @PLACE(64, -10);
//   #MNB1 @ORIENT("R0");
//   #MNB1:1 @TEXT("${net}", key="netname", size=0.6, halign="start", valign="middle", rotate=90, dx=0, dy=0.4);
//   #MNB1:2 @TEXT("${net}", key="netname", size=0.6, halign="end", valign="middle", dx=-0.4, dy=0);
//   %g16 = $GROUND @ATTACH &VREFN => @PLACE(64, -15.2);
//   &VREFN @WIRE {#MNB1:3 (64, -12) %g16:p};
//   %g17 = $GROUND @ATTACH &VSS => @PLACE(67, -13.2);
//   &VSS @WIRE {#MNB1:4 (67, -10) %g17:p};
//   #MPB2 @PLACE(64, 6);
//   #MPB2 @ORIENT("R0");
//   #MPB2:1 @TEXT("${net}", key="netname", size=0.6, halign="end", valign="middle", rotate=90, dx=0, dy=-0.4);
//   #MPB2:2 @TEXT("${net}", key="netname", size=0.6, halign="end", valign="middle", dx=-0.4, dy=0);
//   #MPB2:3 @TEXT("${net}", key="netname", size=0.6, halign="start", valign="middle", rotate=90, dx=0, dy=0.4);
//   %v18 = $SUPPLY @ATTACH &VREFP => @PLACE(67, 9.2);
//   &VREFP @WIRE {#MPB2:4 (67, 6) %v18:p};
//   #MNB2 @PLACE(80, -10);
//   #MNB2 @ORIENT("R0");
//   #MNB2:1 @TEXT("${net}", key="netname", size=0.6, halign="start", valign="middle", rotate=90, dx=0, dy=0.4);
//   #MNB2:2 @TEXT("${net}", key="netname", size=0.6, halign="end", valign="middle", dx=-0.4, dy=0);
//   %g19 = $GROUND @ATTACH &VREFN => @PLACE(80, -15.2);
//   &VREFN @WIRE {#MNB2:3 (80, -12) %g19:p};
//   %g20 = $GROUND @ATTACH &VSS => @PLACE(83, -13.2);
//   &VSS @WIRE {#MNB2:4 (83, -10) %g20:p};
//   #MFNN @PLACE(108, 12);
//   #MFNN @ORIENT("R0");
//   #MFNN:1 @TEXT("${net}", key="netname", size=0.6, halign="start", valign="middle", rotate=90, dx=0, dy=0.4);
//   #MFNN:2 @TEXT("${net}", key="netname", size=0.6, halign="end", valign="middle", dx=-0.4, dy=0);
//   %g21 = $GROUND @ATTACH &VREFN => @PLACE(108, 6.8);
//   &VREFN @WIRE {#MFNN:3 (108, 10) %g21:p};
//   %g22 = $GROUND @ATTACH &VSS => @PLACE(111, 8.8);
//   &VSS @WIRE {#MFNN:4 (111, 12) %g22:p};
//   #MFNP @PLACE(108, 22);
//   #MFNP @ORIENT("R0");
//   #MFNP:1 @TEXT("${net}", key="netname", size=0.6, halign="end", valign="middle", rotate=90, dx=0, dy=-0.4);
//   #MFNP:2 @TEXT("${net}", key="netname", size=0.6, halign="end", valign="middle", dx=-0.4, dy=0);
//   %v23 = $SUPPLY @ATTACH &VREFP => @PLACE(108, 27.2);
//   &VREFP @WIRE {#MFNP:3 (108, 24) %v23:p};
//   %v24 = $SUPPLY @ATTACH &VREFP => @PLACE(111, 25.2);
//   &VREFP @WIRE {#MFNP:4 (111, 22) %v24:p};
//   #MFPN @PLACE(136, 12);
//   #MFPN @ORIENT("R0");
//   #MFPN:1 @TEXT("${net}", key="netname", size=0.6, halign="start", valign="middle", rotate=90, dx=0, dy=0.4);
//   #MFPN:2 @TEXT("${net}", key="netname", size=0.6, halign="end", valign="middle", dx=-0.4, dy=0);
//   %g25 = $GROUND @ATTACH &VREFN => @PLACE(136, 6.8);
//   &VREFN @WIRE {#MFPN:3 (136, 10) %g25:p};
//   %g26 = $GROUND @ATTACH &VSS => @PLACE(139, 8.8);
//   &VSS @WIRE {#MFPN:4 (139, 12) %g26:p};
//   #MFPP @PLACE(136, 22);
//   #MFPP @ORIENT("R0");
//   #MFPP:1 @TEXT("${net}", key="netname", size=0.6, halign="end", valign="middle", rotate=90, dx=0, dy=-0.4);
//   #MFPP:2 @TEXT("${net}", key="netname", size=0.6, halign="end", valign="middle", dx=-0.4, dy=0);
//   %v27 = $SUPPLY @ATTACH &VREFP => @PLACE(136, 27.2);
//   &VREFP @WIRE {#MFPP:3 (136, 24) %v27:p};
//   %v28 = $SUPPLY @ATTACH &VREFP => @PLACE(139, 25.2);
//   &VREFP @WIRE {#MFPP:4 (139, 22) %v28:p};
//   #MNOUT @PLACE(168, 0);
//   #MNOUT @ORIENT("R0");
//   #MNOUT:1 @TEXT("${net}", key="netname", size=0.6, halign="start", valign="middle", rotate=90, dx=0, dy=0.4);
//   #MNOUT:2 @TEXT("${net}", key="netname", size=0.6, halign="end", valign="middle", dx=-0.4, dy=0);
//   %g29 = $GROUND @ATTACH &VREFN => @PLACE(168, -5.2);
//   &VREFN @WIRE {#MNOUT:3 (168, -2) %g29:p};
//   %g30 = $GROUND @ATTACH &VSS => @PLACE(171, -3.2);
//   &VSS @WIRE {#MNOUT:4 (171, 0) %g30:p};
//   #MPOUT @PLACE(168, 22);
//   #MPOUT @ORIENT("R0");
//   #MPOUT:1 @TEXT("${net}", key="netname", size=0.6, halign="end", valign="middle", rotate=90, dx=0, dy=-0.4);
//   #MPOUT:2 @TEXT("${net}", key="netname", size=0.6, halign="end", valign="middle", dx=-0.4, dy=0);
//   %v31 = $SUPPLY @ATTACH &VREFP => @PLACE(168, 27.2);
//   &VREFP @WIRE {#MPOUT:3 (168, 24) %v31:p};
//   %v32 = $SUPPLY @ATTACH &VREFP => @PLACE(171, 25.2);
//   &VREFP @WIRE {#MPOUT:4 (171, 22) %v32:p};
//   &NOFF @WIRE {#MFNN:1 #MFNP:1};
//   &GN @WIRE {#MFNN:2 (103, 12) (103, 22) #MFNP:2};
//   &PON @WIRE {#MFPN:1 #MFPP:1};
//   &GP @WIRE {#MFPN:2 (131, 12) (131, 22) #MFPP:2};
//   %gp_bus = (16, 22);
//   $JUNCTION @ATTACH %gp_bus;
//   &GP @WIRE {#MPA0:1 (0, 22) %gp_bus (32, 22) #MPA2:1};
//   &GP @WIRE {#MPA1:1 %gp_bus #MNA0:1};
//   &AN1 @WIRE {#MNA0:3 #MNA1:1};
//   &AN2 @WIRE {#MNA1:3 #MNA2:1};
//   &BP1 @WIRE {#MPB0:1 #MPB1:3};
//   &BP2 @WIRE {#MPB1:1 #MPB2:3};
//   %gn_bus = (64, -6);
//   $JUNCTION @ATTACH %gn_bus;
//   &GN @WIRE {#MNB0:1 (48, -6) %gn_bus (80, -6) #MNB2:1};
//   &GN @WIRE {#MNB1:1 %gn_bus #MPB2:1};
//   &BP @WIRE {#MNOUT:1 #MPOUT:1};
//   %p_hi = $IO_PORT @ATTACH &HI => @PLACE(9, 26) => @ORIENT("R0");
//   &HI @WIRE {%p_hi:p #MPA1:2};
//   %p_en = $IO_PORT @ATTACH &EN => @PLACE(-7, 26) => @ORIENT("R0");
//   &EN @WIRE {%p_en:p #MPA0:2};
//   %p_enb = $IO_PORT @ATTACH &ENB => @PLACE(57, 26) => @ORIENT("R0");
//   &ENB @WIRE {%p_enb:p #MPB0:2};
//   %p_bp = $IO_PORT @ATTACH &BP => @PLACE(168, 6) => @ORIENT("R270");
//   &BP @WIRE {%p_bp:p #MNOUT:1};
//   (-10, 48) @TEXT("Tristate nonoverlap driver j=4") => @SET-STYLE $title_style
// }
ends mq_cdac_drv4

// Matched half-capacitor pair j=4, weight 10
subckt mq_cdac_bit4 (VIN VG DH RL EN ENB TOP VREFP VREFN VSS)
// CP*: user-specified pre-layout estimate, 5% of each physical MOM unit to VSS.
// The second MOM terminal is its bottom plate; parallel multipliers are aggregated.
// Series tails add one unit parasitic at MID and one at B, not 5% of the equivalent half unit.
XHCTL (DH HHI VREFP VREFN VSS) mq_cdac_ctl_h
XLCTL (RL LHI VREFP VREFN VSS) mq_cdac_ctl_l
XDH (HHI EN ENB BH VREFP VREFN VSS) mq_cdac_drv4
CH (TOP BH) cfmom_2t w=5e-08 s=2.4e-07 nr=6 lr=1.69e-06 stm=2 spm=4 multi=5
CPH (BH VSS) capacitor c=2.505725e-16
MSH (BH VG VIN VSS) nch_ulvt_mac w=1.2e-07 l=3e-08 nf=1
XDL (LHI EN ENB BL VREFP VREFN VSS) mq_cdac_drv4
CL (TOP BL) cfmom_2t w=5e-08 s=2.4e-07 nr=6 lr=1.69e-06 stm=2 spm=4 multi=5
CPL (BL VSS) capacitor c=2.505725e-16
MSL (BL VG VIN VSS) nch_ulvt_mac w=1.2e-07 l=3e-08 nf=1
// @RNL {
//   /* pins connected by net name: the net-name label of rnl-std-fill on every unwired pin, placed below by its key netname */
//   $LABEL_TERMINAL_SET @TEXT("${net}", key="netname", size=0.6);
//   &VSS @ADD-TO $GROUND_NET_SET; &VREFN @ADD-TO $GROUND_NET_SET; &VREFP @ADD-TO $SUPPLY_NET_SET;
//   {#CH #CL} @AS $MATCHED;
//   {#MSH #MSL} @AS $MATCHED;
//   {#XDH #XDL} @AS $MATCHED;
//   #XHCTL @PLACE(-70, 24);
//   #XHCTL @ORIENT("R0");
//   #XHCTL:IN @TEXT("${net}", key="netname", size=0.6, halign="end", valign="middle", dx=-0.4, dy=0);
//   #XHCTL:HI @TEXT("${net}", key="netname", size=0.6, halign="start", valign="middle", dx=0.4, dy=0);
//   %v1 = $SUPPLY @ATTACH &VREFP => @PLACE(-70, 31.2);
//   &VREFP @WIRE {#XHCTL:VREFP (-70, 28) %v1:p};
//   %g2 = $GROUND @ATTACH &VREFN => @PLACE(-72, 16.8);
//   &VREFN @WIRE {#XHCTL:VREFN (-72, 20) %g2:p};
//   %g3 = $GROUND @ATTACH &VSS => @PLACE(-68, 16.8);
//   &VSS @WIRE {#XHCTL:VSS (-68, 20) %g3:p};
//   #XLCTL @PLACE(-70, -26);
//   #XLCTL @ORIENT("R0");
//   #XLCTL:IN @TEXT("${net}", key="netname", size=0.6, halign="end", valign="middle", dx=-0.4, dy=0);
//   #XLCTL:HI @TEXT("${net}", key="netname", size=0.6, halign="start", valign="middle", dx=0.4, dy=0);
//   %v4 = $SUPPLY @ATTACH &VREFP => @PLACE(-70, -18.8);
//   &VREFP @WIRE {#XLCTL:VREFP (-70, -22) %v4:p};
//   %g5 = $GROUND @ATTACH &VREFN => @PLACE(-72, -33.2);
//   &VREFN @WIRE {#XLCTL:VREFN (-72, -30) %g5:p};
//   %g6 = $GROUND @ATTACH &VSS => @PLACE(-68, -33.2);
//   &VSS @WIRE {#XLCTL:VSS (-68, -30) %g6:p};
//   #XDH @PLACE(-34, 24);
//   #XDH @ORIENT("R0");
//   #XDH:HI @TEXT("${net}", key="netname", size=0.6, halign="end", valign="middle", dx=-0.4, dy=0);
//   #XDH:EN @TEXT("${net}", key="netname", size=0.6, halign="end", valign="middle", dx=-0.4, dy=0);
//   #XDH:ENB @TEXT("${net}", key="netname", size=0.6, halign="end", valign="middle", dx=-0.4, dy=0);
//   #XDH:BP @TEXT("${net}", key="netname", size=0.6, halign="start", valign="middle", dx=0.4, dy=0);
//   %v7 = $SUPPLY @ATTACH &VREFP => @PLACE(-34, 32.2);
//   &VREFP @WIRE {#XDH:VREFP (-34, 29) %v7:p};
//   %g8 = $GROUND @ATTACH &VREFN => @PLACE(-36, 15.8);
//   &VREFN @WIRE {#XDH:VREFN (-36, 19) %g8:p};
//   %g9 = $GROUND @ATTACH &VSS => @PLACE(-32, 15.8);
//   &VSS @WIRE {#XDH:VSS (-32, 19) %g9:p};
//   #CH @PLACE(14, 24) => @ORIENT("R270");
//   #CH:1 @TEXT("${net}", key="netname", size=0.6, halign="start", valign="middle", dx=0.4, dy=0);
//   #CH:2 @TEXT("${net}", key="netname", size=0.6, halign="end", valign="middle", dx=-0.4, dy=0);
//   #CPH @PLACE(60, 20);
//   #CPH @ORIENT("R0");
//   #CPH:1 @TEXT("${net}", key="netname", size=0.6, halign="start", valign="middle", rotate=90, dx=0, dy=0.4);
//   %g10 = $GROUND @ATTACH &VSS => @PLACE(60, 14.8);
//   &VSS @WIRE {#CPH:2 (60, 18) %g10:p};
//   #MSH @PLACE(2, 8);
//   #MSH @ORIENT("R0");
//   #MSH:1 @TEXT("${net}", key="netname", size=0.6, halign="start", valign="middle", rotate=90, dx=0, dy=0.4);
//   #MSH:2 @TEXT("${net}", key="netname", size=0.6, halign="end", valign="middle", dx=-0.4, dy=0);
//   #MSH:3 @TEXT("${net}", key="netname", size=0.6, halign="end", valign="middle", rotate=90, dx=0, dy=-0.4);
//   %g11 = $GROUND @ATTACH &VSS => @PLACE(5, 4.8);
//   &VSS @WIRE {#MSH:4 (5, 8) %g11:p};
//   #XDL @PLACE(-34, -26);
//   #XDL @ORIENT("R0");
//   #XDL:HI @TEXT("${net}", key="netname", size=0.6, halign="end", valign="middle", dx=-0.4, dy=0);
//   #XDL:EN @TEXT("${net}", key="netname", size=0.6, halign="end", valign="middle", dx=-0.4, dy=0);
//   #XDL:ENB @TEXT("${net}", key="netname", size=0.6, halign="end", valign="middle", dx=-0.4, dy=0);
//   #XDL:BP @TEXT("${net}", key="netname", size=0.6, halign="start", valign="middle", dx=0.4, dy=0);
//   %v12 = $SUPPLY @ATTACH &VREFP => @PLACE(-34, -17.8);
//   &VREFP @WIRE {#XDL:VREFP (-34, -21) %v12:p};
//   %g13 = $GROUND @ATTACH &VREFN => @PLACE(-36, -34.2);
//   &VREFN @WIRE {#XDL:VREFN (-36, -31) %g13:p};
//   %g14 = $GROUND @ATTACH &VSS => @PLACE(-32, -34.2);
//   &VSS @WIRE {#XDL:VSS (-32, -31) %g14:p};
//   #CL @PLACE(14, -26) => @ORIENT("R270");
//   #CL:1 @TEXT("${net}", key="netname", size=0.6, halign="start", valign="middle", dx=0.4, dy=0);
//   #CL:2 @TEXT("${net}", key="netname", size=0.6, halign="end", valign="middle", dx=-0.4, dy=0);
//   #CPL @PLACE(60, -30);
//   #CPL @ORIENT("R0");
//   #CPL:1 @TEXT("${net}", key="netname", size=0.6, halign="start", valign="middle", rotate=90, dx=0, dy=0.4);
//   %g15 = $GROUND @ATTACH &VSS => @PLACE(60, -35.2);
//   &VSS @WIRE {#CPL:2 (60, -32) %g15:p};
//   #MSL @PLACE(2, -42);
//   #MSL @ORIENT("R0");
//   #MSL:1 @TEXT("${net}", key="netname", size=0.6, halign="start", valign="middle", rotate=90, dx=0, dy=0.4);
//   #MSL:2 @TEXT("${net}", key="netname", size=0.6, halign="end", valign="middle", dx=-0.4, dy=0);
//   #MSL:3 @TEXT("${net}", key="netname", size=0.6, halign="end", valign="middle", rotate=90, dx=0, dy=-0.4);
//   %g16 = $GROUND @ATTACH &VSS => @PLACE(5, -45.2);
//   &VSS @WIRE {#MSL:4 (5, -42) %g16:p};
//   &HHI @WIRE {#XHCTL:HI (-52, 24) (-52, 26) #XDH:HI};
//   %b_H = (-12, 24);
//   $JUNCTION @ATTACH %b_H;
//   &BH @WIRE {#XDH:BP %b_H};
//   &BH @WIRE {%b_H #CH:2};
//   &BH @WIRE {%b_H (-12, 10) #MSH:1};
//   &LHI @WIRE {#XLCTL:HI (-52, -26) (-52, -24) #XDL:HI};
//   %b_L = (-12, -26);
//   $JUNCTION @ATTACH %b_L;
//   &BL @WIRE {#XDL:BP %b_L};
//   &BL @WIRE {%b_L #CL:2};
//   &BL @WIRE {%b_L (-12, -40) #MSL:1};
//   &VIN @WIRE {#MSH:3 (6, 6) (6, -44) #MSL:3};
//   &VG @WIRE {#MSH:2 (-5, 8) (-5, -42) #MSL:2};
//   %top_H = (44, 24);
//   $JUNCTION @ATTACH %top_H;
//   %top_L = (44, -26);
//   $JUNCTION @ATTACH %top_L;
//   &TOP @WIRE {#CH:1 %top_H};
//   &TOP @WIRE {#CL:1 %top_L};
//   &TOP @WIRE {%top_H %top_L};
//   %p_vin = $IO_PORT @ATTACH &VIN => @PLACE(2, 2) => @ORIENT("R90");
//   &VIN @WIRE {%p_vin:p #MSH:3};
//   %p_vg = $IO_PORT @ATTACH &VG => @PLACE(-5, 8) => @ORIENT("R0");
//   &VG @WIRE {%p_vg:p #MSH:2};
//   %p_dh = $IO_PORT @ATTACH &DH => @PLACE(-81, 24) => @ORIENT("R0");
//   &DH @WIRE {%p_dh:p #XHCTL:IN};
//   %p_rl = $IO_PORT @ATTACH &RL => @PLACE(-81, -26) => @ORIENT("R0");
//   &RL @WIRE {%p_rl:p #XLCTL:IN};
//   %p_en = $IO_PORT @ATTACH &EN => @PLACE(-45, 24) => @ORIENT("R0");
//   &EN @WIRE {%p_en:p #XDH:EN};
//   %p_enb = $IO_PORT @ATTACH &ENB => @PLACE(-45, 22) => @ORIENT("R0");
//   &ENB @WIRE {%p_enb:p #XDH:ENB};
//   %p_top = $IO_PORT @ATTACH &TOP => @PLACE(20, 24) => @ORIENT("MY");
//   &TOP @WIRE {%p_top:p #CH:1};
//   (-10, 46) @TEXT("Matched half-capacitor pair j=4, weight 10") => @SET-STYLE $title_style
// }
ends mq_cdac_bit4

// Tristate nonoverlap driver j=3
subckt mq_cdac_drv3 (HI EN ENB BP VREFP VREFN VSS)
// GP = NAND(EN, HI, NOT(GN)); GN = NOR(ENB, HI, NOT(GP)).
// Feedback senses the opposite output-device gate; each turn-on waits for the opposite turn-off.
MPA0 (GP EN VREFP VREFP) pch_ulvt_mac w=1.2e-07 l=3e-08 nf=1
MNA0 (GP EN AN1 VSS) nch_ulvt_mac w=2.4e-07 l=3e-08 nf=1
MPA1 (GP HI VREFP VREFP) pch_ulvt_mac w=1.2e-07 l=3e-08 nf=1
MNA1 (AN1 HI AN2 VSS) nch_ulvt_mac w=2.4e-07 l=3e-08 nf=1
MPA2 (GP NOFF VREFP VREFP) pch_ulvt_mac w=1.2e-07 l=3e-08 nf=1
MNA2 (AN2 NOFF VREFN VSS) nch_ulvt_mac w=2.4e-07 l=3e-08 nf=1
MPB0 (BP1 ENB VREFP VREFP) pch_ulvt_mac w=3.6e-07 l=3e-08 nf=1
MNB0 (GN ENB VREFN VSS) nch_ulvt_mac w=1.2e-07 l=3e-08 nf=1
MPB1 (BP2 HI BP1 VREFP) pch_ulvt_mac w=3.6e-07 l=3e-08 nf=1
MNB1 (GN HI VREFN VSS) nch_ulvt_mac w=1.2e-07 l=3e-08 nf=1
MPB2 (GN PON BP2 VREFP) pch_ulvt_mac w=3.6e-07 l=3e-08 nf=1
MNB2 (GN PON VREFN VSS) nch_ulvt_mac w=1.2e-07 l=3e-08 nf=1
MFNN (NOFF GN VREFN VSS) nch_ulvt_mac w=1.2e-07 l=3e-08 nf=1
MFNP (NOFF GN VREFP VREFP) pch_ulvt_mac w=2.4e-07 l=3e-08 nf=1
MFPN (PON GP VREFN VSS) nch_ulvt_mac w=1.2e-07 l=3e-08 nf=1
MFPP (PON GP VREFP VREFP) pch_ulvt_mac w=2.4e-07 l=3e-08 nf=1
MNOUT (BP GN VREFN VSS) nch_ulvt_mac w=6e-07 l=3e-08 nf=1
MPOUT (BP GP VREFP VREFP) pch_ulvt_mac w=1.2e-06 l=3e-08 nf=1
// @RNL {
//   /* pins connected by net name: the net-name label of rnl-std-fill on every unwired pin, placed below by its key netname */
//   $LABEL_TERMINAL_SET @TEXT("${net}", key="netname", size=0.6);
//   &VSS @ADD-TO $GROUND_NET_SET; &VREFN @ADD-TO $GROUND_NET_SET; &VREFP @ADD-TO $SUPPLY_NET_SET;
//   {#MFNN #MFNP} @GROUP;
//   {#MFPN #MFPP} @GROUP;
//   {#MPA0 #MPA1 #MPA2 #MNA0 #MNA1 #MNA2} @GROUP;
//   {#MPB0 #MPB1 #MPB2 #MNB0 #MNB1 #MNB2} @GROUP;
//   {#MNOUT #MPOUT} @GROUP;
//   #MPA0 @PLACE(0, 26);
//   #MPA0 @ORIENT("R0");
//   #MPA0:1 @TEXT("${net}", key="netname", size=0.6, halign="end", valign="middle", rotate=90, dx=0, dy=-0.4);
//   #MPA0:2 @TEXT("${net}", key="netname", size=0.6, halign="end", valign="middle", dx=-0.4, dy=0);
//   %v1 = $SUPPLY @ATTACH &VREFP => @PLACE(0, 31.2);
//   &VREFP @WIRE {#MPA0:3 (0, 28) %v1:p};
//   %v2 = $SUPPLY @ATTACH &VREFP => @PLACE(3, 29.2);
//   &VREFP @WIRE {#MPA0:4 (3, 26) %v2:p};
//   #MNA0 @PLACE(16, 12);
//   #MNA0 @ORIENT("R0");
//   #MNA0:1 @TEXT("${net}", key="netname", size=0.6, halign="start", valign="middle", rotate=90, dx=0, dy=0.4);
//   #MNA0:2 @TEXT("${net}", key="netname", size=0.6, halign="end", valign="middle", dx=-0.4, dy=0);
//   #MNA0:3 @TEXT("${net}", key="netname", size=0.6, halign="end", valign="middle", rotate=90, dx=0, dy=-0.4);
//   %g3 = $GROUND @ATTACH &VSS => @PLACE(19, 8.8);
//   &VSS @WIRE {#MNA0:4 (19, 12) %g3:p};
//   #MPA1 @PLACE(16, 26);
//   #MPA1 @ORIENT("R0");
//   #MPA1:1 @TEXT("${net}", key="netname", size=0.6, halign="end", valign="middle", rotate=90, dx=0, dy=-0.4);
//   #MPA1:2 @TEXT("${net}", key="netname", size=0.6, halign="end", valign="middle", dx=-0.4, dy=0);
//   %v4 = $SUPPLY @ATTACH &VREFP => @PLACE(16, 31.2);
//   &VREFP @WIRE {#MPA1:3 (16, 28) %v4:p};
//   %v5 = $SUPPLY @ATTACH &VREFP => @PLACE(19, 29.2);
//   &VREFP @WIRE {#MPA1:4 (19, 26) %v5:p};
//   #MNA1 @PLACE(16, 2);
//   #MNA1 @ORIENT("R0");
//   #MNA1:1 @TEXT("${net}", key="netname", size=0.6, halign="start", valign="middle", rotate=90, dx=0, dy=0.4);
//   #MNA1:2 @TEXT("${net}", key="netname", size=0.6, halign="end", valign="middle", dx=-0.4, dy=0);
//   #MNA1:3 @TEXT("${net}", key="netname", size=0.6, halign="end", valign="middle", rotate=90, dx=0, dy=-0.4);
//   %g6 = $GROUND @ATTACH &VSS => @PLACE(19, -1.2);
//   &VSS @WIRE {#MNA1:4 (19, 2) %g6:p};
//   #MPA2 @PLACE(32, 26);
//   #MPA2 @ORIENT("R0");
//   #MPA2:1 @TEXT("${net}", key="netname", size=0.6, halign="end", valign="middle", rotate=90, dx=0, dy=-0.4);
//   #MPA2:2 @TEXT("${net}", key="netname", size=0.6, halign="end", valign="middle", dx=-0.4, dy=0);
//   %v7 = $SUPPLY @ATTACH &VREFP => @PLACE(32, 31.2);
//   &VREFP @WIRE {#MPA2:3 (32, 28) %v7:p};
//   %v8 = $SUPPLY @ATTACH &VREFP => @PLACE(35, 29.2);
//   &VREFP @WIRE {#MPA2:4 (35, 26) %v8:p};
//   #MNA2 @PLACE(16, -8);
//   #MNA2 @ORIENT("R0");
//   #MNA2:1 @TEXT("${net}", key="netname", size=0.6, halign="start", valign="middle", rotate=90, dx=0, dy=0.4);
//   #MNA2:2 @TEXT("${net}", key="netname", size=0.6, halign="end", valign="middle", dx=-0.4, dy=0);
//   %g9 = $GROUND @ATTACH &VREFN => @PLACE(16, -13.2);
//   &VREFN @WIRE {#MNA2:3 (16, -10) %g9:p};
//   %g10 = $GROUND @ATTACH &VSS => @PLACE(19, -11.2);
//   &VSS @WIRE {#MNA2:4 (19, -8) %g10:p};
//   #MPB0 @PLACE(64, 26);
//   #MPB0 @ORIENT("R0");
//   #MPB0:1 @TEXT("${net}", key="netname", size=0.6, halign="end", valign="middle", rotate=90, dx=0, dy=-0.4);
//   #MPB0:2 @TEXT("${net}", key="netname", size=0.6, halign="end", valign="middle", dx=-0.4, dy=0);
//   %v11 = $SUPPLY @ATTACH &VREFP => @PLACE(64, 31.2);
//   &VREFP @WIRE {#MPB0:3 (64, 28) %v11:p};
//   %v12 = $SUPPLY @ATTACH &VREFP => @PLACE(67, 29.2);
//   &VREFP @WIRE {#MPB0:4 (67, 26) %v12:p};
//   #MNB0 @PLACE(48, -10);
//   #MNB0 @ORIENT("R0");
//   #MNB0:1 @TEXT("${net}", key="netname", size=0.6, halign="start", valign="middle", rotate=90, dx=0, dy=0.4);
//   #MNB0:2 @TEXT("${net}", key="netname", size=0.6, halign="end", valign="middle", dx=-0.4, dy=0);
//   %g13 = $GROUND @ATTACH &VREFN => @PLACE(48, -15.2);
//   &VREFN @WIRE {#MNB0:3 (48, -12) %g13:p};
//   %g14 = $GROUND @ATTACH &VSS => @PLACE(51, -13.2);
//   &VSS @WIRE {#MNB0:4 (51, -10) %g14:p};
//   #MPB1 @PLACE(64, 16);
//   #MPB1 @ORIENT("R0");
//   #MPB1:1 @TEXT("${net}", key="netname", size=0.6, halign="end", valign="middle", rotate=90, dx=0, dy=-0.4);
//   #MPB1:2 @TEXT("${net}", key="netname", size=0.6, halign="end", valign="middle", dx=-0.4, dy=0);
//   #MPB1:3 @TEXT("${net}", key="netname", size=0.6, halign="start", valign="middle", rotate=90, dx=0, dy=0.4);
//   %v15 = $SUPPLY @ATTACH &VREFP => @PLACE(67, 19.2);
//   &VREFP @WIRE {#MPB1:4 (67, 16) %v15:p};
//   #MNB1 @PLACE(64, -10);
//   #MNB1 @ORIENT("R0");
//   #MNB1:1 @TEXT("${net}", key="netname", size=0.6, halign="start", valign="middle", rotate=90, dx=0, dy=0.4);
//   #MNB1:2 @TEXT("${net}", key="netname", size=0.6, halign="end", valign="middle", dx=-0.4, dy=0);
//   %g16 = $GROUND @ATTACH &VREFN => @PLACE(64, -15.2);
//   &VREFN @WIRE {#MNB1:3 (64, -12) %g16:p};
//   %g17 = $GROUND @ATTACH &VSS => @PLACE(67, -13.2);
//   &VSS @WIRE {#MNB1:4 (67, -10) %g17:p};
//   #MPB2 @PLACE(64, 6);
//   #MPB2 @ORIENT("R0");
//   #MPB2:1 @TEXT("${net}", key="netname", size=0.6, halign="end", valign="middle", rotate=90, dx=0, dy=-0.4);
//   #MPB2:2 @TEXT("${net}", key="netname", size=0.6, halign="end", valign="middle", dx=-0.4, dy=0);
//   #MPB2:3 @TEXT("${net}", key="netname", size=0.6, halign="start", valign="middle", rotate=90, dx=0, dy=0.4);
//   %v18 = $SUPPLY @ATTACH &VREFP => @PLACE(67, 9.2);
//   &VREFP @WIRE {#MPB2:4 (67, 6) %v18:p};
//   #MNB2 @PLACE(80, -10);
//   #MNB2 @ORIENT("R0");
//   #MNB2:1 @TEXT("${net}", key="netname", size=0.6, halign="start", valign="middle", rotate=90, dx=0, dy=0.4);
//   #MNB2:2 @TEXT("${net}", key="netname", size=0.6, halign="end", valign="middle", dx=-0.4, dy=0);
//   %g19 = $GROUND @ATTACH &VREFN => @PLACE(80, -15.2);
//   &VREFN @WIRE {#MNB2:3 (80, -12) %g19:p};
//   %g20 = $GROUND @ATTACH &VSS => @PLACE(83, -13.2);
//   &VSS @WIRE {#MNB2:4 (83, -10) %g20:p};
//   #MFNN @PLACE(108, 12);
//   #MFNN @ORIENT("R0");
//   #MFNN:1 @TEXT("${net}", key="netname", size=0.6, halign="start", valign="middle", rotate=90, dx=0, dy=0.4);
//   #MFNN:2 @TEXT("${net}", key="netname", size=0.6, halign="end", valign="middle", dx=-0.4, dy=0);
//   %g21 = $GROUND @ATTACH &VREFN => @PLACE(108, 6.8);
//   &VREFN @WIRE {#MFNN:3 (108, 10) %g21:p};
//   %g22 = $GROUND @ATTACH &VSS => @PLACE(111, 8.8);
//   &VSS @WIRE {#MFNN:4 (111, 12) %g22:p};
//   #MFNP @PLACE(108, 22);
//   #MFNP @ORIENT("R0");
//   #MFNP:1 @TEXT("${net}", key="netname", size=0.6, halign="end", valign="middle", rotate=90, dx=0, dy=-0.4);
//   #MFNP:2 @TEXT("${net}", key="netname", size=0.6, halign="end", valign="middle", dx=-0.4, dy=0);
//   %v23 = $SUPPLY @ATTACH &VREFP => @PLACE(108, 27.2);
//   &VREFP @WIRE {#MFNP:3 (108, 24) %v23:p};
//   %v24 = $SUPPLY @ATTACH &VREFP => @PLACE(111, 25.2);
//   &VREFP @WIRE {#MFNP:4 (111, 22) %v24:p};
//   #MFPN @PLACE(136, 12);
//   #MFPN @ORIENT("R0");
//   #MFPN:1 @TEXT("${net}", key="netname", size=0.6, halign="start", valign="middle", rotate=90, dx=0, dy=0.4);
//   #MFPN:2 @TEXT("${net}", key="netname", size=0.6, halign="end", valign="middle", dx=-0.4, dy=0);
//   %g25 = $GROUND @ATTACH &VREFN => @PLACE(136, 6.8);
//   &VREFN @WIRE {#MFPN:3 (136, 10) %g25:p};
//   %g26 = $GROUND @ATTACH &VSS => @PLACE(139, 8.8);
//   &VSS @WIRE {#MFPN:4 (139, 12) %g26:p};
//   #MFPP @PLACE(136, 22);
//   #MFPP @ORIENT("R0");
//   #MFPP:1 @TEXT("${net}", key="netname", size=0.6, halign="end", valign="middle", rotate=90, dx=0, dy=-0.4);
//   #MFPP:2 @TEXT("${net}", key="netname", size=0.6, halign="end", valign="middle", dx=-0.4, dy=0);
//   %v27 = $SUPPLY @ATTACH &VREFP => @PLACE(136, 27.2);
//   &VREFP @WIRE {#MFPP:3 (136, 24) %v27:p};
//   %v28 = $SUPPLY @ATTACH &VREFP => @PLACE(139, 25.2);
//   &VREFP @WIRE {#MFPP:4 (139, 22) %v28:p};
//   #MNOUT @PLACE(168, 0);
//   #MNOUT @ORIENT("R0");
//   #MNOUT:1 @TEXT("${net}", key="netname", size=0.6, halign="start", valign="middle", rotate=90, dx=0, dy=0.4);
//   #MNOUT:2 @TEXT("${net}", key="netname", size=0.6, halign="end", valign="middle", dx=-0.4, dy=0);
//   %g29 = $GROUND @ATTACH &VREFN => @PLACE(168, -5.2);
//   &VREFN @WIRE {#MNOUT:3 (168, -2) %g29:p};
//   %g30 = $GROUND @ATTACH &VSS => @PLACE(171, -3.2);
//   &VSS @WIRE {#MNOUT:4 (171, 0) %g30:p};
//   #MPOUT @PLACE(168, 22);
//   #MPOUT @ORIENT("R0");
//   #MPOUT:1 @TEXT("${net}", key="netname", size=0.6, halign="end", valign="middle", rotate=90, dx=0, dy=-0.4);
//   #MPOUT:2 @TEXT("${net}", key="netname", size=0.6, halign="end", valign="middle", dx=-0.4, dy=0);
//   %v31 = $SUPPLY @ATTACH &VREFP => @PLACE(168, 27.2);
//   &VREFP @WIRE {#MPOUT:3 (168, 24) %v31:p};
//   %v32 = $SUPPLY @ATTACH &VREFP => @PLACE(171, 25.2);
//   &VREFP @WIRE {#MPOUT:4 (171, 22) %v32:p};
//   &NOFF @WIRE {#MFNN:1 #MFNP:1};
//   &GN @WIRE {#MFNN:2 (103, 12) (103, 22) #MFNP:2};
//   &PON @WIRE {#MFPN:1 #MFPP:1};
//   &GP @WIRE {#MFPN:2 (131, 12) (131, 22) #MFPP:2};
//   %gp_bus = (16, 22);
//   $JUNCTION @ATTACH %gp_bus;
//   &GP @WIRE {#MPA0:1 (0, 22) %gp_bus (32, 22) #MPA2:1};
//   &GP @WIRE {#MPA1:1 %gp_bus #MNA0:1};
//   &AN1 @WIRE {#MNA0:3 #MNA1:1};
//   &AN2 @WIRE {#MNA1:3 #MNA2:1};
//   &BP1 @WIRE {#MPB0:1 #MPB1:3};
//   &BP2 @WIRE {#MPB1:1 #MPB2:3};
//   %gn_bus = (64, -6);
//   $JUNCTION @ATTACH %gn_bus;
//   &GN @WIRE {#MNB0:1 (48, -6) %gn_bus (80, -6) #MNB2:1};
//   &GN @WIRE {#MNB1:1 %gn_bus #MPB2:1};
//   &BP @WIRE {#MNOUT:1 #MPOUT:1};
//   %p_hi = $IO_PORT @ATTACH &HI => @PLACE(9, 26) => @ORIENT("R0");
//   &HI @WIRE {%p_hi:p #MPA1:2};
//   %p_en = $IO_PORT @ATTACH &EN => @PLACE(-7, 26) => @ORIENT("R0");
//   &EN @WIRE {%p_en:p #MPA0:2};
//   %p_enb = $IO_PORT @ATTACH &ENB => @PLACE(57, 26) => @ORIENT("R0");
//   &ENB @WIRE {%p_enb:p #MPB0:2};
//   %p_bp = $IO_PORT @ATTACH &BP => @PLACE(168, 6) => @ORIENT("R270");
//   &BP @WIRE {%p_bp:p #MNOUT:1};
//   (-10, 48) @TEXT("Tristate nonoverlap driver j=3") => @SET-STYLE $title_style
// }
ends mq_cdac_drv3

// Matched half-capacitor pair j=3, weight 6
subckt mq_cdac_bit3 (VIN VG DH RL EN ENB TOP VREFP VREFN VSS)
// CP*: user-specified pre-layout estimate, 5% of each physical MOM unit to VSS.
// The second MOM terminal is its bottom plate; parallel multipliers are aggregated.
// Series tails add one unit parasitic at MID and one at B, not 5% of the equivalent half unit.
XHCTL (DH HHI VREFP VREFN VSS) mq_cdac_ctl_h
XLCTL (RL LHI VREFP VREFN VSS) mq_cdac_ctl_l
XDH (HHI EN ENB BH VREFP VREFN VSS) mq_cdac_drv3
CH (TOP BH) cfmom_2t w=5e-08 s=2.4e-07 nr=6 lr=1.69e-06 stm=2 spm=4 multi=3
CPH (BH VSS) capacitor c=1.503435e-16
MSH (BH VG VIN VSS) nch_ulvt_mac w=1.2e-07 l=3e-08 nf=1
XDL (LHI EN ENB BL VREFP VREFN VSS) mq_cdac_drv3
CL (TOP BL) cfmom_2t w=5e-08 s=2.4e-07 nr=6 lr=1.69e-06 stm=2 spm=4 multi=3
CPL (BL VSS) capacitor c=1.503435e-16
MSL (BL VG VIN VSS) nch_ulvt_mac w=1.2e-07 l=3e-08 nf=1
// @RNL {
//   /* pins connected by net name: the net-name label of rnl-std-fill on every unwired pin, placed below by its key netname */
//   $LABEL_TERMINAL_SET @TEXT("${net}", key="netname", size=0.6);
//   &VSS @ADD-TO $GROUND_NET_SET; &VREFN @ADD-TO $GROUND_NET_SET; &VREFP @ADD-TO $SUPPLY_NET_SET;
//   {#CH #CL} @AS $MATCHED;
//   {#MSH #MSL} @AS $MATCHED;
//   {#XDH #XDL} @AS $MATCHED;
//   #XHCTL @PLACE(-70, 24);
//   #XHCTL @ORIENT("R0");
//   #XHCTL:IN @TEXT("${net}", key="netname", size=0.6, halign="end", valign="middle", dx=-0.4, dy=0);
//   #XHCTL:HI @TEXT("${net}", key="netname", size=0.6, halign="start", valign="middle", dx=0.4, dy=0);
//   %v1 = $SUPPLY @ATTACH &VREFP => @PLACE(-70, 31.2);
//   &VREFP @WIRE {#XHCTL:VREFP (-70, 28) %v1:p};
//   %g2 = $GROUND @ATTACH &VREFN => @PLACE(-72, 16.8);
//   &VREFN @WIRE {#XHCTL:VREFN (-72, 20) %g2:p};
//   %g3 = $GROUND @ATTACH &VSS => @PLACE(-68, 16.8);
//   &VSS @WIRE {#XHCTL:VSS (-68, 20) %g3:p};
//   #XLCTL @PLACE(-70, -26);
//   #XLCTL @ORIENT("R0");
//   #XLCTL:IN @TEXT("${net}", key="netname", size=0.6, halign="end", valign="middle", dx=-0.4, dy=0);
//   #XLCTL:HI @TEXT("${net}", key="netname", size=0.6, halign="start", valign="middle", dx=0.4, dy=0);
//   %v4 = $SUPPLY @ATTACH &VREFP => @PLACE(-70, -18.8);
//   &VREFP @WIRE {#XLCTL:VREFP (-70, -22) %v4:p};
//   %g5 = $GROUND @ATTACH &VREFN => @PLACE(-72, -33.2);
//   &VREFN @WIRE {#XLCTL:VREFN (-72, -30) %g5:p};
//   %g6 = $GROUND @ATTACH &VSS => @PLACE(-68, -33.2);
//   &VSS @WIRE {#XLCTL:VSS (-68, -30) %g6:p};
//   #XDH @PLACE(-34, 24);
//   #XDH @ORIENT("R0");
//   #XDH:HI @TEXT("${net}", key="netname", size=0.6, halign="end", valign="middle", dx=-0.4, dy=0);
//   #XDH:EN @TEXT("${net}", key="netname", size=0.6, halign="end", valign="middle", dx=-0.4, dy=0);
//   #XDH:ENB @TEXT("${net}", key="netname", size=0.6, halign="end", valign="middle", dx=-0.4, dy=0);
//   #XDH:BP @TEXT("${net}", key="netname", size=0.6, halign="start", valign="middle", dx=0.4, dy=0);
//   %v7 = $SUPPLY @ATTACH &VREFP => @PLACE(-34, 32.2);
//   &VREFP @WIRE {#XDH:VREFP (-34, 29) %v7:p};
//   %g8 = $GROUND @ATTACH &VREFN => @PLACE(-36, 15.8);
//   &VREFN @WIRE {#XDH:VREFN (-36, 19) %g8:p};
//   %g9 = $GROUND @ATTACH &VSS => @PLACE(-32, 15.8);
//   &VSS @WIRE {#XDH:VSS (-32, 19) %g9:p};
//   #CH @PLACE(14, 24) => @ORIENT("R270");
//   #CH:1 @TEXT("${net}", key="netname", size=0.6, halign="start", valign="middle", dx=0.4, dy=0);
//   #CH:2 @TEXT("${net}", key="netname", size=0.6, halign="end", valign="middle", dx=-0.4, dy=0);
//   #CPH @PLACE(60, 20);
//   #CPH @ORIENT("R0");
//   #CPH:1 @TEXT("${net}", key="netname", size=0.6, halign="start", valign="middle", rotate=90, dx=0, dy=0.4);
//   %g10 = $GROUND @ATTACH &VSS => @PLACE(60, 14.8);
//   &VSS @WIRE {#CPH:2 (60, 18) %g10:p};
//   #MSH @PLACE(2, 8);
//   #MSH @ORIENT("R0");
//   #MSH:1 @TEXT("${net}", key="netname", size=0.6, halign="start", valign="middle", rotate=90, dx=0, dy=0.4);
//   #MSH:2 @TEXT("${net}", key="netname", size=0.6, halign="end", valign="middle", dx=-0.4, dy=0);
//   #MSH:3 @TEXT("${net}", key="netname", size=0.6, halign="end", valign="middle", rotate=90, dx=0, dy=-0.4);
//   %g11 = $GROUND @ATTACH &VSS => @PLACE(5, 4.8);
//   &VSS @WIRE {#MSH:4 (5, 8) %g11:p};
//   #XDL @PLACE(-34, -26);
//   #XDL @ORIENT("R0");
//   #XDL:HI @TEXT("${net}", key="netname", size=0.6, halign="end", valign="middle", dx=-0.4, dy=0);
//   #XDL:EN @TEXT("${net}", key="netname", size=0.6, halign="end", valign="middle", dx=-0.4, dy=0);
//   #XDL:ENB @TEXT("${net}", key="netname", size=0.6, halign="end", valign="middle", dx=-0.4, dy=0);
//   #XDL:BP @TEXT("${net}", key="netname", size=0.6, halign="start", valign="middle", dx=0.4, dy=0);
//   %v12 = $SUPPLY @ATTACH &VREFP => @PLACE(-34, -17.8);
//   &VREFP @WIRE {#XDL:VREFP (-34, -21) %v12:p};
//   %g13 = $GROUND @ATTACH &VREFN => @PLACE(-36, -34.2);
//   &VREFN @WIRE {#XDL:VREFN (-36, -31) %g13:p};
//   %g14 = $GROUND @ATTACH &VSS => @PLACE(-32, -34.2);
//   &VSS @WIRE {#XDL:VSS (-32, -31) %g14:p};
//   #CL @PLACE(14, -26) => @ORIENT("R270");
//   #CL:1 @TEXT("${net}", key="netname", size=0.6, halign="start", valign="middle", dx=0.4, dy=0);
//   #CL:2 @TEXT("${net}", key="netname", size=0.6, halign="end", valign="middle", dx=-0.4, dy=0);
//   #CPL @PLACE(60, -30);
//   #CPL @ORIENT("R0");
//   #CPL:1 @TEXT("${net}", key="netname", size=0.6, halign="start", valign="middle", rotate=90, dx=0, dy=0.4);
//   %g15 = $GROUND @ATTACH &VSS => @PLACE(60, -35.2);
//   &VSS @WIRE {#CPL:2 (60, -32) %g15:p};
//   #MSL @PLACE(2, -42);
//   #MSL @ORIENT("R0");
//   #MSL:1 @TEXT("${net}", key="netname", size=0.6, halign="start", valign="middle", rotate=90, dx=0, dy=0.4);
//   #MSL:2 @TEXT("${net}", key="netname", size=0.6, halign="end", valign="middle", dx=-0.4, dy=0);
//   #MSL:3 @TEXT("${net}", key="netname", size=0.6, halign="end", valign="middle", rotate=90, dx=0, dy=-0.4);
//   %g16 = $GROUND @ATTACH &VSS => @PLACE(5, -45.2);
//   &VSS @WIRE {#MSL:4 (5, -42) %g16:p};
//   &HHI @WIRE {#XHCTL:HI (-52, 24) (-52, 26) #XDH:HI};
//   %b_H = (-12, 24);
//   $JUNCTION @ATTACH %b_H;
//   &BH @WIRE {#XDH:BP %b_H};
//   &BH @WIRE {%b_H #CH:2};
//   &BH @WIRE {%b_H (-12, 10) #MSH:1};
//   &LHI @WIRE {#XLCTL:HI (-52, -26) (-52, -24) #XDL:HI};
//   %b_L = (-12, -26);
//   $JUNCTION @ATTACH %b_L;
//   &BL @WIRE {#XDL:BP %b_L};
//   &BL @WIRE {%b_L #CL:2};
//   &BL @WIRE {%b_L (-12, -40) #MSL:1};
//   &VIN @WIRE {#MSH:3 (6, 6) (6, -44) #MSL:3};
//   &VG @WIRE {#MSH:2 (-5, 8) (-5, -42) #MSL:2};
//   %top_H = (44, 24);
//   $JUNCTION @ATTACH %top_H;
//   %top_L = (44, -26);
//   $JUNCTION @ATTACH %top_L;
//   &TOP @WIRE {#CH:1 %top_H};
//   &TOP @WIRE {#CL:1 %top_L};
//   &TOP @WIRE {%top_H %top_L};
//   %p_vin = $IO_PORT @ATTACH &VIN => @PLACE(2, 2) => @ORIENT("R90");
//   &VIN @WIRE {%p_vin:p #MSH:3};
//   %p_vg = $IO_PORT @ATTACH &VG => @PLACE(-5, 8) => @ORIENT("R0");
//   &VG @WIRE {%p_vg:p #MSH:2};
//   %p_dh = $IO_PORT @ATTACH &DH => @PLACE(-81, 24) => @ORIENT("R0");
//   &DH @WIRE {%p_dh:p #XHCTL:IN};
//   %p_rl = $IO_PORT @ATTACH &RL => @PLACE(-81, -26) => @ORIENT("R0");
//   &RL @WIRE {%p_rl:p #XLCTL:IN};
//   %p_en = $IO_PORT @ATTACH &EN => @PLACE(-45, 24) => @ORIENT("R0");
//   &EN @WIRE {%p_en:p #XDH:EN};
//   %p_enb = $IO_PORT @ATTACH &ENB => @PLACE(-45, 22) => @ORIENT("R0");
//   &ENB @WIRE {%p_enb:p #XDH:ENB};
//   %p_top = $IO_PORT @ATTACH &TOP => @PLACE(20, 24) => @ORIENT("MY");
//   &TOP @WIRE {%p_top:p #CH:1};
//   (-10, 46) @TEXT("Matched half-capacitor pair j=3, weight 6") => @SET-STYLE $title_style
// }
ends mq_cdac_bit3

// Tristate nonoverlap driver j=2
subckt mq_cdac_drv2 (HI EN ENB BP VREFP VREFN VSS)
// GP = NAND(EN, HI, NOT(GN)); GN = NOR(ENB, HI, NOT(GP)).
// Feedback senses the opposite output-device gate; each turn-on waits for the opposite turn-off.
MPA0 (GP EN VREFP VREFP) pch_ulvt_mac w=1.2e-07 l=3e-08 nf=1
MNA0 (GP EN AN1 VSS) nch_ulvt_mac w=2.4e-07 l=3e-08 nf=1
MPA1 (GP HI VREFP VREFP) pch_ulvt_mac w=1.2e-07 l=3e-08 nf=1
MNA1 (AN1 HI AN2 VSS) nch_ulvt_mac w=2.4e-07 l=3e-08 nf=1
MPA2 (GP NOFF VREFP VREFP) pch_ulvt_mac w=1.2e-07 l=3e-08 nf=1
MNA2 (AN2 NOFF VREFN VSS) nch_ulvt_mac w=2.4e-07 l=3e-08 nf=1
MPB0 (BP1 ENB VREFP VREFP) pch_ulvt_mac w=3.6e-07 l=3e-08 nf=1
MNB0 (GN ENB VREFN VSS) nch_ulvt_mac w=1.2e-07 l=3e-08 nf=1
MPB1 (BP2 HI BP1 VREFP) pch_ulvt_mac w=3.6e-07 l=3e-08 nf=1
MNB1 (GN HI VREFN VSS) nch_ulvt_mac w=1.2e-07 l=3e-08 nf=1
MPB2 (GN PON BP2 VREFP) pch_ulvt_mac w=3.6e-07 l=3e-08 nf=1
MNB2 (GN PON VREFN VSS) nch_ulvt_mac w=1.2e-07 l=3e-08 nf=1
MFNN (NOFF GN VREFN VSS) nch_ulvt_mac w=1.2e-07 l=3e-08 nf=1
MFNP (NOFF GN VREFP VREFP) pch_ulvt_mac w=2.4e-07 l=3e-08 nf=1
MFPN (PON GP VREFN VSS) nch_ulvt_mac w=1.2e-07 l=3e-08 nf=1
MFPP (PON GP VREFP VREFP) pch_ulvt_mac w=2.4e-07 l=3e-08 nf=1
MNOUT (BP GN VREFN VSS) nch_ulvt_mac w=6e-07 l=3e-08 nf=1
MPOUT (BP GP VREFP VREFP) pch_ulvt_mac w=1.2e-06 l=3e-08 nf=1
// @RNL {
//   /* pins connected by net name: the net-name label of rnl-std-fill on every unwired pin, placed below by its key netname */
//   $LABEL_TERMINAL_SET @TEXT("${net}", key="netname", size=0.6);
//   &VSS @ADD-TO $GROUND_NET_SET; &VREFN @ADD-TO $GROUND_NET_SET; &VREFP @ADD-TO $SUPPLY_NET_SET;
//   {#MFNN #MFNP} @GROUP;
//   {#MFPN #MFPP} @GROUP;
//   {#MPA0 #MPA1 #MPA2 #MNA0 #MNA1 #MNA2} @GROUP;
//   {#MPB0 #MPB1 #MPB2 #MNB0 #MNB1 #MNB2} @GROUP;
//   {#MNOUT #MPOUT} @GROUP;
//   #MPA0 @PLACE(0, 26);
//   #MPA0 @ORIENT("R0");
//   #MPA0:1 @TEXT("${net}", key="netname", size=0.6, halign="end", valign="middle", rotate=90, dx=0, dy=-0.4);
//   #MPA0:2 @TEXT("${net}", key="netname", size=0.6, halign="end", valign="middle", dx=-0.4, dy=0);
//   %v1 = $SUPPLY @ATTACH &VREFP => @PLACE(0, 31.2);
//   &VREFP @WIRE {#MPA0:3 (0, 28) %v1:p};
//   %v2 = $SUPPLY @ATTACH &VREFP => @PLACE(3, 29.2);
//   &VREFP @WIRE {#MPA0:4 (3, 26) %v2:p};
//   #MNA0 @PLACE(16, 12);
//   #MNA0 @ORIENT("R0");
//   #MNA0:1 @TEXT("${net}", key="netname", size=0.6, halign="start", valign="middle", rotate=90, dx=0, dy=0.4);
//   #MNA0:2 @TEXT("${net}", key="netname", size=0.6, halign="end", valign="middle", dx=-0.4, dy=0);
//   #MNA0:3 @TEXT("${net}", key="netname", size=0.6, halign="end", valign="middle", rotate=90, dx=0, dy=-0.4);
//   %g3 = $GROUND @ATTACH &VSS => @PLACE(19, 8.8);
//   &VSS @WIRE {#MNA0:4 (19, 12) %g3:p};
//   #MPA1 @PLACE(16, 26);
//   #MPA1 @ORIENT("R0");
//   #MPA1:1 @TEXT("${net}", key="netname", size=0.6, halign="end", valign="middle", rotate=90, dx=0, dy=-0.4);
//   #MPA1:2 @TEXT("${net}", key="netname", size=0.6, halign="end", valign="middle", dx=-0.4, dy=0);
//   %v4 = $SUPPLY @ATTACH &VREFP => @PLACE(16, 31.2);
//   &VREFP @WIRE {#MPA1:3 (16, 28) %v4:p};
//   %v5 = $SUPPLY @ATTACH &VREFP => @PLACE(19, 29.2);
//   &VREFP @WIRE {#MPA1:4 (19, 26) %v5:p};
//   #MNA1 @PLACE(16, 2);
//   #MNA1 @ORIENT("R0");
//   #MNA1:1 @TEXT("${net}", key="netname", size=0.6, halign="start", valign="middle", rotate=90, dx=0, dy=0.4);
//   #MNA1:2 @TEXT("${net}", key="netname", size=0.6, halign="end", valign="middle", dx=-0.4, dy=0);
//   #MNA1:3 @TEXT("${net}", key="netname", size=0.6, halign="end", valign="middle", rotate=90, dx=0, dy=-0.4);
//   %g6 = $GROUND @ATTACH &VSS => @PLACE(19, -1.2);
//   &VSS @WIRE {#MNA1:4 (19, 2) %g6:p};
//   #MPA2 @PLACE(32, 26);
//   #MPA2 @ORIENT("R0");
//   #MPA2:1 @TEXT("${net}", key="netname", size=0.6, halign="end", valign="middle", rotate=90, dx=0, dy=-0.4);
//   #MPA2:2 @TEXT("${net}", key="netname", size=0.6, halign="end", valign="middle", dx=-0.4, dy=0);
//   %v7 = $SUPPLY @ATTACH &VREFP => @PLACE(32, 31.2);
//   &VREFP @WIRE {#MPA2:3 (32, 28) %v7:p};
//   %v8 = $SUPPLY @ATTACH &VREFP => @PLACE(35, 29.2);
//   &VREFP @WIRE {#MPA2:4 (35, 26) %v8:p};
//   #MNA2 @PLACE(16, -8);
//   #MNA2 @ORIENT("R0");
//   #MNA2:1 @TEXT("${net}", key="netname", size=0.6, halign="start", valign="middle", rotate=90, dx=0, dy=0.4);
//   #MNA2:2 @TEXT("${net}", key="netname", size=0.6, halign="end", valign="middle", dx=-0.4, dy=0);
//   %g9 = $GROUND @ATTACH &VREFN => @PLACE(16, -13.2);
//   &VREFN @WIRE {#MNA2:3 (16, -10) %g9:p};
//   %g10 = $GROUND @ATTACH &VSS => @PLACE(19, -11.2);
//   &VSS @WIRE {#MNA2:4 (19, -8) %g10:p};
//   #MPB0 @PLACE(64, 26);
//   #MPB0 @ORIENT("R0");
//   #MPB0:1 @TEXT("${net}", key="netname", size=0.6, halign="end", valign="middle", rotate=90, dx=0, dy=-0.4);
//   #MPB0:2 @TEXT("${net}", key="netname", size=0.6, halign="end", valign="middle", dx=-0.4, dy=0);
//   %v11 = $SUPPLY @ATTACH &VREFP => @PLACE(64, 31.2);
//   &VREFP @WIRE {#MPB0:3 (64, 28) %v11:p};
//   %v12 = $SUPPLY @ATTACH &VREFP => @PLACE(67, 29.2);
//   &VREFP @WIRE {#MPB0:4 (67, 26) %v12:p};
//   #MNB0 @PLACE(48, -10);
//   #MNB0 @ORIENT("R0");
//   #MNB0:1 @TEXT("${net}", key="netname", size=0.6, halign="start", valign="middle", rotate=90, dx=0, dy=0.4);
//   #MNB0:2 @TEXT("${net}", key="netname", size=0.6, halign="end", valign="middle", dx=-0.4, dy=0);
//   %g13 = $GROUND @ATTACH &VREFN => @PLACE(48, -15.2);
//   &VREFN @WIRE {#MNB0:3 (48, -12) %g13:p};
//   %g14 = $GROUND @ATTACH &VSS => @PLACE(51, -13.2);
//   &VSS @WIRE {#MNB0:4 (51, -10) %g14:p};
//   #MPB1 @PLACE(64, 16);
//   #MPB1 @ORIENT("R0");
//   #MPB1:1 @TEXT("${net}", key="netname", size=0.6, halign="end", valign="middle", rotate=90, dx=0, dy=-0.4);
//   #MPB1:2 @TEXT("${net}", key="netname", size=0.6, halign="end", valign="middle", dx=-0.4, dy=0);
//   #MPB1:3 @TEXT("${net}", key="netname", size=0.6, halign="start", valign="middle", rotate=90, dx=0, dy=0.4);
//   %v15 = $SUPPLY @ATTACH &VREFP => @PLACE(67, 19.2);
//   &VREFP @WIRE {#MPB1:4 (67, 16) %v15:p};
//   #MNB1 @PLACE(64, -10);
//   #MNB1 @ORIENT("R0");
//   #MNB1:1 @TEXT("${net}", key="netname", size=0.6, halign="start", valign="middle", rotate=90, dx=0, dy=0.4);
//   #MNB1:2 @TEXT("${net}", key="netname", size=0.6, halign="end", valign="middle", dx=-0.4, dy=0);
//   %g16 = $GROUND @ATTACH &VREFN => @PLACE(64, -15.2);
//   &VREFN @WIRE {#MNB1:3 (64, -12) %g16:p};
//   %g17 = $GROUND @ATTACH &VSS => @PLACE(67, -13.2);
//   &VSS @WIRE {#MNB1:4 (67, -10) %g17:p};
//   #MPB2 @PLACE(64, 6);
//   #MPB2 @ORIENT("R0");
//   #MPB2:1 @TEXT("${net}", key="netname", size=0.6, halign="end", valign="middle", rotate=90, dx=0, dy=-0.4);
//   #MPB2:2 @TEXT("${net}", key="netname", size=0.6, halign="end", valign="middle", dx=-0.4, dy=0);
//   #MPB2:3 @TEXT("${net}", key="netname", size=0.6, halign="start", valign="middle", rotate=90, dx=0, dy=0.4);
//   %v18 = $SUPPLY @ATTACH &VREFP => @PLACE(67, 9.2);
//   &VREFP @WIRE {#MPB2:4 (67, 6) %v18:p};
//   #MNB2 @PLACE(80, -10);
//   #MNB2 @ORIENT("R0");
//   #MNB2:1 @TEXT("${net}", key="netname", size=0.6, halign="start", valign="middle", rotate=90, dx=0, dy=0.4);
//   #MNB2:2 @TEXT("${net}", key="netname", size=0.6, halign="end", valign="middle", dx=-0.4, dy=0);
//   %g19 = $GROUND @ATTACH &VREFN => @PLACE(80, -15.2);
//   &VREFN @WIRE {#MNB2:3 (80, -12) %g19:p};
//   %g20 = $GROUND @ATTACH &VSS => @PLACE(83, -13.2);
//   &VSS @WIRE {#MNB2:4 (83, -10) %g20:p};
//   #MFNN @PLACE(108, 12);
//   #MFNN @ORIENT("R0");
//   #MFNN:1 @TEXT("${net}", key="netname", size=0.6, halign="start", valign="middle", rotate=90, dx=0, dy=0.4);
//   #MFNN:2 @TEXT("${net}", key="netname", size=0.6, halign="end", valign="middle", dx=-0.4, dy=0);
//   %g21 = $GROUND @ATTACH &VREFN => @PLACE(108, 6.8);
//   &VREFN @WIRE {#MFNN:3 (108, 10) %g21:p};
//   %g22 = $GROUND @ATTACH &VSS => @PLACE(111, 8.8);
//   &VSS @WIRE {#MFNN:4 (111, 12) %g22:p};
//   #MFNP @PLACE(108, 22);
//   #MFNP @ORIENT("R0");
//   #MFNP:1 @TEXT("${net}", key="netname", size=0.6, halign="end", valign="middle", rotate=90, dx=0, dy=-0.4);
//   #MFNP:2 @TEXT("${net}", key="netname", size=0.6, halign="end", valign="middle", dx=-0.4, dy=0);
//   %v23 = $SUPPLY @ATTACH &VREFP => @PLACE(108, 27.2);
//   &VREFP @WIRE {#MFNP:3 (108, 24) %v23:p};
//   %v24 = $SUPPLY @ATTACH &VREFP => @PLACE(111, 25.2);
//   &VREFP @WIRE {#MFNP:4 (111, 22) %v24:p};
//   #MFPN @PLACE(136, 12);
//   #MFPN @ORIENT("R0");
//   #MFPN:1 @TEXT("${net}", key="netname", size=0.6, halign="start", valign="middle", rotate=90, dx=0, dy=0.4);
//   #MFPN:2 @TEXT("${net}", key="netname", size=0.6, halign="end", valign="middle", dx=-0.4, dy=0);
//   %g25 = $GROUND @ATTACH &VREFN => @PLACE(136, 6.8);
//   &VREFN @WIRE {#MFPN:3 (136, 10) %g25:p};
//   %g26 = $GROUND @ATTACH &VSS => @PLACE(139, 8.8);
//   &VSS @WIRE {#MFPN:4 (139, 12) %g26:p};
//   #MFPP @PLACE(136, 22);
//   #MFPP @ORIENT("R0");
//   #MFPP:1 @TEXT("${net}", key="netname", size=0.6, halign="end", valign="middle", rotate=90, dx=0, dy=-0.4);
//   #MFPP:2 @TEXT("${net}", key="netname", size=0.6, halign="end", valign="middle", dx=-0.4, dy=0);
//   %v27 = $SUPPLY @ATTACH &VREFP => @PLACE(136, 27.2);
//   &VREFP @WIRE {#MFPP:3 (136, 24) %v27:p};
//   %v28 = $SUPPLY @ATTACH &VREFP => @PLACE(139, 25.2);
//   &VREFP @WIRE {#MFPP:4 (139, 22) %v28:p};
//   #MNOUT @PLACE(168, 0);
//   #MNOUT @ORIENT("R0");
//   #MNOUT:1 @TEXT("${net}", key="netname", size=0.6, halign="start", valign="middle", rotate=90, dx=0, dy=0.4);
//   #MNOUT:2 @TEXT("${net}", key="netname", size=0.6, halign="end", valign="middle", dx=-0.4, dy=0);
//   %g29 = $GROUND @ATTACH &VREFN => @PLACE(168, -5.2);
//   &VREFN @WIRE {#MNOUT:3 (168, -2) %g29:p};
//   %g30 = $GROUND @ATTACH &VSS => @PLACE(171, -3.2);
//   &VSS @WIRE {#MNOUT:4 (171, 0) %g30:p};
//   #MPOUT @PLACE(168, 22);
//   #MPOUT @ORIENT("R0");
//   #MPOUT:1 @TEXT("${net}", key="netname", size=0.6, halign="end", valign="middle", rotate=90, dx=0, dy=-0.4);
//   #MPOUT:2 @TEXT("${net}", key="netname", size=0.6, halign="end", valign="middle", dx=-0.4, dy=0);
//   %v31 = $SUPPLY @ATTACH &VREFP => @PLACE(168, 27.2);
//   &VREFP @WIRE {#MPOUT:3 (168, 24) %v31:p};
//   %v32 = $SUPPLY @ATTACH &VREFP => @PLACE(171, 25.2);
//   &VREFP @WIRE {#MPOUT:4 (171, 22) %v32:p};
//   &NOFF @WIRE {#MFNN:1 #MFNP:1};
//   &GN @WIRE {#MFNN:2 (103, 12) (103, 22) #MFNP:2};
//   &PON @WIRE {#MFPN:1 #MFPP:1};
//   &GP @WIRE {#MFPN:2 (131, 12) (131, 22) #MFPP:2};
//   %gp_bus = (16, 22);
//   $JUNCTION @ATTACH %gp_bus;
//   &GP @WIRE {#MPA0:1 (0, 22) %gp_bus (32, 22) #MPA2:1};
//   &GP @WIRE {#MPA1:1 %gp_bus #MNA0:1};
//   &AN1 @WIRE {#MNA0:3 #MNA1:1};
//   &AN2 @WIRE {#MNA1:3 #MNA2:1};
//   &BP1 @WIRE {#MPB0:1 #MPB1:3};
//   &BP2 @WIRE {#MPB1:1 #MPB2:3};
//   %gn_bus = (64, -6);
//   $JUNCTION @ATTACH %gn_bus;
//   &GN @WIRE {#MNB0:1 (48, -6) %gn_bus (80, -6) #MNB2:1};
//   &GN @WIRE {#MNB1:1 %gn_bus #MPB2:1};
//   &BP @WIRE {#MNOUT:1 #MPOUT:1};
//   %p_hi = $IO_PORT @ATTACH &HI => @PLACE(9, 26) => @ORIENT("R0");
//   &HI @WIRE {%p_hi:p #MPA1:2};
//   %p_en = $IO_PORT @ATTACH &EN => @PLACE(-7, 26) => @ORIENT("R0");
//   &EN @WIRE {%p_en:p #MPA0:2};
//   %p_enb = $IO_PORT @ATTACH &ENB => @PLACE(57, 26) => @ORIENT("R0");
//   &ENB @WIRE {%p_enb:p #MPB0:2};
//   %p_bp = $IO_PORT @ATTACH &BP => @PLACE(168, 6) => @ORIENT("R270");
//   &BP @WIRE {%p_bp:p #MNOUT:1};
//   (-10, 48) @TEXT("Tristate nonoverlap driver j=2") => @SET-STYLE $title_style
// }
ends mq_cdac_drv2

// Matched half-capacitor pair j=2, weight 3
subckt mq_cdac_bit2 (VIN VG DH RL EN ENB TOP VREFP VREFN VSS)
// CP*: user-specified pre-layout estimate, 5% of each physical MOM unit to VSS.
// The second MOM terminal is its bottom plate; parallel multipliers are aggregated.
// Series tails add one unit parasitic at MID and one at B, not 5% of the equivalent half unit.
XHCTL (DH HHI VREFP VREFN VSS) mq_cdac_ctl_h
XLCTL (RL LHI VREFP VREFN VSS) mq_cdac_ctl_l
XDH (HHI EN ENB BH VREFP VREFN VSS) mq_cdac_drv2
CH (TOP BH) cfmom_2t w=5e-08 s=2.4e-07 nr=6 lr=1.69e-06 stm=2 spm=4 multi=1
CPH (BH VSS) capacitor c=5.01145e-17
CHA (TOP MIDH) cfmom_2t w=5e-08 s=2.4e-07 nr=6 lr=1.69e-06 stm=2 spm=4 multi=1
CPHA (MIDH VSS) capacitor c=5.01145e-17
CHB (MIDH BH) cfmom_2t w=5e-08 s=2.4e-07 nr=6 lr=1.69e-06 stm=2 spm=4 multi=1
CPHB (BH VSS) capacitor c=5.01145e-17
MSH (BH VG VIN VSS) nch_ulvt_mac w=1.2e-07 l=3e-08 nf=1
XDL (LHI EN ENB BL VREFP VREFN VSS) mq_cdac_drv2
CL (TOP BL) cfmom_2t w=5e-08 s=2.4e-07 nr=6 lr=1.69e-06 stm=2 spm=4 multi=1
CPL (BL VSS) capacitor c=5.01145e-17
CLA (TOP MIDL) cfmom_2t w=5e-08 s=2.4e-07 nr=6 lr=1.69e-06 stm=2 spm=4 multi=1
CPLA (MIDL VSS) capacitor c=5.01145e-17
CLB (MIDL BL) cfmom_2t w=5e-08 s=2.4e-07 nr=6 lr=1.69e-06 stm=2 spm=4 multi=1
CPLB (BL VSS) capacitor c=5.01145e-17
MSL (BL VG VIN VSS) nch_ulvt_mac w=1.2e-07 l=3e-08 nf=1
// @RNL {
//   /* pins connected by net name: the net-name label of rnl-std-fill on every unwired pin, placed below by its key netname */
//   $LABEL_TERMINAL_SET @TEXT("${net}", key="netname", size=0.6);
//   &VSS @ADD-TO $GROUND_NET_SET; &VREFN @ADD-TO $GROUND_NET_SET; &VREFP @ADD-TO $SUPPLY_NET_SET;
//   {#CH #CL} @AS $MATCHED;
//   {#CHA #CHB #CLA #CLB} @AS $MATCHED;
//   {#CHA #CHB #CLA #CLB} @GROUP;
//   {#MSH #MSL} @AS $MATCHED;
//   {#XDH #XDL} @AS $MATCHED;
//   #XHCTL @PLACE(-70, 24);
//   #XHCTL @ORIENT("R0");
//   #XHCTL:IN @TEXT("${net}", key="netname", size=0.6, halign="end", valign="middle", dx=-0.4, dy=0);
//   #XHCTL:HI @TEXT("${net}", key="netname", size=0.6, halign="start", valign="middle", dx=0.4, dy=0);
//   %v1 = $SUPPLY @ATTACH &VREFP => @PLACE(-70, 31.2);
//   &VREFP @WIRE {#XHCTL:VREFP (-70, 28) %v1:p};
//   %g2 = $GROUND @ATTACH &VREFN => @PLACE(-72, 16.8);
//   &VREFN @WIRE {#XHCTL:VREFN (-72, 20) %g2:p};
//   %g3 = $GROUND @ATTACH &VSS => @PLACE(-68, 16.8);
//   &VSS @WIRE {#XHCTL:VSS (-68, 20) %g3:p};
//   #XLCTL @PLACE(-70, -26);
//   #XLCTL @ORIENT("R0");
//   #XLCTL:IN @TEXT("${net}", key="netname", size=0.6, halign="end", valign="middle", dx=-0.4, dy=0);
//   #XLCTL:HI @TEXT("${net}", key="netname", size=0.6, halign="start", valign="middle", dx=0.4, dy=0);
//   %v4 = $SUPPLY @ATTACH &VREFP => @PLACE(-70, -18.8);
//   &VREFP @WIRE {#XLCTL:VREFP (-70, -22) %v4:p};
//   %g5 = $GROUND @ATTACH &VREFN => @PLACE(-72, -33.2);
//   &VREFN @WIRE {#XLCTL:VREFN (-72, -30) %g5:p};
//   %g6 = $GROUND @ATTACH &VSS => @PLACE(-68, -33.2);
//   &VSS @WIRE {#XLCTL:VSS (-68, -30) %g6:p};
//   #XDH @PLACE(-34, 24);
//   #XDH @ORIENT("R0");
//   #XDH:HI @TEXT("${net}", key="netname", size=0.6, halign="end", valign="middle", dx=-0.4, dy=0);
//   #XDH:EN @TEXT("${net}", key="netname", size=0.6, halign="end", valign="middle", dx=-0.4, dy=0);
//   #XDH:ENB @TEXT("${net}", key="netname", size=0.6, halign="end", valign="middle", dx=-0.4, dy=0);
//   #XDH:BP @TEXT("${net}", key="netname", size=0.6, halign="start", valign="middle", dx=0.4, dy=0);
//   %v7 = $SUPPLY @ATTACH &VREFP => @PLACE(-34, 32.2);
//   &VREFP @WIRE {#XDH:VREFP (-34, 29) %v7:p};
//   %g8 = $GROUND @ATTACH &VREFN => @PLACE(-36, 15.8);
//   &VREFN @WIRE {#XDH:VREFN (-36, 19) %g8:p};
//   %g9 = $GROUND @ATTACH &VSS => @PLACE(-32, 15.8);
//   &VSS @WIRE {#XDH:VSS (-32, 19) %g9:p};
//   #CH @PLACE(14, 24) => @ORIENT("R270");
//   #CH:1 @TEXT("${net}", key="netname", size=0.6, halign="start", valign="middle", dx=0.4, dy=0);
//   #CH:2 @TEXT("${net}", key="netname", size=0.6, halign="end", valign="middle", dx=-0.4, dy=0);
//   #CPH @PLACE(60, 20);
//   #CPH @ORIENT("R0");
//   #CPH:1 @TEXT("${net}", key="netname", size=0.6, halign="start", valign="middle", rotate=90, dx=0, dy=0.4);
//   %g10 = $GROUND @ATTACH &VSS => @PLACE(60, 14.8);
//   &VSS @WIRE {#CPH:2 (60, 18) %g10:p};
//   #CHA @PLACE(30, 38) => @ORIENT("R270");
//   #CHA:1 @TEXT("${net}", key="netname", size=0.6, halign="start", valign="middle", dx=0.4, dy=0);
//   #CHA:2 @TEXT("${net}", key="netname", size=0.6, halign="end", valign="middle", dx=-0.4, dy=0);
//   #CPHA @PLACE(76, 20);
//   #CPHA @ORIENT("R0");
//   #CPHA:1 @TEXT("${net}", key="netname", size=0.6, halign="start", valign="middle", rotate=90, dx=0, dy=0.4);
//   %g11 = $GROUND @ATTACH &VSS => @PLACE(76, 14.8);
//   &VSS @WIRE {#CPHA:2 (76, 18) %g11:p};
//   #CHB @PLACE(10, 38) => @ORIENT("R270");
//   #CHB:1 @TEXT("${net}", key="netname", size=0.6, halign="start", valign="middle", dx=0.4, dy=0);
//   #CHB:2 @TEXT("${net}", key="netname", size=0.6, halign="end", valign="middle", dx=-0.4, dy=0);
//   #CPHB @PLACE(92, 20);
//   #CPHB @ORIENT("R0");
//   #CPHB:1 @TEXT("${net}", key="netname", size=0.6, halign="start", valign="middle", rotate=90, dx=0, dy=0.4);
//   %g12 = $GROUND @ATTACH &VSS => @PLACE(92, 14.8);
//   &VSS @WIRE {#CPHB:2 (92, 18) %g12:p};
//   #MSH @PLACE(2, 8);
//   #MSH @ORIENT("R0");
//   #MSH:1 @TEXT("${net}", key="netname", size=0.6, halign="start", valign="middle", rotate=90, dx=0, dy=0.4);
//   #MSH:2 @TEXT("${net}", key="netname", size=0.6, halign="end", valign="middle", dx=-0.4, dy=0);
//   #MSH:3 @TEXT("${net}", key="netname", size=0.6, halign="end", valign="middle", rotate=90, dx=0, dy=-0.4);
//   %g13 = $GROUND @ATTACH &VSS => @PLACE(5, 4.8);
//   &VSS @WIRE {#MSH:4 (5, 8) %g13:p};
//   #XDL @PLACE(-34, -26);
//   #XDL @ORIENT("R0");
//   #XDL:HI @TEXT("${net}", key="netname", size=0.6, halign="end", valign="middle", dx=-0.4, dy=0);
//   #XDL:EN @TEXT("${net}", key="netname", size=0.6, halign="end", valign="middle", dx=-0.4, dy=0);
//   #XDL:ENB @TEXT("${net}", key="netname", size=0.6, halign="end", valign="middle", dx=-0.4, dy=0);
//   #XDL:BP @TEXT("${net}", key="netname", size=0.6, halign="start", valign="middle", dx=0.4, dy=0);
//   %v14 = $SUPPLY @ATTACH &VREFP => @PLACE(-34, -17.8);
//   &VREFP @WIRE {#XDL:VREFP (-34, -21) %v14:p};
//   %g15 = $GROUND @ATTACH &VREFN => @PLACE(-36, -34.2);
//   &VREFN @WIRE {#XDL:VREFN (-36, -31) %g15:p};
//   %g16 = $GROUND @ATTACH &VSS => @PLACE(-32, -34.2);
//   &VSS @WIRE {#XDL:VSS (-32, -31) %g16:p};
//   #CL @PLACE(14, -26) => @ORIENT("R270");
//   #CL:1 @TEXT("${net}", key="netname", size=0.6, halign="start", valign="middle", dx=0.4, dy=0);
//   #CL:2 @TEXT("${net}", key="netname", size=0.6, halign="end", valign="middle", dx=-0.4, dy=0);
//   #CPL @PLACE(60, -30);
//   #CPL @ORIENT("R0");
//   #CPL:1 @TEXT("${net}", key="netname", size=0.6, halign="start", valign="middle", rotate=90, dx=0, dy=0.4);
//   %g17 = $GROUND @ATTACH &VSS => @PLACE(60, -35.2);
//   &VSS @WIRE {#CPL:2 (60, -32) %g17:p};
//   #CLA @PLACE(30, -12) => @ORIENT("R270");
//   #CLA:1 @TEXT("${net}", key="netname", size=0.6, halign="start", valign="middle", dx=0.4, dy=0);
//   #CLA:2 @TEXT("${net}", key="netname", size=0.6, halign="end", valign="middle", dx=-0.4, dy=0);
//   #CPLA @PLACE(76, -30);
//   #CPLA @ORIENT("R0");
//   #CPLA:1 @TEXT("${net}", key="netname", size=0.6, halign="start", valign="middle", rotate=90, dx=0, dy=0.4);
//   %g18 = $GROUND @ATTACH &VSS => @PLACE(76, -35.2);
//   &VSS @WIRE {#CPLA:2 (76, -32) %g18:p};
//   #CLB @PLACE(10, -12) => @ORIENT("R270");
//   #CLB:1 @TEXT("${net}", key="netname", size=0.6, halign="start", valign="middle", dx=0.4, dy=0);
//   #CLB:2 @TEXT("${net}", key="netname", size=0.6, halign="end", valign="middle", dx=-0.4, dy=0);
//   #CPLB @PLACE(92, -30);
//   #CPLB @ORIENT("R0");
//   #CPLB:1 @TEXT("${net}", key="netname", size=0.6, halign="start", valign="middle", rotate=90, dx=0, dy=0.4);
//   %g19 = $GROUND @ATTACH &VSS => @PLACE(92, -35.2);
//   &VSS @WIRE {#CPLB:2 (92, -32) %g19:p};
//   #MSL @PLACE(2, -42);
//   #MSL @ORIENT("R0");
//   #MSL:1 @TEXT("${net}", key="netname", size=0.6, halign="start", valign="middle", rotate=90, dx=0, dy=0.4);
//   #MSL:2 @TEXT("${net}", key="netname", size=0.6, halign="end", valign="middle", dx=-0.4, dy=0);
//   #MSL:3 @TEXT("${net}", key="netname", size=0.6, halign="end", valign="middle", rotate=90, dx=0, dy=-0.4);
//   %g20 = $GROUND @ATTACH &VSS => @PLACE(5, -45.2);
//   &VSS @WIRE {#MSL:4 (5, -42) %g20:p};
//   &HHI @WIRE {#XHCTL:HI (-52, 24) (-52, 26) #XDH:HI};
//   %b_H = (-12, 24);
//   $JUNCTION @ATTACH %b_H;
//   &BH @WIRE {#XDH:BP %b_H};
//   &BH @WIRE {%b_H #CH:2};
//   &MIDH @WIRE {#CHB:1 #CHA:2};
//   &BH @WIRE {%b_H (-12, 38) #CHB:2};
//   &BH @WIRE {%b_H (-12, 10) #MSH:1};
//   &LHI @WIRE {#XLCTL:HI (-52, -26) (-52, -24) #XDL:HI};
//   %b_L = (-12, -26);
//   $JUNCTION @ATTACH %b_L;
//   &BL @WIRE {#XDL:BP %b_L};
//   &BL @WIRE {%b_L #CL:2};
//   &MIDL @WIRE {#CLB:1 #CLA:2};
//   &BL @WIRE {%b_L (-12, -12) #CLB:2};
//   &BL @WIRE {%b_L (-12, -40) #MSL:1};
//   &VIN @WIRE {#MSH:3 (6, 6) (6, -44) #MSL:3};
//   &VG @WIRE {#MSH:2 (-5, 8) (-5, -42) #MSL:2};
//   %top_H = (44, 24);
//   $JUNCTION @ATTACH %top_H;
//   %top_L = (44, -26);
//   $JUNCTION @ATTACH %top_L;
//   &TOP @WIRE {#CHA:1 (44, 38) %top_H};
//   &TOP @WIRE {#CH:1 %top_H};
//   &TOP @WIRE {#CLA:1 (44, -12) %top_L};
//   &TOP @WIRE {#CL:1 %top_L};
//   &TOP @WIRE {%top_H %top_L};
//   %p_vin = $IO_PORT @ATTACH &VIN => @PLACE(2, 2) => @ORIENT("R90");
//   &VIN @WIRE {%p_vin:p #MSH:3};
//   %p_vg = $IO_PORT @ATTACH &VG => @PLACE(-5, 8) => @ORIENT("R0");
//   &VG @WIRE {%p_vg:p #MSH:2};
//   %p_dh = $IO_PORT @ATTACH &DH => @PLACE(-81, 24) => @ORIENT("R0");
//   &DH @WIRE {%p_dh:p #XHCTL:IN};
//   %p_rl = $IO_PORT @ATTACH &RL => @PLACE(-81, -26) => @ORIENT("R0");
//   &RL @WIRE {%p_rl:p #XLCTL:IN};
//   %p_en = $IO_PORT @ATTACH &EN => @PLACE(-45, 24) => @ORIENT("R0");
//   &EN @WIRE {%p_en:p #XDH:EN};
//   %p_enb = $IO_PORT @ATTACH &ENB => @PLACE(-45, 22) => @ORIENT("R0");
//   &ENB @WIRE {%p_enb:p #XDH:ENB};
//   %p_top = $IO_PORT @ATTACH &TOP => @PLACE(20, 24) => @ORIENT("MY");
//   &TOP @WIRE {%p_top:p #CH:1};
//   (-10, 60) @TEXT("Matched half-capacitor pair j=2, weight 3") => @SET-STYLE $title_style
// }
ends mq_cdac_bit2

// Tristate nonoverlap driver j=1
subckt mq_cdac_drv1 (HI EN ENB BP VREFP VREFN VSS)
// GP = NAND(EN, HI, NOT(GN)); GN = NOR(ENB, HI, NOT(GP)).
// Feedback senses the opposite output-device gate; each turn-on waits for the opposite turn-off.
MPA0 (GP EN VREFP VREFP) pch_ulvt_mac w=1.2e-07 l=3e-08 nf=1
MNA0 (GP EN AN1 VSS) nch_ulvt_mac w=2.4e-07 l=3e-08 nf=1
MPA1 (GP HI VREFP VREFP) pch_ulvt_mac w=1.2e-07 l=3e-08 nf=1
MNA1 (AN1 HI AN2 VSS) nch_ulvt_mac w=2.4e-07 l=3e-08 nf=1
MPA2 (GP NOFF VREFP VREFP) pch_ulvt_mac w=1.2e-07 l=3e-08 nf=1
MNA2 (AN2 NOFF VREFN VSS) nch_ulvt_mac w=2.4e-07 l=3e-08 nf=1
MPB0 (BP1 ENB VREFP VREFP) pch_ulvt_mac w=3.6e-07 l=3e-08 nf=1
MNB0 (GN ENB VREFN VSS) nch_ulvt_mac w=1.2e-07 l=3e-08 nf=1
MPB1 (BP2 HI BP1 VREFP) pch_ulvt_mac w=3.6e-07 l=3e-08 nf=1
MNB1 (GN HI VREFN VSS) nch_ulvt_mac w=1.2e-07 l=3e-08 nf=1
MPB2 (GN PON BP2 VREFP) pch_ulvt_mac w=3.6e-07 l=3e-08 nf=1
MNB2 (GN PON VREFN VSS) nch_ulvt_mac w=1.2e-07 l=3e-08 nf=1
MFNN (NOFF GN VREFN VSS) nch_ulvt_mac w=1.2e-07 l=3e-08 nf=1
MFNP (NOFF GN VREFP VREFP) pch_ulvt_mac w=2.4e-07 l=3e-08 nf=1
MFPN (PON GP VREFN VSS) nch_ulvt_mac w=1.2e-07 l=3e-08 nf=1
MFPP (PON GP VREFP VREFP) pch_ulvt_mac w=2.4e-07 l=3e-08 nf=1
MNOUT (BP GN VREFN VSS) nch_ulvt_mac w=6e-07 l=3e-08 nf=1
MPOUT (BP GP VREFP VREFP) pch_ulvt_mac w=1.2e-06 l=3e-08 nf=1
// @RNL {
//   /* pins connected by net name: the net-name label of rnl-std-fill on every unwired pin, placed below by its key netname */
//   $LABEL_TERMINAL_SET @TEXT("${net}", key="netname", size=0.6);
//   &VSS @ADD-TO $GROUND_NET_SET; &VREFN @ADD-TO $GROUND_NET_SET; &VREFP @ADD-TO $SUPPLY_NET_SET;
//   {#MFNN #MFNP} @GROUP;
//   {#MFPN #MFPP} @GROUP;
//   {#MPA0 #MPA1 #MPA2 #MNA0 #MNA1 #MNA2} @GROUP;
//   {#MPB0 #MPB1 #MPB2 #MNB0 #MNB1 #MNB2} @GROUP;
//   {#MNOUT #MPOUT} @GROUP;
//   #MPA0 @PLACE(0, 26);
//   #MPA0 @ORIENT("R0");
//   #MPA0:1 @TEXT("${net}", key="netname", size=0.6, halign="end", valign="middle", rotate=90, dx=0, dy=-0.4);
//   #MPA0:2 @TEXT("${net}", key="netname", size=0.6, halign="end", valign="middle", dx=-0.4, dy=0);
//   %v1 = $SUPPLY @ATTACH &VREFP => @PLACE(0, 31.2);
//   &VREFP @WIRE {#MPA0:3 (0, 28) %v1:p};
//   %v2 = $SUPPLY @ATTACH &VREFP => @PLACE(3, 29.2);
//   &VREFP @WIRE {#MPA0:4 (3, 26) %v2:p};
//   #MNA0 @PLACE(16, 12);
//   #MNA0 @ORIENT("R0");
//   #MNA0:1 @TEXT("${net}", key="netname", size=0.6, halign="start", valign="middle", rotate=90, dx=0, dy=0.4);
//   #MNA0:2 @TEXT("${net}", key="netname", size=0.6, halign="end", valign="middle", dx=-0.4, dy=0);
//   #MNA0:3 @TEXT("${net}", key="netname", size=0.6, halign="end", valign="middle", rotate=90, dx=0, dy=-0.4);
//   %g3 = $GROUND @ATTACH &VSS => @PLACE(19, 8.8);
//   &VSS @WIRE {#MNA0:4 (19, 12) %g3:p};
//   #MPA1 @PLACE(16, 26);
//   #MPA1 @ORIENT("R0");
//   #MPA1:1 @TEXT("${net}", key="netname", size=0.6, halign="end", valign="middle", rotate=90, dx=0, dy=-0.4);
//   #MPA1:2 @TEXT("${net}", key="netname", size=0.6, halign="end", valign="middle", dx=-0.4, dy=0);
//   %v4 = $SUPPLY @ATTACH &VREFP => @PLACE(16, 31.2);
//   &VREFP @WIRE {#MPA1:3 (16, 28) %v4:p};
//   %v5 = $SUPPLY @ATTACH &VREFP => @PLACE(19, 29.2);
//   &VREFP @WIRE {#MPA1:4 (19, 26) %v5:p};
//   #MNA1 @PLACE(16, 2);
//   #MNA1 @ORIENT("R0");
//   #MNA1:1 @TEXT("${net}", key="netname", size=0.6, halign="start", valign="middle", rotate=90, dx=0, dy=0.4);
//   #MNA1:2 @TEXT("${net}", key="netname", size=0.6, halign="end", valign="middle", dx=-0.4, dy=0);
//   #MNA1:3 @TEXT("${net}", key="netname", size=0.6, halign="end", valign="middle", rotate=90, dx=0, dy=-0.4);
//   %g6 = $GROUND @ATTACH &VSS => @PLACE(19, -1.2);
//   &VSS @WIRE {#MNA1:4 (19, 2) %g6:p};
//   #MPA2 @PLACE(32, 26);
//   #MPA2 @ORIENT("R0");
//   #MPA2:1 @TEXT("${net}", key="netname", size=0.6, halign="end", valign="middle", rotate=90, dx=0, dy=-0.4);
//   #MPA2:2 @TEXT("${net}", key="netname", size=0.6, halign="end", valign="middle", dx=-0.4, dy=0);
//   %v7 = $SUPPLY @ATTACH &VREFP => @PLACE(32, 31.2);
//   &VREFP @WIRE {#MPA2:3 (32, 28) %v7:p};
//   %v8 = $SUPPLY @ATTACH &VREFP => @PLACE(35, 29.2);
//   &VREFP @WIRE {#MPA2:4 (35, 26) %v8:p};
//   #MNA2 @PLACE(16, -8);
//   #MNA2 @ORIENT("R0");
//   #MNA2:1 @TEXT("${net}", key="netname", size=0.6, halign="start", valign="middle", rotate=90, dx=0, dy=0.4);
//   #MNA2:2 @TEXT("${net}", key="netname", size=0.6, halign="end", valign="middle", dx=-0.4, dy=0);
//   %g9 = $GROUND @ATTACH &VREFN => @PLACE(16, -13.2);
//   &VREFN @WIRE {#MNA2:3 (16, -10) %g9:p};
//   %g10 = $GROUND @ATTACH &VSS => @PLACE(19, -11.2);
//   &VSS @WIRE {#MNA2:4 (19, -8) %g10:p};
//   #MPB0 @PLACE(64, 26);
//   #MPB0 @ORIENT("R0");
//   #MPB0:1 @TEXT("${net}", key="netname", size=0.6, halign="end", valign="middle", rotate=90, dx=0, dy=-0.4);
//   #MPB0:2 @TEXT("${net}", key="netname", size=0.6, halign="end", valign="middle", dx=-0.4, dy=0);
//   %v11 = $SUPPLY @ATTACH &VREFP => @PLACE(64, 31.2);
//   &VREFP @WIRE {#MPB0:3 (64, 28) %v11:p};
//   %v12 = $SUPPLY @ATTACH &VREFP => @PLACE(67, 29.2);
//   &VREFP @WIRE {#MPB0:4 (67, 26) %v12:p};
//   #MNB0 @PLACE(48, -10);
//   #MNB0 @ORIENT("R0");
//   #MNB0:1 @TEXT("${net}", key="netname", size=0.6, halign="start", valign="middle", rotate=90, dx=0, dy=0.4);
//   #MNB0:2 @TEXT("${net}", key="netname", size=0.6, halign="end", valign="middle", dx=-0.4, dy=0);
//   %g13 = $GROUND @ATTACH &VREFN => @PLACE(48, -15.2);
//   &VREFN @WIRE {#MNB0:3 (48, -12) %g13:p};
//   %g14 = $GROUND @ATTACH &VSS => @PLACE(51, -13.2);
//   &VSS @WIRE {#MNB0:4 (51, -10) %g14:p};
//   #MPB1 @PLACE(64, 16);
//   #MPB1 @ORIENT("R0");
//   #MPB1:1 @TEXT("${net}", key="netname", size=0.6, halign="end", valign="middle", rotate=90, dx=0, dy=-0.4);
//   #MPB1:2 @TEXT("${net}", key="netname", size=0.6, halign="end", valign="middle", dx=-0.4, dy=0);
//   #MPB1:3 @TEXT("${net}", key="netname", size=0.6, halign="start", valign="middle", rotate=90, dx=0, dy=0.4);
//   %v15 = $SUPPLY @ATTACH &VREFP => @PLACE(67, 19.2);
//   &VREFP @WIRE {#MPB1:4 (67, 16) %v15:p};
//   #MNB1 @PLACE(64, -10);
//   #MNB1 @ORIENT("R0");
//   #MNB1:1 @TEXT("${net}", key="netname", size=0.6, halign="start", valign="middle", rotate=90, dx=0, dy=0.4);
//   #MNB1:2 @TEXT("${net}", key="netname", size=0.6, halign="end", valign="middle", dx=-0.4, dy=0);
//   %g16 = $GROUND @ATTACH &VREFN => @PLACE(64, -15.2);
//   &VREFN @WIRE {#MNB1:3 (64, -12) %g16:p};
//   %g17 = $GROUND @ATTACH &VSS => @PLACE(67, -13.2);
//   &VSS @WIRE {#MNB1:4 (67, -10) %g17:p};
//   #MPB2 @PLACE(64, 6);
//   #MPB2 @ORIENT("R0");
//   #MPB2:1 @TEXT("${net}", key="netname", size=0.6, halign="end", valign="middle", rotate=90, dx=0, dy=-0.4);
//   #MPB2:2 @TEXT("${net}", key="netname", size=0.6, halign="end", valign="middle", dx=-0.4, dy=0);
//   #MPB2:3 @TEXT("${net}", key="netname", size=0.6, halign="start", valign="middle", rotate=90, dx=0, dy=0.4);
//   %v18 = $SUPPLY @ATTACH &VREFP => @PLACE(67, 9.2);
//   &VREFP @WIRE {#MPB2:4 (67, 6) %v18:p};
//   #MNB2 @PLACE(80, -10);
//   #MNB2 @ORIENT("R0");
//   #MNB2:1 @TEXT("${net}", key="netname", size=0.6, halign="start", valign="middle", rotate=90, dx=0, dy=0.4);
//   #MNB2:2 @TEXT("${net}", key="netname", size=0.6, halign="end", valign="middle", dx=-0.4, dy=0);
//   %g19 = $GROUND @ATTACH &VREFN => @PLACE(80, -15.2);
//   &VREFN @WIRE {#MNB2:3 (80, -12) %g19:p};
//   %g20 = $GROUND @ATTACH &VSS => @PLACE(83, -13.2);
//   &VSS @WIRE {#MNB2:4 (83, -10) %g20:p};
//   #MFNN @PLACE(108, 12);
//   #MFNN @ORIENT("R0");
//   #MFNN:1 @TEXT("${net}", key="netname", size=0.6, halign="start", valign="middle", rotate=90, dx=0, dy=0.4);
//   #MFNN:2 @TEXT("${net}", key="netname", size=0.6, halign="end", valign="middle", dx=-0.4, dy=0);
//   %g21 = $GROUND @ATTACH &VREFN => @PLACE(108, 6.8);
//   &VREFN @WIRE {#MFNN:3 (108, 10) %g21:p};
//   %g22 = $GROUND @ATTACH &VSS => @PLACE(111, 8.8);
//   &VSS @WIRE {#MFNN:4 (111, 12) %g22:p};
//   #MFNP @PLACE(108, 22);
//   #MFNP @ORIENT("R0");
//   #MFNP:1 @TEXT("${net}", key="netname", size=0.6, halign="end", valign="middle", rotate=90, dx=0, dy=-0.4);
//   #MFNP:2 @TEXT("${net}", key="netname", size=0.6, halign="end", valign="middle", dx=-0.4, dy=0);
//   %v23 = $SUPPLY @ATTACH &VREFP => @PLACE(108, 27.2);
//   &VREFP @WIRE {#MFNP:3 (108, 24) %v23:p};
//   %v24 = $SUPPLY @ATTACH &VREFP => @PLACE(111, 25.2);
//   &VREFP @WIRE {#MFNP:4 (111, 22) %v24:p};
//   #MFPN @PLACE(136, 12);
//   #MFPN @ORIENT("R0");
//   #MFPN:1 @TEXT("${net}", key="netname", size=0.6, halign="start", valign="middle", rotate=90, dx=0, dy=0.4);
//   #MFPN:2 @TEXT("${net}", key="netname", size=0.6, halign="end", valign="middle", dx=-0.4, dy=0);
//   %g25 = $GROUND @ATTACH &VREFN => @PLACE(136, 6.8);
//   &VREFN @WIRE {#MFPN:3 (136, 10) %g25:p};
//   %g26 = $GROUND @ATTACH &VSS => @PLACE(139, 8.8);
//   &VSS @WIRE {#MFPN:4 (139, 12) %g26:p};
//   #MFPP @PLACE(136, 22);
//   #MFPP @ORIENT("R0");
//   #MFPP:1 @TEXT("${net}", key="netname", size=0.6, halign="end", valign="middle", rotate=90, dx=0, dy=-0.4);
//   #MFPP:2 @TEXT("${net}", key="netname", size=0.6, halign="end", valign="middle", dx=-0.4, dy=0);
//   %v27 = $SUPPLY @ATTACH &VREFP => @PLACE(136, 27.2);
//   &VREFP @WIRE {#MFPP:3 (136, 24) %v27:p};
//   %v28 = $SUPPLY @ATTACH &VREFP => @PLACE(139, 25.2);
//   &VREFP @WIRE {#MFPP:4 (139, 22) %v28:p};
//   #MNOUT @PLACE(168, 0);
//   #MNOUT @ORIENT("R0");
//   #MNOUT:1 @TEXT("${net}", key="netname", size=0.6, halign="start", valign="middle", rotate=90, dx=0, dy=0.4);
//   #MNOUT:2 @TEXT("${net}", key="netname", size=0.6, halign="end", valign="middle", dx=-0.4, dy=0);
//   %g29 = $GROUND @ATTACH &VREFN => @PLACE(168, -5.2);
//   &VREFN @WIRE {#MNOUT:3 (168, -2) %g29:p};
//   %g30 = $GROUND @ATTACH &VSS => @PLACE(171, -3.2);
//   &VSS @WIRE {#MNOUT:4 (171, 0) %g30:p};
//   #MPOUT @PLACE(168, 22);
//   #MPOUT @ORIENT("R0");
//   #MPOUT:1 @TEXT("${net}", key="netname", size=0.6, halign="end", valign="middle", rotate=90, dx=0, dy=-0.4);
//   #MPOUT:2 @TEXT("${net}", key="netname", size=0.6, halign="end", valign="middle", dx=-0.4, dy=0);
//   %v31 = $SUPPLY @ATTACH &VREFP => @PLACE(168, 27.2);
//   &VREFP @WIRE {#MPOUT:3 (168, 24) %v31:p};
//   %v32 = $SUPPLY @ATTACH &VREFP => @PLACE(171, 25.2);
//   &VREFP @WIRE {#MPOUT:4 (171, 22) %v32:p};
//   &NOFF @WIRE {#MFNN:1 #MFNP:1};
//   &GN @WIRE {#MFNN:2 (103, 12) (103, 22) #MFNP:2};
//   &PON @WIRE {#MFPN:1 #MFPP:1};
//   &GP @WIRE {#MFPN:2 (131, 12) (131, 22) #MFPP:2};
//   %gp_bus = (16, 22);
//   $JUNCTION @ATTACH %gp_bus;
//   &GP @WIRE {#MPA0:1 (0, 22) %gp_bus (32, 22) #MPA2:1};
//   &GP @WIRE {#MPA1:1 %gp_bus #MNA0:1};
//   &AN1 @WIRE {#MNA0:3 #MNA1:1};
//   &AN2 @WIRE {#MNA1:3 #MNA2:1};
//   &BP1 @WIRE {#MPB0:1 #MPB1:3};
//   &BP2 @WIRE {#MPB1:1 #MPB2:3};
//   %gn_bus = (64, -6);
//   $JUNCTION @ATTACH %gn_bus;
//   &GN @WIRE {#MNB0:1 (48, -6) %gn_bus (80, -6) #MNB2:1};
//   &GN @WIRE {#MNB1:1 %gn_bus #MPB2:1};
//   &BP @WIRE {#MNOUT:1 #MPOUT:1};
//   %p_hi = $IO_PORT @ATTACH &HI => @PLACE(9, 26) => @ORIENT("R0");
//   &HI @WIRE {%p_hi:p #MPA1:2};
//   %p_en = $IO_PORT @ATTACH &EN => @PLACE(-7, 26) => @ORIENT("R0");
//   &EN @WIRE {%p_en:p #MPA0:2};
//   %p_enb = $IO_PORT @ATTACH &ENB => @PLACE(57, 26) => @ORIENT("R0");
//   &ENB @WIRE {%p_enb:p #MPB0:2};
//   %p_bp = $IO_PORT @ATTACH &BP => @PLACE(168, 6) => @ORIENT("R270");
//   &BP @WIRE {%p_bp:p #MNOUT:1};
//   (-10, 48) @TEXT("Tristate nonoverlap driver j=1") => @SET-STYLE $title_style
// }
ends mq_cdac_drv1

// Matched half-capacitor pair j=1, weight 2
subckt mq_cdac_bit1 (VIN VG DH RL EN ENB TOP VREFP VREFN VSS)
// CP*: user-specified pre-layout estimate, 5% of each physical MOM unit to VSS.
// The second MOM terminal is its bottom plate; parallel multipliers are aggregated.
// Series tails add one unit parasitic at MID and one at B, not 5% of the equivalent half unit.
XHCTL (DH HHI VREFP VREFN VSS) mq_cdac_ctl_h
XLCTL (RL LHI VREFP VREFN VSS) mq_cdac_ctl_l
XDH (HHI EN ENB BH VREFP VREFN VSS) mq_cdac_drv1
CH (TOP BH) cfmom_2t w=5e-08 s=2.4e-07 nr=6 lr=1.69e-06 stm=2 spm=4 multi=1
CPH (BH VSS) capacitor c=5.01145e-17
MSH (BH VG VIN VSS) nch_ulvt_mac w=1.2e-07 l=3e-08 nf=1
XDL (LHI EN ENB BL VREFP VREFN VSS) mq_cdac_drv1
CL (TOP BL) cfmom_2t w=5e-08 s=2.4e-07 nr=6 lr=1.69e-06 stm=2 spm=4 multi=1
CPL (BL VSS) capacitor c=5.01145e-17
MSL (BL VG VIN VSS) nch_ulvt_mac w=1.2e-07 l=3e-08 nf=1
// @RNL {
//   /* pins connected by net name: the net-name label of rnl-std-fill on every unwired pin, placed below by its key netname */
//   $LABEL_TERMINAL_SET @TEXT("${net}", key="netname", size=0.6);
//   &VSS @ADD-TO $GROUND_NET_SET; &VREFN @ADD-TO $GROUND_NET_SET; &VREFP @ADD-TO $SUPPLY_NET_SET;
//   {#CH #CL} @AS $MATCHED;
//   {#MSH #MSL} @AS $MATCHED;
//   {#XDH #XDL} @AS $MATCHED;
//   #XHCTL @PLACE(-70, 24);
//   #XHCTL @ORIENT("R0");
//   #XHCTL:IN @TEXT("${net}", key="netname", size=0.6, halign="end", valign="middle", dx=-0.4, dy=0);
//   #XHCTL:HI @TEXT("${net}", key="netname", size=0.6, halign="start", valign="middle", dx=0.4, dy=0);
//   %v1 = $SUPPLY @ATTACH &VREFP => @PLACE(-70, 31.2);
//   &VREFP @WIRE {#XHCTL:VREFP (-70, 28) %v1:p};
//   %g2 = $GROUND @ATTACH &VREFN => @PLACE(-72, 16.8);
//   &VREFN @WIRE {#XHCTL:VREFN (-72, 20) %g2:p};
//   %g3 = $GROUND @ATTACH &VSS => @PLACE(-68, 16.8);
//   &VSS @WIRE {#XHCTL:VSS (-68, 20) %g3:p};
//   #XLCTL @PLACE(-70, -26);
//   #XLCTL @ORIENT("R0");
//   #XLCTL:IN @TEXT("${net}", key="netname", size=0.6, halign="end", valign="middle", dx=-0.4, dy=0);
//   #XLCTL:HI @TEXT("${net}", key="netname", size=0.6, halign="start", valign="middle", dx=0.4, dy=0);
//   %v4 = $SUPPLY @ATTACH &VREFP => @PLACE(-70, -18.8);
//   &VREFP @WIRE {#XLCTL:VREFP (-70, -22) %v4:p};
//   %g5 = $GROUND @ATTACH &VREFN => @PLACE(-72, -33.2);
//   &VREFN @WIRE {#XLCTL:VREFN (-72, -30) %g5:p};
//   %g6 = $GROUND @ATTACH &VSS => @PLACE(-68, -33.2);
//   &VSS @WIRE {#XLCTL:VSS (-68, -30) %g6:p};
//   #XDH @PLACE(-34, 24);
//   #XDH @ORIENT("R0");
//   #XDH:HI @TEXT("${net}", key="netname", size=0.6, halign="end", valign="middle", dx=-0.4, dy=0);
//   #XDH:EN @TEXT("${net}", key="netname", size=0.6, halign="end", valign="middle", dx=-0.4, dy=0);
//   #XDH:ENB @TEXT("${net}", key="netname", size=0.6, halign="end", valign="middle", dx=-0.4, dy=0);
//   #XDH:BP @TEXT("${net}", key="netname", size=0.6, halign="start", valign="middle", dx=0.4, dy=0);
//   %v7 = $SUPPLY @ATTACH &VREFP => @PLACE(-34, 32.2);
//   &VREFP @WIRE {#XDH:VREFP (-34, 29) %v7:p};
//   %g8 = $GROUND @ATTACH &VREFN => @PLACE(-36, 15.8);
//   &VREFN @WIRE {#XDH:VREFN (-36, 19) %g8:p};
//   %g9 = $GROUND @ATTACH &VSS => @PLACE(-32, 15.8);
//   &VSS @WIRE {#XDH:VSS (-32, 19) %g9:p};
//   #CH @PLACE(14, 24) => @ORIENT("R270");
//   #CH:1 @TEXT("${net}", key="netname", size=0.6, halign="start", valign="middle", dx=0.4, dy=0);
//   #CH:2 @TEXT("${net}", key="netname", size=0.6, halign="end", valign="middle", dx=-0.4, dy=0);
//   #CPH @PLACE(60, 20);
//   #CPH @ORIENT("R0");
//   #CPH:1 @TEXT("${net}", key="netname", size=0.6, halign="start", valign="middle", rotate=90, dx=0, dy=0.4);
//   %g10 = $GROUND @ATTACH &VSS => @PLACE(60, 14.8);
//   &VSS @WIRE {#CPH:2 (60, 18) %g10:p};
//   #MSH @PLACE(2, 8);
//   #MSH @ORIENT("R0");
//   #MSH:1 @TEXT("${net}", key="netname", size=0.6, halign="start", valign="middle", rotate=90, dx=0, dy=0.4);
//   #MSH:2 @TEXT("${net}", key="netname", size=0.6, halign="end", valign="middle", dx=-0.4, dy=0);
//   #MSH:3 @TEXT("${net}", key="netname", size=0.6, halign="end", valign="middle", rotate=90, dx=0, dy=-0.4);
//   %g11 = $GROUND @ATTACH &VSS => @PLACE(5, 4.8);
//   &VSS @WIRE {#MSH:4 (5, 8) %g11:p};
//   #XDL @PLACE(-34, -26);
//   #XDL @ORIENT("R0");
//   #XDL:HI @TEXT("${net}", key="netname", size=0.6, halign="end", valign="middle", dx=-0.4, dy=0);
//   #XDL:EN @TEXT("${net}", key="netname", size=0.6, halign="end", valign="middle", dx=-0.4, dy=0);
//   #XDL:ENB @TEXT("${net}", key="netname", size=0.6, halign="end", valign="middle", dx=-0.4, dy=0);
//   #XDL:BP @TEXT("${net}", key="netname", size=0.6, halign="start", valign="middle", dx=0.4, dy=0);
//   %v12 = $SUPPLY @ATTACH &VREFP => @PLACE(-34, -17.8);
//   &VREFP @WIRE {#XDL:VREFP (-34, -21) %v12:p};
//   %g13 = $GROUND @ATTACH &VREFN => @PLACE(-36, -34.2);
//   &VREFN @WIRE {#XDL:VREFN (-36, -31) %g13:p};
//   %g14 = $GROUND @ATTACH &VSS => @PLACE(-32, -34.2);
//   &VSS @WIRE {#XDL:VSS (-32, -31) %g14:p};
//   #CL @PLACE(14, -26) => @ORIENT("R270");
//   #CL:1 @TEXT("${net}", key="netname", size=0.6, halign="start", valign="middle", dx=0.4, dy=0);
//   #CL:2 @TEXT("${net}", key="netname", size=0.6, halign="end", valign="middle", dx=-0.4, dy=0);
//   #CPL @PLACE(60, -30);
//   #CPL @ORIENT("R0");
//   #CPL:1 @TEXT("${net}", key="netname", size=0.6, halign="start", valign="middle", rotate=90, dx=0, dy=0.4);
//   %g15 = $GROUND @ATTACH &VSS => @PLACE(60, -35.2);
//   &VSS @WIRE {#CPL:2 (60, -32) %g15:p};
//   #MSL @PLACE(2, -42);
//   #MSL @ORIENT("R0");
//   #MSL:1 @TEXT("${net}", key="netname", size=0.6, halign="start", valign="middle", rotate=90, dx=0, dy=0.4);
//   #MSL:2 @TEXT("${net}", key="netname", size=0.6, halign="end", valign="middle", dx=-0.4, dy=0);
//   #MSL:3 @TEXT("${net}", key="netname", size=0.6, halign="end", valign="middle", rotate=90, dx=0, dy=-0.4);
//   %g16 = $GROUND @ATTACH &VSS => @PLACE(5, -45.2);
//   &VSS @WIRE {#MSL:4 (5, -42) %g16:p};
//   &HHI @WIRE {#XHCTL:HI (-52, 24) (-52, 26) #XDH:HI};
//   %b_H = (-12, 24);
//   $JUNCTION @ATTACH %b_H;
//   &BH @WIRE {#XDH:BP %b_H};
//   &BH @WIRE {%b_H #CH:2};
//   &BH @WIRE {%b_H (-12, 10) #MSH:1};
//   &LHI @WIRE {#XLCTL:HI (-52, -26) (-52, -24) #XDL:HI};
//   %b_L = (-12, -26);
//   $JUNCTION @ATTACH %b_L;
//   &BL @WIRE {#XDL:BP %b_L};
//   &BL @WIRE {%b_L #CL:2};
//   &BL @WIRE {%b_L (-12, -40) #MSL:1};
//   &VIN @WIRE {#MSH:3 (6, 6) (6, -44) #MSL:3};
//   &VG @WIRE {#MSH:2 (-5, 8) (-5, -42) #MSL:2};
//   %top_H = (44, 24);
//   $JUNCTION @ATTACH %top_H;
//   %top_L = (44, -26);
//   $JUNCTION @ATTACH %top_L;
//   &TOP @WIRE {#CH:1 %top_H};
//   &TOP @WIRE {#CL:1 %top_L};
//   &TOP @WIRE {%top_H %top_L};
//   %p_vin = $IO_PORT @ATTACH &VIN => @PLACE(2, 2) => @ORIENT("R90");
//   &VIN @WIRE {%p_vin:p #MSH:3};
//   %p_vg = $IO_PORT @ATTACH &VG => @PLACE(-5, 8) => @ORIENT("R0");
//   &VG @WIRE {%p_vg:p #MSH:2};
//   %p_dh = $IO_PORT @ATTACH &DH => @PLACE(-81, 24) => @ORIENT("R0");
//   &DH @WIRE {%p_dh:p #XHCTL:IN};
//   %p_rl = $IO_PORT @ATTACH &RL => @PLACE(-81, -26) => @ORIENT("R0");
//   &RL @WIRE {%p_rl:p #XLCTL:IN};
//   %p_en = $IO_PORT @ATTACH &EN => @PLACE(-45, 24) => @ORIENT("R0");
//   &EN @WIRE {%p_en:p #XDH:EN};
//   %p_enb = $IO_PORT @ATTACH &ENB => @PLACE(-45, 22) => @ORIENT("R0");
//   &ENB @WIRE {%p_enb:p #XDH:ENB};
//   %p_top = $IO_PORT @ATTACH &TOP => @PLACE(20, 24) => @ORIENT("MY");
//   &TOP @WIRE {%p_top:p #CH:1};
//   (-10, 46) @TEXT("Matched half-capacitor pair j=1, weight 2") => @SET-STYLE $title_style
// }
ends mq_cdac_bit1

// Tristate nonoverlap driver j=0
subckt mq_cdac_drv0 (HI EN ENB BP VREFP VREFN VSS)
// GP = NAND(EN, HI, NOT(GN)); GN = NOR(ENB, HI, NOT(GP)).
// Feedback senses the opposite output-device gate; each turn-on waits for the opposite turn-off.
MPA0 (GP EN VREFP VREFP) pch_ulvt_mac w=1.2e-07 l=3e-08 nf=1
MNA0 (GP EN AN1 VSS) nch_ulvt_mac w=2.4e-07 l=3e-08 nf=1
MPA1 (GP HI VREFP VREFP) pch_ulvt_mac w=1.2e-07 l=3e-08 nf=1
MNA1 (AN1 HI AN2 VSS) nch_ulvt_mac w=2.4e-07 l=3e-08 nf=1
MPA2 (GP NOFF VREFP VREFP) pch_ulvt_mac w=1.2e-07 l=3e-08 nf=1
MNA2 (AN2 NOFF VREFN VSS) nch_ulvt_mac w=2.4e-07 l=3e-08 nf=1
MPB0 (BP1 ENB VREFP VREFP) pch_ulvt_mac w=3.6e-07 l=3e-08 nf=1
MNB0 (GN ENB VREFN VSS) nch_ulvt_mac w=1.2e-07 l=3e-08 nf=1
MPB1 (BP2 HI BP1 VREFP) pch_ulvt_mac w=3.6e-07 l=3e-08 nf=1
MNB1 (GN HI VREFN VSS) nch_ulvt_mac w=1.2e-07 l=3e-08 nf=1
MPB2 (GN PON BP2 VREFP) pch_ulvt_mac w=3.6e-07 l=3e-08 nf=1
MNB2 (GN PON VREFN VSS) nch_ulvt_mac w=1.2e-07 l=3e-08 nf=1
MFNN (NOFF GN VREFN VSS) nch_ulvt_mac w=1.2e-07 l=3e-08 nf=1
MFNP (NOFF GN VREFP VREFP) pch_ulvt_mac w=2.4e-07 l=3e-08 nf=1
MFPN (PON GP VREFN VSS) nch_ulvt_mac w=1.2e-07 l=3e-08 nf=1
MFPP (PON GP VREFP VREFP) pch_ulvt_mac w=2.4e-07 l=3e-08 nf=1
MNOUT (BP GN VREFN VSS) nch_ulvt_mac w=6e-07 l=3e-08 nf=1
MPOUT (BP GP VREFP VREFP) pch_ulvt_mac w=1.2e-06 l=3e-08 nf=1
// @RNL {
//   /* pins connected by net name: the net-name label of rnl-std-fill on every unwired pin, placed below by its key netname */
//   $LABEL_TERMINAL_SET @TEXT("${net}", key="netname", size=0.6);
//   &VSS @ADD-TO $GROUND_NET_SET; &VREFN @ADD-TO $GROUND_NET_SET; &VREFP @ADD-TO $SUPPLY_NET_SET;
//   {#MFNN #MFNP} @GROUP;
//   {#MFPN #MFPP} @GROUP;
//   {#MPA0 #MPA1 #MPA2 #MNA0 #MNA1 #MNA2} @GROUP;
//   {#MPB0 #MPB1 #MPB2 #MNB0 #MNB1 #MNB2} @GROUP;
//   {#MNOUT #MPOUT} @GROUP;
//   #MPA0 @PLACE(0, 26);
//   #MPA0 @ORIENT("R0");
//   #MPA0:1 @TEXT("${net}", key="netname", size=0.6, halign="end", valign="middle", rotate=90, dx=0, dy=-0.4);
//   #MPA0:2 @TEXT("${net}", key="netname", size=0.6, halign="end", valign="middle", dx=-0.4, dy=0);
//   %v1 = $SUPPLY @ATTACH &VREFP => @PLACE(0, 31.2);
//   &VREFP @WIRE {#MPA0:3 (0, 28) %v1:p};
//   %v2 = $SUPPLY @ATTACH &VREFP => @PLACE(3, 29.2);
//   &VREFP @WIRE {#MPA0:4 (3, 26) %v2:p};
//   #MNA0 @PLACE(16, 12);
//   #MNA0 @ORIENT("R0");
//   #MNA0:1 @TEXT("${net}", key="netname", size=0.6, halign="start", valign="middle", rotate=90, dx=0, dy=0.4);
//   #MNA0:2 @TEXT("${net}", key="netname", size=0.6, halign="end", valign="middle", dx=-0.4, dy=0);
//   #MNA0:3 @TEXT("${net}", key="netname", size=0.6, halign="end", valign="middle", rotate=90, dx=0, dy=-0.4);
//   %g3 = $GROUND @ATTACH &VSS => @PLACE(19, 8.8);
//   &VSS @WIRE {#MNA0:4 (19, 12) %g3:p};
//   #MPA1 @PLACE(16, 26);
//   #MPA1 @ORIENT("R0");
//   #MPA1:1 @TEXT("${net}", key="netname", size=0.6, halign="end", valign="middle", rotate=90, dx=0, dy=-0.4);
//   #MPA1:2 @TEXT("${net}", key="netname", size=0.6, halign="end", valign="middle", dx=-0.4, dy=0);
//   %v4 = $SUPPLY @ATTACH &VREFP => @PLACE(16, 31.2);
//   &VREFP @WIRE {#MPA1:3 (16, 28) %v4:p};
//   %v5 = $SUPPLY @ATTACH &VREFP => @PLACE(19, 29.2);
//   &VREFP @WIRE {#MPA1:4 (19, 26) %v5:p};
//   #MNA1 @PLACE(16, 2);
//   #MNA1 @ORIENT("R0");
//   #MNA1:1 @TEXT("${net}", key="netname", size=0.6, halign="start", valign="middle", rotate=90, dx=0, dy=0.4);
//   #MNA1:2 @TEXT("${net}", key="netname", size=0.6, halign="end", valign="middle", dx=-0.4, dy=0);
//   #MNA1:3 @TEXT("${net}", key="netname", size=0.6, halign="end", valign="middle", rotate=90, dx=0, dy=-0.4);
//   %g6 = $GROUND @ATTACH &VSS => @PLACE(19, -1.2);
//   &VSS @WIRE {#MNA1:4 (19, 2) %g6:p};
//   #MPA2 @PLACE(32, 26);
//   #MPA2 @ORIENT("R0");
//   #MPA2:1 @TEXT("${net}", key="netname", size=0.6, halign="end", valign="middle", rotate=90, dx=0, dy=-0.4);
//   #MPA2:2 @TEXT("${net}", key="netname", size=0.6, halign="end", valign="middle", dx=-0.4, dy=0);
//   %v7 = $SUPPLY @ATTACH &VREFP => @PLACE(32, 31.2);
//   &VREFP @WIRE {#MPA2:3 (32, 28) %v7:p};
//   %v8 = $SUPPLY @ATTACH &VREFP => @PLACE(35, 29.2);
//   &VREFP @WIRE {#MPA2:4 (35, 26) %v8:p};
//   #MNA2 @PLACE(16, -8);
//   #MNA2 @ORIENT("R0");
//   #MNA2:1 @TEXT("${net}", key="netname", size=0.6, halign="start", valign="middle", rotate=90, dx=0, dy=0.4);
//   #MNA2:2 @TEXT("${net}", key="netname", size=0.6, halign="end", valign="middle", dx=-0.4, dy=0);
//   %g9 = $GROUND @ATTACH &VREFN => @PLACE(16, -13.2);
//   &VREFN @WIRE {#MNA2:3 (16, -10) %g9:p};
//   %g10 = $GROUND @ATTACH &VSS => @PLACE(19, -11.2);
//   &VSS @WIRE {#MNA2:4 (19, -8) %g10:p};
//   #MPB0 @PLACE(64, 26);
//   #MPB0 @ORIENT("R0");
//   #MPB0:1 @TEXT("${net}", key="netname", size=0.6, halign="end", valign="middle", rotate=90, dx=0, dy=-0.4);
//   #MPB0:2 @TEXT("${net}", key="netname", size=0.6, halign="end", valign="middle", dx=-0.4, dy=0);
//   %v11 = $SUPPLY @ATTACH &VREFP => @PLACE(64, 31.2);
//   &VREFP @WIRE {#MPB0:3 (64, 28) %v11:p};
//   %v12 = $SUPPLY @ATTACH &VREFP => @PLACE(67, 29.2);
//   &VREFP @WIRE {#MPB0:4 (67, 26) %v12:p};
//   #MNB0 @PLACE(48, -10);
//   #MNB0 @ORIENT("R0");
//   #MNB0:1 @TEXT("${net}", key="netname", size=0.6, halign="start", valign="middle", rotate=90, dx=0, dy=0.4);
//   #MNB0:2 @TEXT("${net}", key="netname", size=0.6, halign="end", valign="middle", dx=-0.4, dy=0);
//   %g13 = $GROUND @ATTACH &VREFN => @PLACE(48, -15.2);
//   &VREFN @WIRE {#MNB0:3 (48, -12) %g13:p};
//   %g14 = $GROUND @ATTACH &VSS => @PLACE(51, -13.2);
//   &VSS @WIRE {#MNB0:4 (51, -10) %g14:p};
//   #MPB1 @PLACE(64, 16);
//   #MPB1 @ORIENT("R0");
//   #MPB1:1 @TEXT("${net}", key="netname", size=0.6, halign="end", valign="middle", rotate=90, dx=0, dy=-0.4);
//   #MPB1:2 @TEXT("${net}", key="netname", size=0.6, halign="end", valign="middle", dx=-0.4, dy=0);
//   #MPB1:3 @TEXT("${net}", key="netname", size=0.6, halign="start", valign="middle", rotate=90, dx=0, dy=0.4);
//   %v15 = $SUPPLY @ATTACH &VREFP => @PLACE(67, 19.2);
//   &VREFP @WIRE {#MPB1:4 (67, 16) %v15:p};
//   #MNB1 @PLACE(64, -10);
//   #MNB1 @ORIENT("R0");
//   #MNB1:1 @TEXT("${net}", key="netname", size=0.6, halign="start", valign="middle", rotate=90, dx=0, dy=0.4);
//   #MNB1:2 @TEXT("${net}", key="netname", size=0.6, halign="end", valign="middle", dx=-0.4, dy=0);
//   %g16 = $GROUND @ATTACH &VREFN => @PLACE(64, -15.2);
//   &VREFN @WIRE {#MNB1:3 (64, -12) %g16:p};
//   %g17 = $GROUND @ATTACH &VSS => @PLACE(67, -13.2);
//   &VSS @WIRE {#MNB1:4 (67, -10) %g17:p};
//   #MPB2 @PLACE(64, 6);
//   #MPB2 @ORIENT("R0");
//   #MPB2:1 @TEXT("${net}", key="netname", size=0.6, halign="end", valign="middle", rotate=90, dx=0, dy=-0.4);
//   #MPB2:2 @TEXT("${net}", key="netname", size=0.6, halign="end", valign="middle", dx=-0.4, dy=0);
//   #MPB2:3 @TEXT("${net}", key="netname", size=0.6, halign="start", valign="middle", rotate=90, dx=0, dy=0.4);
//   %v18 = $SUPPLY @ATTACH &VREFP => @PLACE(67, 9.2);
//   &VREFP @WIRE {#MPB2:4 (67, 6) %v18:p};
//   #MNB2 @PLACE(80, -10);
//   #MNB2 @ORIENT("R0");
//   #MNB2:1 @TEXT("${net}", key="netname", size=0.6, halign="start", valign="middle", rotate=90, dx=0, dy=0.4);
//   #MNB2:2 @TEXT("${net}", key="netname", size=0.6, halign="end", valign="middle", dx=-0.4, dy=0);
//   %g19 = $GROUND @ATTACH &VREFN => @PLACE(80, -15.2);
//   &VREFN @WIRE {#MNB2:3 (80, -12) %g19:p};
//   %g20 = $GROUND @ATTACH &VSS => @PLACE(83, -13.2);
//   &VSS @WIRE {#MNB2:4 (83, -10) %g20:p};
//   #MFNN @PLACE(108, 12);
//   #MFNN @ORIENT("R0");
//   #MFNN:1 @TEXT("${net}", key="netname", size=0.6, halign="start", valign="middle", rotate=90, dx=0, dy=0.4);
//   #MFNN:2 @TEXT("${net}", key="netname", size=0.6, halign="end", valign="middle", dx=-0.4, dy=0);
//   %g21 = $GROUND @ATTACH &VREFN => @PLACE(108, 6.8);
//   &VREFN @WIRE {#MFNN:3 (108, 10) %g21:p};
//   %g22 = $GROUND @ATTACH &VSS => @PLACE(111, 8.8);
//   &VSS @WIRE {#MFNN:4 (111, 12) %g22:p};
//   #MFNP @PLACE(108, 22);
//   #MFNP @ORIENT("R0");
//   #MFNP:1 @TEXT("${net}", key="netname", size=0.6, halign="end", valign="middle", rotate=90, dx=0, dy=-0.4);
//   #MFNP:2 @TEXT("${net}", key="netname", size=0.6, halign="end", valign="middle", dx=-0.4, dy=0);
//   %v23 = $SUPPLY @ATTACH &VREFP => @PLACE(108, 27.2);
//   &VREFP @WIRE {#MFNP:3 (108, 24) %v23:p};
//   %v24 = $SUPPLY @ATTACH &VREFP => @PLACE(111, 25.2);
//   &VREFP @WIRE {#MFNP:4 (111, 22) %v24:p};
//   #MFPN @PLACE(136, 12);
//   #MFPN @ORIENT("R0");
//   #MFPN:1 @TEXT("${net}", key="netname", size=0.6, halign="start", valign="middle", rotate=90, dx=0, dy=0.4);
//   #MFPN:2 @TEXT("${net}", key="netname", size=0.6, halign="end", valign="middle", dx=-0.4, dy=0);
//   %g25 = $GROUND @ATTACH &VREFN => @PLACE(136, 6.8);
//   &VREFN @WIRE {#MFPN:3 (136, 10) %g25:p};
//   %g26 = $GROUND @ATTACH &VSS => @PLACE(139, 8.8);
//   &VSS @WIRE {#MFPN:4 (139, 12) %g26:p};
//   #MFPP @PLACE(136, 22);
//   #MFPP @ORIENT("R0");
//   #MFPP:1 @TEXT("${net}", key="netname", size=0.6, halign="end", valign="middle", rotate=90, dx=0, dy=-0.4);
//   #MFPP:2 @TEXT("${net}", key="netname", size=0.6, halign="end", valign="middle", dx=-0.4, dy=0);
//   %v27 = $SUPPLY @ATTACH &VREFP => @PLACE(136, 27.2);
//   &VREFP @WIRE {#MFPP:3 (136, 24) %v27:p};
//   %v28 = $SUPPLY @ATTACH &VREFP => @PLACE(139, 25.2);
//   &VREFP @WIRE {#MFPP:4 (139, 22) %v28:p};
//   #MNOUT @PLACE(168, 0);
//   #MNOUT @ORIENT("R0");
//   #MNOUT:1 @TEXT("${net}", key="netname", size=0.6, halign="start", valign="middle", rotate=90, dx=0, dy=0.4);
//   #MNOUT:2 @TEXT("${net}", key="netname", size=0.6, halign="end", valign="middle", dx=-0.4, dy=0);
//   %g29 = $GROUND @ATTACH &VREFN => @PLACE(168, -5.2);
//   &VREFN @WIRE {#MNOUT:3 (168, -2) %g29:p};
//   %g30 = $GROUND @ATTACH &VSS => @PLACE(171, -3.2);
//   &VSS @WIRE {#MNOUT:4 (171, 0) %g30:p};
//   #MPOUT @PLACE(168, 22);
//   #MPOUT @ORIENT("R0");
//   #MPOUT:1 @TEXT("${net}", key="netname", size=0.6, halign="end", valign="middle", rotate=90, dx=0, dy=-0.4);
//   #MPOUT:2 @TEXT("${net}", key="netname", size=0.6, halign="end", valign="middle", dx=-0.4, dy=0);
//   %v31 = $SUPPLY @ATTACH &VREFP => @PLACE(168, 27.2);
//   &VREFP @WIRE {#MPOUT:3 (168, 24) %v31:p};
//   %v32 = $SUPPLY @ATTACH &VREFP => @PLACE(171, 25.2);
//   &VREFP @WIRE {#MPOUT:4 (171, 22) %v32:p};
//   &NOFF @WIRE {#MFNN:1 #MFNP:1};
//   &GN @WIRE {#MFNN:2 (103, 12) (103, 22) #MFNP:2};
//   &PON @WIRE {#MFPN:1 #MFPP:1};
//   &GP @WIRE {#MFPN:2 (131, 12) (131, 22) #MFPP:2};
//   %gp_bus = (16, 22);
//   $JUNCTION @ATTACH %gp_bus;
//   &GP @WIRE {#MPA0:1 (0, 22) %gp_bus (32, 22) #MPA2:1};
//   &GP @WIRE {#MPA1:1 %gp_bus #MNA0:1};
//   &AN1 @WIRE {#MNA0:3 #MNA1:1};
//   &AN2 @WIRE {#MNA1:3 #MNA2:1};
//   &BP1 @WIRE {#MPB0:1 #MPB1:3};
//   &BP2 @WIRE {#MPB1:1 #MPB2:3};
//   %gn_bus = (64, -6);
//   $JUNCTION @ATTACH %gn_bus;
//   &GN @WIRE {#MNB0:1 (48, -6) %gn_bus (80, -6) #MNB2:1};
//   &GN @WIRE {#MNB1:1 %gn_bus #MPB2:1};
//   &BP @WIRE {#MNOUT:1 #MPOUT:1};
//   %p_hi = $IO_PORT @ATTACH &HI => @PLACE(9, 26) => @ORIENT("R0");
//   &HI @WIRE {%p_hi:p #MPA1:2};
//   %p_en = $IO_PORT @ATTACH &EN => @PLACE(-7, 26) => @ORIENT("R0");
//   &EN @WIRE {%p_en:p #MPA0:2};
//   %p_enb = $IO_PORT @ATTACH &ENB => @PLACE(57, 26) => @ORIENT("R0");
//   &ENB @WIRE {%p_enb:p #MPB0:2};
//   %p_bp = $IO_PORT @ATTACH &BP => @PLACE(168, 6) => @ORIENT("R270");
//   &BP @WIRE {%p_bp:p #MNOUT:1};
//   (-10, 48) @TEXT("Tristate nonoverlap driver j=0") => @SET-STYLE $title_style
// }
ends mq_cdac_drv0

// Matched half-capacitor pair j=0, weight 1
subckt mq_cdac_bit0 (VIN VG DH RL EN ENB TOP VREFP VREFN VSS)
// CP*: user-specified pre-layout estimate, 5% of each physical MOM unit to VSS.
// The second MOM terminal is its bottom plate; parallel multipliers are aggregated.
// Series tails add one unit parasitic at MID and one at B, not 5% of the equivalent half unit.
XHCTL (DH HHI VREFP VREFN VSS) mq_cdac_ctl_h
XLCTL (RL LHI VREFP VREFN VSS) mq_cdac_ctl_l
XDH (HHI EN ENB BH VREFP VREFN VSS) mq_cdac_drv0
CHA (TOP MIDH) cfmom_2t w=5e-08 s=2.4e-07 nr=6 lr=1.69e-06 stm=2 spm=4 multi=1
CPHA (MIDH VSS) capacitor c=5.01145e-17
CHB (MIDH BH) cfmom_2t w=5e-08 s=2.4e-07 nr=6 lr=1.69e-06 stm=2 spm=4 multi=1
CPHB (BH VSS) capacitor c=5.01145e-17
MSH (BH VG VIN VSS) nch_ulvt_mac w=1.2e-07 l=3e-08 nf=1
XDL (LHI EN ENB BL VREFP VREFN VSS) mq_cdac_drv0
CLA (TOP MIDL) cfmom_2t w=5e-08 s=2.4e-07 nr=6 lr=1.69e-06 stm=2 spm=4 multi=1
CPLA (MIDL VSS) capacitor c=5.01145e-17
CLB (MIDL BL) cfmom_2t w=5e-08 s=2.4e-07 nr=6 lr=1.69e-06 stm=2 spm=4 multi=1
CPLB (BL VSS) capacitor c=5.01145e-17
MSL (BL VG VIN VSS) nch_ulvt_mac w=1.2e-07 l=3e-08 nf=1
// @RNL {
//   /* pins connected by net name: the net-name label of rnl-std-fill on every unwired pin, placed below by its key netname */
//   $LABEL_TERMINAL_SET @TEXT("${net}", key="netname", size=0.6);
//   &VSS @ADD-TO $GROUND_NET_SET; &VREFN @ADD-TO $GROUND_NET_SET; &VREFP @ADD-TO $SUPPLY_NET_SET;
//   {#CHA #CHB #CLA #CLB} @AS $MATCHED;
//   {#CHA #CHB #CLA #CLB} @GROUP;
//   {#MSH #MSL} @AS $MATCHED;
//   {#XDH #XDL} @AS $MATCHED;
//   #XHCTL @PLACE(-70, 24);
//   #XHCTL @ORIENT("R0");
//   #XHCTL:IN @TEXT("${net}", key="netname", size=0.6, halign="end", valign="middle", dx=-0.4, dy=0);
//   #XHCTL:HI @TEXT("${net}", key="netname", size=0.6, halign="start", valign="middle", dx=0.4, dy=0);
//   %v1 = $SUPPLY @ATTACH &VREFP => @PLACE(-70, 31.2);
//   &VREFP @WIRE {#XHCTL:VREFP (-70, 28) %v1:p};
//   %g2 = $GROUND @ATTACH &VREFN => @PLACE(-72, 16.8);
//   &VREFN @WIRE {#XHCTL:VREFN (-72, 20) %g2:p};
//   %g3 = $GROUND @ATTACH &VSS => @PLACE(-68, 16.8);
//   &VSS @WIRE {#XHCTL:VSS (-68, 20) %g3:p};
//   #XLCTL @PLACE(-70, -26);
//   #XLCTL @ORIENT("R0");
//   #XLCTL:IN @TEXT("${net}", key="netname", size=0.6, halign="end", valign="middle", dx=-0.4, dy=0);
//   #XLCTL:HI @TEXT("${net}", key="netname", size=0.6, halign="start", valign="middle", dx=0.4, dy=0);
//   %v4 = $SUPPLY @ATTACH &VREFP => @PLACE(-70, -18.8);
//   &VREFP @WIRE {#XLCTL:VREFP (-70, -22) %v4:p};
//   %g5 = $GROUND @ATTACH &VREFN => @PLACE(-72, -33.2);
//   &VREFN @WIRE {#XLCTL:VREFN (-72, -30) %g5:p};
//   %g6 = $GROUND @ATTACH &VSS => @PLACE(-68, -33.2);
//   &VSS @WIRE {#XLCTL:VSS (-68, -30) %g6:p};
//   #XDH @PLACE(-34, 24);
//   #XDH @ORIENT("R0");
//   #XDH:HI @TEXT("${net}", key="netname", size=0.6, halign="end", valign="middle", dx=-0.4, dy=0);
//   #XDH:EN @TEXT("${net}", key="netname", size=0.6, halign="end", valign="middle", dx=-0.4, dy=0);
//   #XDH:ENB @TEXT("${net}", key="netname", size=0.6, halign="end", valign="middle", dx=-0.4, dy=0);
//   #XDH:BP @TEXT("${net}", key="netname", size=0.6, halign="start", valign="middle", dx=0.4, dy=0);
//   %v7 = $SUPPLY @ATTACH &VREFP => @PLACE(-34, 32.2);
//   &VREFP @WIRE {#XDH:VREFP (-34, 29) %v7:p};
//   %g8 = $GROUND @ATTACH &VREFN => @PLACE(-36, 15.8);
//   &VREFN @WIRE {#XDH:VREFN (-36, 19) %g8:p};
//   %g9 = $GROUND @ATTACH &VSS => @PLACE(-32, 15.8);
//   &VSS @WIRE {#XDH:VSS (-32, 19) %g9:p};
//   #CHA @PLACE(30, 38) => @ORIENT("R270");
//   #CHA:1 @TEXT("${net}", key="netname", size=0.6, halign="start", valign="middle", dx=0.4, dy=0);
//   #CHA:2 @TEXT("${net}", key="netname", size=0.6, halign="end", valign="middle", dx=-0.4, dy=0);
//   #CPHA @PLACE(76, 20);
//   #CPHA @ORIENT("R0");
//   #CPHA:1 @TEXT("${net}", key="netname", size=0.6, halign="start", valign="middle", rotate=90, dx=0, dy=0.4);
//   %g10 = $GROUND @ATTACH &VSS => @PLACE(76, 14.8);
//   &VSS @WIRE {#CPHA:2 (76, 18) %g10:p};
//   #CHB @PLACE(10, 38) => @ORIENT("R270");
//   #CHB:1 @TEXT("${net}", key="netname", size=0.6, halign="start", valign="middle", dx=0.4, dy=0);
//   #CHB:2 @TEXT("${net}", key="netname", size=0.6, halign="end", valign="middle", dx=-0.4, dy=0);
//   #CPHB @PLACE(92, 20);
//   #CPHB @ORIENT("R0");
//   #CPHB:1 @TEXT("${net}", key="netname", size=0.6, halign="start", valign="middle", rotate=90, dx=0, dy=0.4);
//   %g11 = $GROUND @ATTACH &VSS => @PLACE(92, 14.8);
//   &VSS @WIRE {#CPHB:2 (92, 18) %g11:p};
//   #MSH @PLACE(2, 8);
//   #MSH @ORIENT("R0");
//   #MSH:1 @TEXT("${net}", key="netname", size=0.6, halign="start", valign="middle", rotate=90, dx=0, dy=0.4);
//   #MSH:2 @TEXT("${net}", key="netname", size=0.6, halign="end", valign="middle", dx=-0.4, dy=0);
//   #MSH:3 @TEXT("${net}", key="netname", size=0.6, halign="end", valign="middle", rotate=90, dx=0, dy=-0.4);
//   %g12 = $GROUND @ATTACH &VSS => @PLACE(5, 4.8);
//   &VSS @WIRE {#MSH:4 (5, 8) %g12:p};
//   #XDL @PLACE(-34, -26);
//   #XDL @ORIENT("R0");
//   #XDL:HI @TEXT("${net}", key="netname", size=0.6, halign="end", valign="middle", dx=-0.4, dy=0);
//   #XDL:EN @TEXT("${net}", key="netname", size=0.6, halign="end", valign="middle", dx=-0.4, dy=0);
//   #XDL:ENB @TEXT("${net}", key="netname", size=0.6, halign="end", valign="middle", dx=-0.4, dy=0);
//   #XDL:BP @TEXT("${net}", key="netname", size=0.6, halign="start", valign="middle", dx=0.4, dy=0);
//   %v13 = $SUPPLY @ATTACH &VREFP => @PLACE(-34, -17.8);
//   &VREFP @WIRE {#XDL:VREFP (-34, -21) %v13:p};
//   %g14 = $GROUND @ATTACH &VREFN => @PLACE(-36, -34.2);
//   &VREFN @WIRE {#XDL:VREFN (-36, -31) %g14:p};
//   %g15 = $GROUND @ATTACH &VSS => @PLACE(-32, -34.2);
//   &VSS @WIRE {#XDL:VSS (-32, -31) %g15:p};
//   #CLA @PLACE(30, -12) => @ORIENT("R270");
//   #CLA:1 @TEXT("${net}", key="netname", size=0.6, halign="start", valign="middle", dx=0.4, dy=0);
//   #CLA:2 @TEXT("${net}", key="netname", size=0.6, halign="end", valign="middle", dx=-0.4, dy=0);
//   #CPLA @PLACE(76, -30);
//   #CPLA @ORIENT("R0");
//   #CPLA:1 @TEXT("${net}", key="netname", size=0.6, halign="start", valign="middle", rotate=90, dx=0, dy=0.4);
//   %g16 = $GROUND @ATTACH &VSS => @PLACE(76, -35.2);
//   &VSS @WIRE {#CPLA:2 (76, -32) %g16:p};
//   #CLB @PLACE(10, -12) => @ORIENT("R270");
//   #CLB:1 @TEXT("${net}", key="netname", size=0.6, halign="start", valign="middle", dx=0.4, dy=0);
//   #CLB:2 @TEXT("${net}", key="netname", size=0.6, halign="end", valign="middle", dx=-0.4, dy=0);
//   #CPLB @PLACE(92, -30);
//   #CPLB @ORIENT("R0");
//   #CPLB:1 @TEXT("${net}", key="netname", size=0.6, halign="start", valign="middle", rotate=90, dx=0, dy=0.4);
//   %g17 = $GROUND @ATTACH &VSS => @PLACE(92, -35.2);
//   &VSS @WIRE {#CPLB:2 (92, -32) %g17:p};
//   #MSL @PLACE(2, -42);
//   #MSL @ORIENT("R0");
//   #MSL:1 @TEXT("${net}", key="netname", size=0.6, halign="start", valign="middle", rotate=90, dx=0, dy=0.4);
//   #MSL:2 @TEXT("${net}", key="netname", size=0.6, halign="end", valign="middle", dx=-0.4, dy=0);
//   #MSL:3 @TEXT("${net}", key="netname", size=0.6, halign="end", valign="middle", rotate=90, dx=0, dy=-0.4);
//   %g18 = $GROUND @ATTACH &VSS => @PLACE(5, -45.2);
//   &VSS @WIRE {#MSL:4 (5, -42) %g18:p};
//   &HHI @WIRE {#XHCTL:HI (-52, 24) (-52, 26) #XDH:HI};
//   %b_H = (-12, 24);
//   $JUNCTION @ATTACH %b_H;
//   &BH @WIRE {#XDH:BP %b_H};
//   &MIDH @WIRE {#CHB:1 #CHA:2};
//   &BH @WIRE {%b_H (-12, 38) #CHB:2};
//   &BH @WIRE {%b_H (-12, 10) #MSH:1};
//   &LHI @WIRE {#XLCTL:HI (-52, -26) (-52, -24) #XDL:HI};
//   %b_L = (-12, -26);
//   $JUNCTION @ATTACH %b_L;
//   &BL @WIRE {#XDL:BP %b_L};
//   &MIDL @WIRE {#CLB:1 #CLA:2};
//   &BL @WIRE {%b_L (-12, -12) #CLB:2};
//   &BL @WIRE {%b_L (-12, -40) #MSL:1};
//   &VIN @WIRE {#MSH:3 (6, 6) (6, -44) #MSL:3};
//   &VG @WIRE {#MSH:2 (-5, 8) (-5, -42) #MSL:2};
//   %top_H = (44, 24);
//   $JUNCTION @ATTACH %top_H;
//   %top_L = (44, -26);
//   $JUNCTION @ATTACH %top_L;
//   &TOP @WIRE {#CHA:1 (44, 38) %top_H};
//   &TOP @WIRE {#CLA:1 (44, -12) %top_L};
//   &TOP @WIRE {%top_H %top_L};
//   %p_vin = $IO_PORT @ATTACH &VIN => @PLACE(2, 2) => @ORIENT("R90");
//   &VIN @WIRE {%p_vin:p #MSH:3};
//   %p_vg = $IO_PORT @ATTACH &VG => @PLACE(-5, 8) => @ORIENT("R0");
//   &VG @WIRE {%p_vg:p #MSH:2};
//   %p_dh = $IO_PORT @ATTACH &DH => @PLACE(-81, 24) => @ORIENT("R0");
//   &DH @WIRE {%p_dh:p #XHCTL:IN};
//   %p_rl = $IO_PORT @ATTACH &RL => @PLACE(-81, -26) => @ORIENT("R0");
//   &RL @WIRE {%p_rl:p #XLCTL:IN};
//   %p_en = $IO_PORT @ATTACH &EN => @PLACE(-45, 24) => @ORIENT("R0");
//   &EN @WIRE {%p_en:p #XDH:EN};
//   %p_enb = $IO_PORT @ATTACH &ENB => @PLACE(-45, 22) => @ORIENT("R0");
//   &ENB @WIRE {%p_enb:p #XDH:ENB};
//   %p_top = $IO_PORT @ATTACH &TOP => @PLACE(36, 38) => @ORIENT("MY");
//   &TOP @WIRE {%p_top:p #CHA:1};
//   (-10, 60) @TEXT("Matched half-capacitor pair j=0, weight 1") => @SET-STYLE $title_style
// }
ends mq_cdac_bit0

// CDAC candidate: unit MOM banks and series half units
subckt adc_cdac (VIN VG TOP VCM VREFP VREFN PHI_S PHI_SB CONV DH12 DH11 DH10 DH9 DH8 DH7 DH6 DH5 DH4 DH3 DH2 DH1 DH0 RL12 RL11 RL10 RL9 RL8 RL7 RL6 RL5 RL4 RL3 RL2 RL1 RL0 DVDD VSS)
// All reference switches are driven to the reference rails, including at low DVDD.
// The top-plate transmission gate is driven directly by PHI_S/PHI_SB.
// j=9 and j=6 remain connected to their neutral references during sampling.
// Odd half-weights use two identical legal MOM units in series for their half-unit term.
XEN (CONV EN ENB VREFP VREFN VSS) mq_cdac_enable
MTN (TOP PHI_S VCM VSS) nch_ulvt_mac w=3.2e-05 l=3e-08 nf=16
MTP (TOP PHI_SB VCM DVDD) pch_ulvt_mac w=3.2e-05 l=3e-08 nf=16
XB12 (VIN VG DH12 RL12 EN ENB TOP VREFP VREFN VSS) mq_cdac_bit12
XB11 (VIN VG DH11 RL11 EN ENB TOP VREFP VREFN VSS) mq_cdac_bit11
XB10 (VIN VG DH10 RL10 EN ENB TOP VREFP VREFN VSS) mq_cdac_bit10
XB9 (DH9 RL9 VREFP VREFN TOP VREFP VREFN VSS) mq_cdac_bit9
XB8 (VIN VG DH8 RL8 EN ENB TOP VREFP VREFN VSS) mq_cdac_bit8
XB7 (VIN VG DH7 RL7 EN ENB TOP VREFP VREFN VSS) mq_cdac_bit7
XB6 (DH6 RL6 VREFP VREFN TOP VREFP VREFN VSS) mq_cdac_bit6
XB5 (VIN VG DH5 RL5 EN ENB TOP VREFP VREFN VSS) mq_cdac_bit5
XB4 (VIN VG DH4 RL4 EN ENB TOP VREFP VREFN VSS) mq_cdac_bit4
XB3 (VIN VG DH3 RL3 EN ENB TOP VREFP VREFN VSS) mq_cdac_bit3
XB2 (VIN VG DH2 RL2 EN ENB TOP VREFP VREFN VSS) mq_cdac_bit2
XB1 (VIN VG DH1 RL1 EN ENB TOP VREFP VREFN VSS) mq_cdac_bit1
XB0 (VIN VG DH0 RL0 EN ENB TOP VREFP VREFN VSS) mq_cdac_bit0
// @RNL {
//   /* pins connected by net name: the net-name label of rnl-std-fill on every unwired pin, placed below by its key netname */
//   $LABEL_TERMINAL_SET @TEXT("${net}", key="netname", size=0.6);
//   &VSS @ADD-TO $GROUND_NET_SET; &VREFN @ADD-TO $GROUND_NET_SET; &VREFP @ADD-TO $SUPPLY_NET_SET;
//   &DVDD @ADD-TO $SUPPLY_NET_SET;
//   {#MTN #MTP} @GROUP;
//   #XEN @PLACE(88, 12);
//   #XEN @ORIENT("R0");
//   #XEN:IN @TEXT("${net}", key="netname", size=0.6, halign="end", valign="middle", dx=-0.4, dy=0);
//   #XEN:EN @TEXT("${net}", key="netname", size=0.6, halign="start", valign="middle", dx=0.4, dy=0);
//   #XEN:ENB @TEXT("${net}", key="netname", size=0.6, halign="start", valign="middle", dx=0.4, dy=0);
//   %v1 = $SUPPLY @ATTACH &VREFP => @PLACE(88, 19.2);
//   &VREFP @WIRE {#XEN:VREFP (88, 16) %v1:p};
//   %g2 = $GROUND @ATTACH &VREFN => @PLACE(86, 4.8);
//   &VREFN @WIRE {#XEN:VREFN (86, 8) %g2:p};
//   %g3 = $GROUND @ATTACH &VSS => @PLACE(90, 4.8);
//   &VSS @WIRE {#XEN:VSS (90, 8) %g3:p};
//   #MTN @PLACE(88, -18);
//   #MTN @ORIENT("R0");
//   #MTN:1 @TEXT("${net}", key="netname", size=0.6, halign="start", valign="middle", rotate=90, dx=0, dy=0.4);
//   #MTN:2 @TEXT("${net}", key="netname", size=0.6, halign="end", valign="middle", dx=-0.4, dy=0);
//   #MTN:3 @TEXT("${net}", key="netname", size=0.6, halign="end", valign="middle", rotate=90, dx=0, dy=-0.4);
//   %g4 = $GROUND @ATTACH &VSS => @PLACE(91, -21.2);
//   &VSS @WIRE {#MTN:4 (91, -18) %g4:p};
//   #MTP @PLACE(112, -18);
//   #MTP @ORIENT("R0");
//   #MTP:1 @TEXT("${net}", key="netname", size=0.6, halign="end", valign="middle", rotate=90, dx=0, dy=-0.4);
//   #MTP:2 @TEXT("${net}", key="netname", size=0.6, halign="end", valign="middle", dx=-0.4, dy=0);
//   #MTP:3 @TEXT("${net}", key="netname", size=0.6, halign="start", valign="middle", rotate=90, dx=0, dy=0.4);
//   %v5 = $SUPPLY @ATTACH &DVDD => @PLACE(115, -14.8);
//   &DVDD @WIRE {#MTP:4 (115, -18) %v5:p};
//   #XB12 @PLACE(-30, 0);
//   #XB12 @ORIENT("R0");
//   #XB12:VIN @TEXT("${net}", key="netname", size=0.6, halign="end", valign="middle", dx=-0.4, dy=0);
//   #XB12:VG @TEXT("${net}", key="netname", size=0.6, halign="end", valign="middle", dx=-0.4, dy=0);
//   #XB12:DH @TEXT("${net}", key="netname", size=0.6, halign="end", valign="middle", dx=-0.4, dy=0);
//   #XB12:RL @TEXT("${net}", key="netname", size=0.6, halign="end", valign="middle", dx=-0.4, dy=0);
//   #XB12:EN @TEXT("${net}", key="netname", size=0.6, halign="end", valign="middle", dx=-0.4, dy=0);
//   #XB12:ENB @TEXT("${net}", key="netname", size=0.6, halign="end", valign="middle", dx=-0.4, dy=0);
//   #XB12:TOP @TEXT("${net}", key="netname", size=0.6, halign="start", valign="middle", dx=0.4, dy=0);
//   %v6 = $SUPPLY @ATTACH &VREFP => @PLACE(-30, 11.2);
//   &VREFP @WIRE {#XB12:VREFP (-30, 8) %v6:p};
//   %g7 = $GROUND @ATTACH &VREFN => @PLACE(-32, -11.2);
//   &VREFN @WIRE {#XB12:VREFN (-32, -8) %g7:p};
//   %g8 = $GROUND @ATTACH &VSS => @PLACE(-28, -11.2);
//   &VSS @WIRE {#XB12:VSS (-28, -8) %g8:p};
//   #XB11 @PLACE(-30, -42);
//   #XB11 @ORIENT("R0");
//   #XB11:VIN @TEXT("${net}", key="netname", size=0.6, halign="end", valign="middle", dx=-0.4, dy=0);
//   #XB11:VG @TEXT("${net}", key="netname", size=0.6, halign="end", valign="middle", dx=-0.4, dy=0);
//   #XB11:DH @TEXT("${net}", key="netname", size=0.6, halign="end", valign="middle", dx=-0.4, dy=0);
//   #XB11:RL @TEXT("${net}", key="netname", size=0.6, halign="end", valign="middle", dx=-0.4, dy=0);
//   #XB11:EN @TEXT("${net}", key="netname", size=0.6, halign="end", valign="middle", dx=-0.4, dy=0);
//   #XB11:ENB @TEXT("${net}", key="netname", size=0.6, halign="end", valign="middle", dx=-0.4, dy=0);
//   #XB11:TOP @TEXT("${net}", key="netname", size=0.6, halign="start", valign="middle", dx=0.4, dy=0);
//   %v9 = $SUPPLY @ATTACH &VREFP => @PLACE(-30, -30.8);
//   &VREFP @WIRE {#XB11:VREFP (-30, -34) %v9:p};
//   %g10 = $GROUND @ATTACH &VREFN => @PLACE(-32, -53.2);
//   &VREFN @WIRE {#XB11:VREFN (-32, -50) %g10:p};
//   %g11 = $GROUND @ATTACH &VSS => @PLACE(-28, -53.2);
//   &VSS @WIRE {#XB11:VSS (-28, -50) %g11:p};
//   #XB10 @PLACE(-30, -84);
//   #XB10 @ORIENT("R0");
//   #XB10:VIN @TEXT("${net}", key="netname", size=0.6, halign="end", valign="middle", dx=-0.4, dy=0);
//   #XB10:VG @TEXT("${net}", key="netname", size=0.6, halign="end", valign="middle", dx=-0.4, dy=0);
//   #XB10:DH @TEXT("${net}", key="netname", size=0.6, halign="end", valign="middle", dx=-0.4, dy=0);
//   #XB10:RL @TEXT("${net}", key="netname", size=0.6, halign="end", valign="middle", dx=-0.4, dy=0);
//   #XB10:EN @TEXT("${net}", key="netname", size=0.6, halign="end", valign="middle", dx=-0.4, dy=0);
//   #XB10:ENB @TEXT("${net}", key="netname", size=0.6, halign="end", valign="middle", dx=-0.4, dy=0);
//   #XB10:TOP @TEXT("${net}", key="netname", size=0.6, halign="start", valign="middle", dx=0.4, dy=0);
//   %v12 = $SUPPLY @ATTACH &VREFP => @PLACE(-30, -72.8);
//   &VREFP @WIRE {#XB10:VREFP (-30, -76) %v12:p};
//   %g13 = $GROUND @ATTACH &VREFN => @PLACE(-32, -95.2);
//   &VREFN @WIRE {#XB10:VREFN (-32, -92) %g13:p};
//   %g14 = $GROUND @ATTACH &VSS => @PLACE(-28, -95.2);
//   &VSS @WIRE {#XB10:VSS (-28, -92) %g14:p};
//   #XB9 @PLACE(-30, -126);
//   #XB9 @ORIENT("R0");
//   #XB9:DH @TEXT("${net}", key="netname", size=0.6, halign="end", valign="middle", dx=-0.4, dy=0);
//   #XB9:RL @TEXT("${net}", key="netname", size=0.6, halign="end", valign="middle", dx=-0.4, dy=0);
//   %v15 = $SUPPLY @ATTACH &VREFP => @PLACE(-37, -123.8);
//   &VREFP @WIRE {#XB9:EN (-37, -127) %v15:p};
//   %g16 = $GROUND @ATTACH &VREFN => @PLACE(-37, -132.2);
//   &VREFN @WIRE {#XB9:ENB (-37, -129) %g16:p};
//   #XB9:TOP @TEXT("${net}", key="netname", size=0.6, halign="start", valign="middle", dx=0.4, dy=0);
//   %v17 = $SUPPLY @ATTACH &VREFP => @PLACE(-30, -116.8);
//   &VREFP @WIRE {#XB9:VREFP (-30, -120) %v17:p};
//   %g18 = $GROUND @ATTACH &VREFN => @PLACE(-32, -135.2);
//   &VREFN @WIRE {#XB9:VREFN (-32, -132) %g18:p};
//   %g19 = $GROUND @ATTACH &VSS => @PLACE(-28, -135.2);
//   &VSS @WIRE {#XB9:VSS (-28, -132) %g19:p};
//   #XB8 @PLACE(-30, -168);
//   #XB8 @ORIENT("R0");
//   #XB8:VIN @TEXT("${net}", key="netname", size=0.6, halign="end", valign="middle", dx=-0.4, dy=0);
//   #XB8:VG @TEXT("${net}", key="netname", size=0.6, halign="end", valign="middle", dx=-0.4, dy=0);
//   #XB8:DH @TEXT("${net}", key="netname", size=0.6, halign="end", valign="middle", dx=-0.4, dy=0);
//   #XB8:RL @TEXT("${net}", key="netname", size=0.6, halign="end", valign="middle", dx=-0.4, dy=0);
//   #XB8:EN @TEXT("${net}", key="netname", size=0.6, halign="end", valign="middle", dx=-0.4, dy=0);
//   #XB8:ENB @TEXT("${net}", key="netname", size=0.6, halign="end", valign="middle", dx=-0.4, dy=0);
//   #XB8:TOP @TEXT("${net}", key="netname", size=0.6, halign="start", valign="middle", dx=0.4, dy=0);
//   %v20 = $SUPPLY @ATTACH &VREFP => @PLACE(-30, -156.8);
//   &VREFP @WIRE {#XB8:VREFP (-30, -160) %v20:p};
//   %g21 = $GROUND @ATTACH &VREFN => @PLACE(-32, -179.2);
//   &VREFN @WIRE {#XB8:VREFN (-32, -176) %g21:p};
//   %g22 = $GROUND @ATTACH &VSS => @PLACE(-28, -179.2);
//   &VSS @WIRE {#XB8:VSS (-28, -176) %g22:p};
//   #XB7 @PLACE(-30, -210);
//   #XB7 @ORIENT("R0");
//   #XB7:VIN @TEXT("${net}", key="netname", size=0.6, halign="end", valign="middle", dx=-0.4, dy=0);
//   #XB7:VG @TEXT("${net}", key="netname", size=0.6, halign="end", valign="middle", dx=-0.4, dy=0);
//   #XB7:DH @TEXT("${net}", key="netname", size=0.6, halign="end", valign="middle", dx=-0.4, dy=0);
//   #XB7:RL @TEXT("${net}", key="netname", size=0.6, halign="end", valign="middle", dx=-0.4, dy=0);
//   #XB7:EN @TEXT("${net}", key="netname", size=0.6, halign="end", valign="middle", dx=-0.4, dy=0);
//   #XB7:ENB @TEXT("${net}", key="netname", size=0.6, halign="end", valign="middle", dx=-0.4, dy=0);
//   #XB7:TOP @TEXT("${net}", key="netname", size=0.6, halign="start", valign="middle", dx=0.4, dy=0);
//   %v23 = $SUPPLY @ATTACH &VREFP => @PLACE(-30, -198.8);
//   &VREFP @WIRE {#XB7:VREFP (-30, -202) %v23:p};
//   %g24 = $GROUND @ATTACH &VREFN => @PLACE(-32, -221.2);
//   &VREFN @WIRE {#XB7:VREFN (-32, -218) %g24:p};
//   %g25 = $GROUND @ATTACH &VSS => @PLACE(-28, -221.2);
//   &VSS @WIRE {#XB7:VSS (-28, -218) %g25:p};
//   #XB6 @PLACE(-30, -252);
//   #XB6 @ORIENT("R0");
//   #XB6:DH @TEXT("${net}", key="netname", size=0.6, halign="end", valign="middle", dx=-0.4, dy=0);
//   #XB6:RL @TEXT("${net}", key="netname", size=0.6, halign="end", valign="middle", dx=-0.4, dy=0);
//   %v26 = $SUPPLY @ATTACH &VREFP => @PLACE(-37, -249.8);
//   &VREFP @WIRE {#XB6:EN (-37, -253) %v26:p};
//   %g27 = $GROUND @ATTACH &VREFN => @PLACE(-37, -258.2);
//   &VREFN @WIRE {#XB6:ENB (-37, -255) %g27:p};
//   #XB6:TOP @TEXT("${net}", key="netname", size=0.6, halign="start", valign="middle", dx=0.4, dy=0);
//   %v28 = $SUPPLY @ATTACH &VREFP => @PLACE(-30, -242.8);
//   &VREFP @WIRE {#XB6:VREFP (-30, -246) %v28:p};
//   %g29 = $GROUND @ATTACH &VREFN => @PLACE(-32, -261.2);
//   &VREFN @WIRE {#XB6:VREFN (-32, -258) %g29:p};
//   %g30 = $GROUND @ATTACH &VSS => @PLACE(-28, -261.2);
//   &VSS @WIRE {#XB6:VSS (-28, -258) %g30:p};
//   #XB5 @PLACE(28, 0);
//   #XB5 @ORIENT("R0");
//   #XB5:VIN @TEXT("${net}", key="netname", size=0.6, halign="end", valign="middle", dx=-0.4, dy=0);
//   #XB5:VG @TEXT("${net}", key="netname", size=0.6, halign="end", valign="middle", dx=-0.4, dy=0);
//   #XB5:DH @TEXT("${net}", key="netname", size=0.6, halign="end", valign="middle", dx=-0.4, dy=0);
//   #XB5:RL @TEXT("${net}", key="netname", size=0.6, halign="end", valign="middle", dx=-0.4, dy=0);
//   #XB5:EN @TEXT("${net}", key="netname", size=0.6, halign="end", valign="middle", dx=-0.4, dy=0);
//   #XB5:ENB @TEXT("${net}", key="netname", size=0.6, halign="end", valign="middle", dx=-0.4, dy=0);
//   #XB5:TOP @TEXT("${net}", key="netname", size=0.6, halign="start", valign="middle", dx=0.4, dy=0);
//   %v31 = $SUPPLY @ATTACH &VREFP => @PLACE(28, 11.2);
//   &VREFP @WIRE {#XB5:VREFP (28, 8) %v31:p};
//   %g32 = $GROUND @ATTACH &VREFN => @PLACE(26, -11.2);
//   &VREFN @WIRE {#XB5:VREFN (26, -8) %g32:p};
//   %g33 = $GROUND @ATTACH &VSS => @PLACE(30, -11.2);
//   &VSS @WIRE {#XB5:VSS (30, -8) %g33:p};
//   #XB4 @PLACE(28, -42);
//   #XB4 @ORIENT("R0");
//   #XB4:VIN @TEXT("${net}", key="netname", size=0.6, halign="end", valign="middle", dx=-0.4, dy=0);
//   #XB4:VG @TEXT("${net}", key="netname", size=0.6, halign="end", valign="middle", dx=-0.4, dy=0);
//   #XB4:DH @TEXT("${net}", key="netname", size=0.6, halign="end", valign="middle", dx=-0.4, dy=0);
//   #XB4:RL @TEXT("${net}", key="netname", size=0.6, halign="end", valign="middle", dx=-0.4, dy=0);
//   #XB4:EN @TEXT("${net}", key="netname", size=0.6, halign="end", valign="middle", dx=-0.4, dy=0);
//   #XB4:ENB @TEXT("${net}", key="netname", size=0.6, halign="end", valign="middle", dx=-0.4, dy=0);
//   #XB4:TOP @TEXT("${net}", key="netname", size=0.6, halign="start", valign="middle", dx=0.4, dy=0);
//   %v34 = $SUPPLY @ATTACH &VREFP => @PLACE(28, -30.8);
//   &VREFP @WIRE {#XB4:VREFP (28, -34) %v34:p};
//   %g35 = $GROUND @ATTACH &VREFN => @PLACE(26, -53.2);
//   &VREFN @WIRE {#XB4:VREFN (26, -50) %g35:p};
//   %g36 = $GROUND @ATTACH &VSS => @PLACE(30, -53.2);
//   &VSS @WIRE {#XB4:VSS (30, -50) %g36:p};
//   #XB3 @PLACE(28, -84);
//   #XB3 @ORIENT("R0");
//   #XB3:VIN @TEXT("${net}", key="netname", size=0.6, halign="end", valign="middle", dx=-0.4, dy=0);
//   #XB3:VG @TEXT("${net}", key="netname", size=0.6, halign="end", valign="middle", dx=-0.4, dy=0);
//   #XB3:DH @TEXT("${net}", key="netname", size=0.6, halign="end", valign="middle", dx=-0.4, dy=0);
//   #XB3:RL @TEXT("${net}", key="netname", size=0.6, halign="end", valign="middle", dx=-0.4, dy=0);
//   #XB3:EN @TEXT("${net}", key="netname", size=0.6, halign="end", valign="middle", dx=-0.4, dy=0);
//   #XB3:ENB @TEXT("${net}", key="netname", size=0.6, halign="end", valign="middle", dx=-0.4, dy=0);
//   #XB3:TOP @TEXT("${net}", key="netname", size=0.6, halign="start", valign="middle", dx=0.4, dy=0);
//   %v37 = $SUPPLY @ATTACH &VREFP => @PLACE(28, -72.8);
//   &VREFP @WIRE {#XB3:VREFP (28, -76) %v37:p};
//   %g38 = $GROUND @ATTACH &VREFN => @PLACE(26, -95.2);
//   &VREFN @WIRE {#XB3:VREFN (26, -92) %g38:p};
//   %g39 = $GROUND @ATTACH &VSS => @PLACE(30, -95.2);
//   &VSS @WIRE {#XB3:VSS (30, -92) %g39:p};
//   #XB2 @PLACE(28, -126);
//   #XB2 @ORIENT("R0");
//   #XB2:VIN @TEXT("${net}", key="netname", size=0.6, halign="end", valign="middle", dx=-0.4, dy=0);
//   #XB2:VG @TEXT("${net}", key="netname", size=0.6, halign="end", valign="middle", dx=-0.4, dy=0);
//   #XB2:DH @TEXT("${net}", key="netname", size=0.6, halign="end", valign="middle", dx=-0.4, dy=0);
//   #XB2:RL @TEXT("${net}", key="netname", size=0.6, halign="end", valign="middle", dx=-0.4, dy=0);
//   #XB2:EN @TEXT("${net}", key="netname", size=0.6, halign="end", valign="middle", dx=-0.4, dy=0);
//   #XB2:ENB @TEXT("${net}", key="netname", size=0.6, halign="end", valign="middle", dx=-0.4, dy=0);
//   #XB2:TOP @TEXT("${net}", key="netname", size=0.6, halign="start", valign="middle", dx=0.4, dy=0);
//   %v40 = $SUPPLY @ATTACH &VREFP => @PLACE(28, -114.8);
//   &VREFP @WIRE {#XB2:VREFP (28, -118) %v40:p};
//   %g41 = $GROUND @ATTACH &VREFN => @PLACE(26, -137.2);
//   &VREFN @WIRE {#XB2:VREFN (26, -134) %g41:p};
//   %g42 = $GROUND @ATTACH &VSS => @PLACE(30, -137.2);
//   &VSS @WIRE {#XB2:VSS (30, -134) %g42:p};
//   #XB1 @PLACE(28, -168);
//   #XB1 @ORIENT("R0");
//   #XB1:VIN @TEXT("${net}", key="netname", size=0.6, halign="end", valign="middle", dx=-0.4, dy=0);
//   #XB1:VG @TEXT("${net}", key="netname", size=0.6, halign="end", valign="middle", dx=-0.4, dy=0);
//   #XB1:DH @TEXT("${net}", key="netname", size=0.6, halign="end", valign="middle", dx=-0.4, dy=0);
//   #XB1:RL @TEXT("${net}", key="netname", size=0.6, halign="end", valign="middle", dx=-0.4, dy=0);
//   #XB1:EN @TEXT("${net}", key="netname", size=0.6, halign="end", valign="middle", dx=-0.4, dy=0);
//   #XB1:ENB @TEXT("${net}", key="netname", size=0.6, halign="end", valign="middle", dx=-0.4, dy=0);
//   #XB1:TOP @TEXT("${net}", key="netname", size=0.6, halign="start", valign="middle", dx=0.4, dy=0);
//   %v43 = $SUPPLY @ATTACH &VREFP => @PLACE(28, -156.8);
//   &VREFP @WIRE {#XB1:VREFP (28, -160) %v43:p};
//   %g44 = $GROUND @ATTACH &VREFN => @PLACE(26, -179.2);
//   &VREFN @WIRE {#XB1:VREFN (26, -176) %g44:p};
//   %g45 = $GROUND @ATTACH &VSS => @PLACE(30, -179.2);
//   &VSS @WIRE {#XB1:VSS (30, -176) %g45:p};
//   #XB0 @PLACE(28, -210);
//   #XB0 @ORIENT("R0");
//   #XB0:VIN @TEXT("${net}", key="netname", size=0.6, halign="end", valign="middle", dx=-0.4, dy=0);
//   #XB0:VG @TEXT("${net}", key="netname", size=0.6, halign="end", valign="middle", dx=-0.4, dy=0);
//   #XB0:DH @TEXT("${net}", key="netname", size=0.6, halign="end", valign="middle", dx=-0.4, dy=0);
//   #XB0:RL @TEXT("${net}", key="netname", size=0.6, halign="end", valign="middle", dx=-0.4, dy=0);
//   #XB0:EN @TEXT("${net}", key="netname", size=0.6, halign="end", valign="middle", dx=-0.4, dy=0);
//   #XB0:ENB @TEXT("${net}", key="netname", size=0.6, halign="end", valign="middle", dx=-0.4, dy=0);
//   #XB0:TOP @TEXT("${net}", key="netname", size=0.6, halign="start", valign="middle", dx=0.4, dy=0);
//   %v46 = $SUPPLY @ATTACH &VREFP => @PLACE(28, -198.8);
//   &VREFP @WIRE {#XB0:VREFP (28, -202) %v46:p};
//   %g47 = $GROUND @ATTACH &VREFN => @PLACE(26, -221.2);
//   &VREFN @WIRE {#XB0:VREFN (26, -218) %g47:p};
//   %g48 = $GROUND @ATTACH &VSS => @PLACE(30, -221.2);
//   &VSS @WIRE {#XB0:VSS (30, -218) %g48:p};
//   %p_vin = $IO_PORT @ATTACH &VIN => @PLACE(-41, 5) => @ORIENT("R0");
//   &VIN @WIRE {%p_vin:p #XB12:VIN};
//   %p_vg = $IO_PORT @ATTACH &VG => @PLACE(-41, 3) => @ORIENT("R0");
//   &VG @WIRE {%p_vg:p #XB12:VG};
//   %p_top = $IO_PORT @ATTACH &TOP => @PLACE(88, -12) => @ORIENT("R270");
//   &TOP @WIRE {%p_top:p #MTN:1};
//   %p_vcm = $IO_PORT @ATTACH &VCM => @PLACE(88, -24) => @ORIENT("R90");
//   &VCM @WIRE {%p_vcm:p #MTN:3};
//   %p_phi_s = $IO_PORT @ATTACH &PHI_S => @PLACE(81, -18) => @ORIENT("R0");
//   &PHI_S @WIRE {%p_phi_s:p #MTN:2};
//   %p_phi_sb = $IO_PORT @ATTACH &PHI_SB => @PLACE(105, -18) => @ORIENT("R0");
//   &PHI_SB @WIRE {%p_phi_sb:p #MTP:2};
//   %p_conv = $IO_PORT @ATTACH &CONV => @PLACE(77, 12) => @ORIENT("R0");
//   &CONV @WIRE {%p_conv:p #XEN:IN};
//   %p_dh12 = $IO_PORT @ATTACH &DH12 => @PLACE(-41, 1) => @ORIENT("R0");
//   &DH12 @WIRE {%p_dh12:p #XB12:DH};
//   %p_dh11 = $IO_PORT @ATTACH &DH11 => @PLACE(-41, -41) => @ORIENT("R0");
//   &DH11 @WIRE {%p_dh11:p #XB11:DH};
//   %p_dh10 = $IO_PORT @ATTACH &DH10 => @PLACE(-41, -83) => @ORIENT("R0");
//   &DH10 @WIRE {%p_dh10:p #XB10:DH};
//   %p_dh9 = $IO_PORT @ATTACH &DH9 => @PLACE(-41, -123) => @ORIENT("R0");
//   &DH9 @WIRE {%p_dh9:p #XB9:DH};
//   %p_dh8 = $IO_PORT @ATTACH &DH8 => @PLACE(-41, -167) => @ORIENT("R0");
//   &DH8 @WIRE {%p_dh8:p #XB8:DH};
//   %p_dh7 = $IO_PORT @ATTACH &DH7 => @PLACE(-41, -209) => @ORIENT("R0");
//   &DH7 @WIRE {%p_dh7:p #XB7:DH};
//   %p_dh6 = $IO_PORT @ATTACH &DH6 => @PLACE(-41, -249) => @ORIENT("R0");
//   &DH6 @WIRE {%p_dh6:p #XB6:DH};
//   %p_dh5 = $IO_PORT @ATTACH &DH5 => @PLACE(17, 1) => @ORIENT("R0");
//   &DH5 @WIRE {%p_dh5:p #XB5:DH};
//   %p_dh4 = $IO_PORT @ATTACH &DH4 => @PLACE(17, -41) => @ORIENT("R0");
//   &DH4 @WIRE {%p_dh4:p #XB4:DH};
//   %p_dh3 = $IO_PORT @ATTACH &DH3 => @PLACE(17, -83) => @ORIENT("R0");
//   &DH3 @WIRE {%p_dh3:p #XB3:DH};
//   %p_dh2 = $IO_PORT @ATTACH &DH2 => @PLACE(17, -125) => @ORIENT("R0");
//   &DH2 @WIRE {%p_dh2:p #XB2:DH};
//   %p_dh1 = $IO_PORT @ATTACH &DH1 => @PLACE(17, -167) => @ORIENT("R0");
//   &DH1 @WIRE {%p_dh1:p #XB1:DH};
//   %p_dh0 = $IO_PORT @ATTACH &DH0 => @PLACE(17, -209) => @ORIENT("R0");
//   &DH0 @WIRE {%p_dh0:p #XB0:DH};
//   %p_rl12 = $IO_PORT @ATTACH &RL12 => @PLACE(-41, -1) => @ORIENT("R0");
//   &RL12 @WIRE {%p_rl12:p #XB12:RL};
//   %p_rl11 = $IO_PORT @ATTACH &RL11 => @PLACE(-41, -43) => @ORIENT("R0");
//   &RL11 @WIRE {%p_rl11:p #XB11:RL};
//   %p_rl10 = $IO_PORT @ATTACH &RL10 => @PLACE(-41, -85) => @ORIENT("R0");
//   &RL10 @WIRE {%p_rl10:p #XB10:RL};
//   %p_rl9 = $IO_PORT @ATTACH &RL9 => @PLACE(-41, -125) => @ORIENT("R0");
//   &RL9 @WIRE {%p_rl9:p #XB9:RL};
//   %p_rl8 = $IO_PORT @ATTACH &RL8 => @PLACE(-41, -169) => @ORIENT("R0");
//   &RL8 @WIRE {%p_rl8:p #XB8:RL};
//   %p_rl7 = $IO_PORT @ATTACH &RL7 => @PLACE(-41, -211) => @ORIENT("R0");
//   &RL7 @WIRE {%p_rl7:p #XB7:RL};
//   %p_rl6 = $IO_PORT @ATTACH &RL6 => @PLACE(-41, -251) => @ORIENT("R0");
//   &RL6 @WIRE {%p_rl6:p #XB6:RL};
//   %p_rl5 = $IO_PORT @ATTACH &RL5 => @PLACE(17, -1) => @ORIENT("R0");
//   &RL5 @WIRE {%p_rl5:p #XB5:RL};
//   %p_rl4 = $IO_PORT @ATTACH &RL4 => @PLACE(17, -43) => @ORIENT("R0");
//   &RL4 @WIRE {%p_rl4:p #XB4:RL};
//   %p_rl3 = $IO_PORT @ATTACH &RL3 => @PLACE(17, -85) => @ORIENT("R0");
//   &RL3 @WIRE {%p_rl3:p #XB3:RL};
//   %p_rl2 = $IO_PORT @ATTACH &RL2 => @PLACE(17, -127) => @ORIENT("R0");
//   &RL2 @WIRE {%p_rl2:p #XB2:RL};
//   %p_rl1 = $IO_PORT @ATTACH &RL1 => @PLACE(17, -169) => @ORIENT("R0");
//   &RL1 @WIRE {%p_rl1:p #XB1:RL};
//   %p_rl0 = $IO_PORT @ATTACH &RL0 => @PLACE(17, -211) => @ORIENT("R0");
//   &RL0 @WIRE {%p_rl0:p #XB0:RL};
//   (-10, 34) @TEXT("CDAC candidate: unit MOM banks and series half units") => @SET-STYLE $title_style
// }
ends adc_cdac
