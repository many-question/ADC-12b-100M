// adc_sarlogic candidate: static CMOS monotonic completion chain.
// @RNL(type="header") {
//   @VERSION("0.3");
//   @USE-PACKAGE(name="adc28", version="0.1", path="../../../rnl/adc28.rnl");
// }
simulator lang=spectre

// Static CMOS inverter; total W, two fingers.
subckt adc_sarlogic_inv (A Y VDD VSS)
parameters wn=400n wp=600n drive=1
MN (Y A VSS VSS) nch_ulvt_mac w=wn l=30n nf=2 m=drive
MP (Y A VDD VDD) pch_ulvt_mac w=wp l=30n nf=2 m=drive
// @RNL {
//   %symbol = @DEFINE-SYMBOL(box=[-9,-3.0,9,3.0]) {
//     @LINE {(-7,-2.0) (7,-2.0) (7,2.0) (-7,2.0) (-7,-2.0)};
//     (-9,0) @PIN(terminal="A", direction="left");
//     @LINE {(-9,0) (-7,0)};
//     (-6.5,0) @TEXT("A", size=0.7, halign="start");
//     (9,0) @PIN(terminal="Y", direction="right");
//     @LINE {(9,0) (7,0)};
//     (6.5,0) @TEXT("Y", size=0.7, halign="end");
//     (0,3.0) @PIN(terminal="VDD", direction="up");
//     (0,-3.0) @PIN(terminal="VSS", direction="down");
//     ? @TEXT("${name}", key="name", dx=-6, dy=5.0, size=1, halign="start");
//   };
//   # @SET-SYMBOL %symbol;
//   &VDD @ADD-TO $SUPPLY_NET_SET; &VSS @ADD-TO $GROUND_NET_SET;
//   $LABEL_TERMINAL_SET @TEXT("${net}", key="netname", size=0.6);
//   #MN @TEXT("W=${w}, L=${l}, nf=${nf}, m=${m}", key="wl", dx=5, dy=-4, size=0.7, halign="start");
//   #MN @PLACE(0,-8) => @ORIENT("R0");
//   %p_MN_d=(0,-3);
//   &Y @WIRE(mode="straight") {#MN:d %p_MN_d};
//   %p_MN_d @TEXT("Y", size=0.8, halign="start", dy=0.5);
//   %p_MN_g=(-6,-8);
//   &A @WIRE(mode="straight") {#MN:g %p_MN_g};
//   %p_MN_g @TEXT("A", size=0.8, halign="end", dy=0);
//   %p_MN_s=(0,-13);
//   &VSS @WIRE(mode="straight") {#MN:s %p_MN_s};
//   %p_MN_s @TEXT("VSS", size=0.8, halign="start", dy=0.5);
//   %p_MN_b=(4,-8);
//   &VSS @WIRE(mode="straight") {#MN:b %p_MN_b};
//   %p_MN_b @TEXT("VSS", size=0.8, halign="start", dy=0);
//   #MP @TEXT("W=${w}, L=${l}, nf=${nf}, m=${m}", key="wl", dx=5, dy=4, size=0.7, halign="start");
//   #MP @PLACE(0,6) => @ORIENT("R0");
//   %p_MP_d=(0,1);
//   &Y @WIRE(mode="straight") {#MP:d %p_MP_d};
//   %p_MP_d @TEXT("Y", size=0.8, halign="start", dy=0.5);
//   %p_MP_g=(-6,6);
//   &A @WIRE(mode="straight") {#MP:g %p_MP_g};
//   %p_MP_g @TEXT("A", size=0.8, halign="end", dy=0);
//   %p_MP_s=(0,11);
//   &VDD @WIRE(mode="straight") {#MP:s %p_MP_s};
//   %p_MP_s @TEXT("VDD", size=0.8, halign="start", dy=0.5);
//   %p_MP_b=(4,6);
//   &VDD @WIRE(mode="straight") {#MP:b %p_MP_b};
//   %p_MP_b @TEXT("VDD", size=0.8, halign="start", dy=0);
//   {#MN #MP} @GROUP;
//   {&A &Y &VDD &VSS} @REMOVE-FROM $PORT_FILL_SET;
//   %port0=$IO_PORT @ATTACH &A => @PLACE(-28,0) => @ORIENT("R0");
//   %port1=$IO_PORT @ATTACH &Y => @PLACE(-28,-3) => @ORIENT("R0");
//   %port2=$IO_PORT @ATTACH &VDD => @PLACE(-28,-6) => @ORIENT("R0");
//   %port3=$IO_PORT @ATTACH &VSS => @PLACE(-28,-9) => @ORIENT("R0");
//   (-28,24) @TEXT("adc_sarlogic_inv", size=1.2, bold=true);
//   (-28,20) @TEXT("Static CMOS inverter; total W, two fingers.", size=0.7);
//   (-28,16) @TEXT("Defaults: wn=400n wp=600n drive=1", size=0.8);
// }
ends adc_sarlogic_inv

// Parallel pull-up, series pull-down; full static CMOS.
subckt adc_sarlogic_nand2 (A B Y VDD VSS)
parameters wn=800n wp=600n
MPA (Y A VDD VDD) pch_ulvt_mac w=wp l=30n nf=2
MNA (Y A nx1 VSS) nch_ulvt_mac w=wn l=30n nf=2
MPB (Y B VDD VDD) pch_ulvt_mac w=wp l=30n nf=2
MNB (nx1 B VSS VSS) nch_ulvt_mac w=wn l=30n nf=2
// @RNL {
//   %symbol = @DEFINE-SYMBOL(box=[-9,-4.0,9,4.0]) {
//     @LINE {(-7,-3.0) (7,-3.0) (7,3.0) (-7,3.0) (-7,-3.0)};
//     (-9,1) @PIN(terminal="A", direction="left");
//     @LINE {(-9,1) (-7,1)};
//     (-6.5,1) @TEXT("A", size=0.7, halign="start");
//     (-9,-1) @PIN(terminal="B", direction="left");
//     @LINE {(-9,-1) (-7,-1)};
//     (-6.5,-1) @TEXT("B", size=0.7, halign="start");
//     (9,0) @PIN(terminal="Y", direction="right");
//     @LINE {(9,0) (7,0)};
//     (6.5,0) @TEXT("Y", size=0.7, halign="end");
//     (0,4.0) @PIN(terminal="VDD", direction="up");
//     (0,-4.0) @PIN(terminal="VSS", direction="down");
//     ? @TEXT("${name}", key="name", dx=-6, dy=6.0, size=1, halign="start");
//   };
//   # @SET-SYMBOL %symbol;
//   &VDD @ADD-TO $SUPPLY_NET_SET; &VSS @ADD-TO $GROUND_NET_SET;
//   $LABEL_TERMINAL_SET @TEXT("${net}", key="netname", size=0.6);
//   #MPA @TEXT("W=${w}, L=${l}, nf=${nf}", key="wl", dx=5, dy=4, size=0.7, halign="start");
//   #MPA @PLACE(0,6) => @ORIENT("R0");
//   %p_MPA_d=(0,1);
//   &Y @WIRE(mode="straight") {#MPA:d %p_MPA_d};
//   %p_MPA_d @TEXT("Y", size=0.8, halign="start", dy=0.5);
//   %p_MPA_g=(-6,6);
//   &A @WIRE(mode="straight") {#MPA:g %p_MPA_g};
//   %p_MPA_g @TEXT("A", size=0.8, halign="end", dy=0);
//   %p_MPA_s=(0,11);
//   &VDD @WIRE(mode="straight") {#MPA:s %p_MPA_s};
//   %p_MPA_s @TEXT("VDD", size=0.8, halign="start", dy=0.5);
//   %p_MPA_b=(4,6);
//   &VDD @WIRE(mode="straight") {#MPA:b %p_MPA_b};
//   %p_MPA_b @TEXT("VDD", size=0.8, halign="start", dy=0);
//   #MNA @TEXT("W=${w}, L=${l}, nf=${nf}", key="wl", dx=5, dy=-4, size=0.7, halign="start");
//   #MNA @PLACE(0,-8) => @ORIENT("R0");
//   %p_MNA_d=(0,-3);
//   &Y @WIRE(mode="straight") {#MNA:d %p_MNA_d};
//   %p_MNA_d @TEXT("Y", size=0.8, halign="start", dy=0.5);
//   %p_MNA_g=(-6,-8);
//   &A @WIRE(mode="straight") {#MNA:g %p_MNA_g};
//   %p_MNA_g @TEXT("A", size=0.8, halign="end", dy=0);
//   %p_MNA_s=(0,-13);
//   &nx1 @WIRE(mode="straight") {#MNA:s %p_MNA_s};
//   %p_MNA_s @TEXT("nx1", size=0.8, halign="start", dy=0.5);
//   %p_MNA_b=(4,-8);
//   &VSS @WIRE(mode="straight") {#MNA:b %p_MNA_b};
//   %p_MNA_b @TEXT("VSS", size=0.8, halign="start", dy=0);
//   #MPB @TEXT("W=${w}, L=${l}, nf=${nf}", key="wl", dx=5, dy=4, size=0.7, halign="start");
//   #MPB @PLACE(18,6) => @ORIENT("R0");
//   %p_MPB_d=(18,1);
//   &Y @WIRE(mode="straight") {#MPB:d %p_MPB_d};
//   %p_MPB_d @TEXT("Y", size=0.8, halign="start", dy=0.5);
//   %p_MPB_g=(12,6);
//   &B @WIRE(mode="straight") {#MPB:g %p_MPB_g};
//   %p_MPB_g @TEXT("B", size=0.8, halign="end", dy=0);
//   %p_MPB_s=(18,11);
//   &VDD @WIRE(mode="straight") {#MPB:s %p_MPB_s};
//   %p_MPB_s @TEXT("VDD", size=0.8, halign="start", dy=0.5);
//   %p_MPB_b=(22,6);
//   &VDD @WIRE(mode="straight") {#MPB:b %p_MPB_b};
//   %p_MPB_b @TEXT("VDD", size=0.8, halign="start", dy=0);
//   #MNB @TEXT("W=${w}, L=${l}, nf=${nf}", key="wl", dx=5, dy=-4, size=0.7, halign="start");
//   #MNB @PLACE(18,-8) => @ORIENT("R0");
//   %p_MNB_d=(18,-3);
//   &nx1 @WIRE(mode="straight") {#MNB:d %p_MNB_d};
//   %p_MNB_d @TEXT("nx1", size=0.8, halign="start", dy=0.5);
//   %p_MNB_g=(12,-8);
//   &B @WIRE(mode="straight") {#MNB:g %p_MNB_g};
//   %p_MNB_g @TEXT("B", size=0.8, halign="end", dy=0);
//   %p_MNB_s=(18,-13);
//   &VSS @WIRE(mode="straight") {#MNB:s %p_MNB_s};
//   %p_MNB_s @TEXT("VSS", size=0.8, halign="start", dy=0.5);
//   %p_MNB_b=(22,-8);
//   &VSS @WIRE(mode="straight") {#MNB:b %p_MNB_b};
//   %p_MNB_b @TEXT("VSS", size=0.8, halign="start", dy=0);
//   {#MPA #MNA #MPB #MNB} @GROUP;
//   {#MNA #MNB} @AS $MATCHED;
//   {#MPA #MPB} @AS $MATCHED;
//   {&A &B &Y &VDD &VSS} @REMOVE-FROM $PORT_FILL_SET;
//   %port0=$IO_PORT @ATTACH &A => @PLACE(-28,0) => @ORIENT("R0");
//   %port1=$IO_PORT @ATTACH &B => @PLACE(-28,-3) => @ORIENT("R0");
//   %port2=$IO_PORT @ATTACH &Y => @PLACE(-28,-6) => @ORIENT("R0");
//   %port3=$IO_PORT @ATTACH &VDD => @PLACE(-28,-9) => @ORIENT("R0");
//   %port4=$IO_PORT @ATTACH &VSS => @PLACE(-28,-12) => @ORIENT("R0");
//   (-28,24) @TEXT("adc_sarlogic_nand2", size=1.2, bold=true);
//   (-28,20) @TEXT("Parallel pull-up, series pull-down; full static CMOS.", size=0.7);
//   (-28,16) @TEXT("Defaults: wn=800n wp=600n", size=0.8);
// }
ends adc_sarlogic_nand2

// Parallel pull-up, series pull-down; full static CMOS.
subckt adc_sarlogic_nand3 (A B C Y VDD VSS)
parameters wn=1200n wp=600n
MPA (Y A VDD VDD) pch_ulvt_mac w=wp l=30n nf=2
MNA (Y A nx1 VSS) nch_ulvt_mac w=wn l=30n nf=2
MPB (Y B VDD VDD) pch_ulvt_mac w=wp l=30n nf=2
MNB (nx1 B nx2 VSS) nch_ulvt_mac w=wn l=30n nf=2
MPC (Y C VDD VDD) pch_ulvt_mac w=wp l=30n nf=2
MNC (nx2 C VSS VSS) nch_ulvt_mac w=wn l=30n nf=2
// @RNL {
//   %symbol = @DEFINE-SYMBOL(box=[-9,-5.0,9,5.0]) {
//     @LINE {(-7,-4.0) (7,-4.0) (7,4.0) (-7,4.0) (-7,-4.0)};
//     (-9,2) @PIN(terminal="A", direction="left");
//     @LINE {(-9,2) (-7,2)};
//     (-6.5,2) @TEXT("A", size=0.7, halign="start");
//     (-9,0) @PIN(terminal="B", direction="left");
//     @LINE {(-9,0) (-7,0)};
//     (-6.5,0) @TEXT("B", size=0.7, halign="start");
//     (-9,-2) @PIN(terminal="C", direction="left");
//     @LINE {(-9,-2) (-7,-2)};
//     (-6.5,-2) @TEXT("C", size=0.7, halign="start");
//     (9,0) @PIN(terminal="Y", direction="right");
//     @LINE {(9,0) (7,0)};
//     (6.5,0) @TEXT("Y", size=0.7, halign="end");
//     (0,5.0) @PIN(terminal="VDD", direction="up");
//     (0,-5.0) @PIN(terminal="VSS", direction="down");
//     ? @TEXT("${name}", key="name", dx=-6, dy=7.0, size=1, halign="start");
//   };
//   # @SET-SYMBOL %symbol;
//   &VDD @ADD-TO $SUPPLY_NET_SET; &VSS @ADD-TO $GROUND_NET_SET;
//   $LABEL_TERMINAL_SET @TEXT("${net}", key="netname", size=0.6);
//   #MPA @TEXT("W=${w}, L=${l}, nf=${nf}", key="wl", dx=5, dy=4, size=0.7, halign="start");
//   #MPA @PLACE(0,6) => @ORIENT("R0");
//   %p_MPA_d=(0,1);
//   &Y @WIRE(mode="straight") {#MPA:d %p_MPA_d};
//   %p_MPA_d @TEXT("Y", size=0.8, halign="start", dy=0.5);
//   %p_MPA_g=(-6,6);
//   &A @WIRE(mode="straight") {#MPA:g %p_MPA_g};
//   %p_MPA_g @TEXT("A", size=0.8, halign="end", dy=0);
//   %p_MPA_s=(0,11);
//   &VDD @WIRE(mode="straight") {#MPA:s %p_MPA_s};
//   %p_MPA_s @TEXT("VDD", size=0.8, halign="start", dy=0.5);
//   %p_MPA_b=(4,6);
//   &VDD @WIRE(mode="straight") {#MPA:b %p_MPA_b};
//   %p_MPA_b @TEXT("VDD", size=0.8, halign="start", dy=0);
//   #MNA @TEXT("W=${w}, L=${l}, nf=${nf}", key="wl", dx=5, dy=-4, size=0.7, halign="start");
//   #MNA @PLACE(0,-8) => @ORIENT("R0");
//   %p_MNA_d=(0,-3);
//   &Y @WIRE(mode="straight") {#MNA:d %p_MNA_d};
//   %p_MNA_d @TEXT("Y", size=0.8, halign="start", dy=0.5);
//   %p_MNA_g=(-6,-8);
//   &A @WIRE(mode="straight") {#MNA:g %p_MNA_g};
//   %p_MNA_g @TEXT("A", size=0.8, halign="end", dy=0);
//   %p_MNA_s=(0,-13);
//   &nx1 @WIRE(mode="straight") {#MNA:s %p_MNA_s};
//   %p_MNA_s @TEXT("nx1", size=0.8, halign="start", dy=0.5);
//   %p_MNA_b=(4,-8);
//   &VSS @WIRE(mode="straight") {#MNA:b %p_MNA_b};
//   %p_MNA_b @TEXT("VSS", size=0.8, halign="start", dy=0);
//   #MPB @TEXT("W=${w}, L=${l}, nf=${nf}", key="wl", dx=5, dy=4, size=0.7, halign="start");
//   #MPB @PLACE(18,6) => @ORIENT("R0");
//   %p_MPB_d=(18,1);
//   &Y @WIRE(mode="straight") {#MPB:d %p_MPB_d};
//   %p_MPB_d @TEXT("Y", size=0.8, halign="start", dy=0.5);
//   %p_MPB_g=(12,6);
//   &B @WIRE(mode="straight") {#MPB:g %p_MPB_g};
//   %p_MPB_g @TEXT("B", size=0.8, halign="end", dy=0);
//   %p_MPB_s=(18,11);
//   &VDD @WIRE(mode="straight") {#MPB:s %p_MPB_s};
//   %p_MPB_s @TEXT("VDD", size=0.8, halign="start", dy=0.5);
//   %p_MPB_b=(22,6);
//   &VDD @WIRE(mode="straight") {#MPB:b %p_MPB_b};
//   %p_MPB_b @TEXT("VDD", size=0.8, halign="start", dy=0);
//   #MNB @TEXT("W=${w}, L=${l}, nf=${nf}", key="wl", dx=5, dy=-4, size=0.7, halign="start");
//   #MNB @PLACE(18,-8) => @ORIENT("R0");
//   %p_MNB_d=(18,-3);
//   &nx1 @WIRE(mode="straight") {#MNB:d %p_MNB_d};
//   %p_MNB_d @TEXT("nx1", size=0.8, halign="start", dy=0.5);
//   %p_MNB_g=(12,-8);
//   &B @WIRE(mode="straight") {#MNB:g %p_MNB_g};
//   %p_MNB_g @TEXT("B", size=0.8, halign="end", dy=0);
//   %p_MNB_s=(18,-13);
//   &nx2 @WIRE(mode="straight") {#MNB:s %p_MNB_s};
//   %p_MNB_s @TEXT("nx2", size=0.8, halign="start", dy=0.5);
//   %p_MNB_b=(22,-8);
//   &VSS @WIRE(mode="straight") {#MNB:b %p_MNB_b};
//   %p_MNB_b @TEXT("VSS", size=0.8, halign="start", dy=0);
//   #MPC @TEXT("W=${w}, L=${l}, nf=${nf}", key="wl", dx=5, dy=4, size=0.7, halign="start");
//   #MPC @PLACE(36,6) => @ORIENT("R0");
//   %p_MPC_d=(36,1);
//   &Y @WIRE(mode="straight") {#MPC:d %p_MPC_d};
//   %p_MPC_d @TEXT("Y", size=0.8, halign="start", dy=0.5);
//   %p_MPC_g=(30,6);
//   &C @WIRE(mode="straight") {#MPC:g %p_MPC_g};
//   %p_MPC_g @TEXT("C", size=0.8, halign="end", dy=0);
//   %p_MPC_s=(36,11);
//   &VDD @WIRE(mode="straight") {#MPC:s %p_MPC_s};
//   %p_MPC_s @TEXT("VDD", size=0.8, halign="start", dy=0.5);
//   %p_MPC_b=(40,6);
//   &VDD @WIRE(mode="straight") {#MPC:b %p_MPC_b};
//   %p_MPC_b @TEXT("VDD", size=0.8, halign="start", dy=0);
//   #MNC @TEXT("W=${w}, L=${l}, nf=${nf}", key="wl", dx=5, dy=-4, size=0.7, halign="start");
//   #MNC @PLACE(36,-8) => @ORIENT("R0");
//   %p_MNC_d=(36,-3);
//   &nx2 @WIRE(mode="straight") {#MNC:d %p_MNC_d};
//   %p_MNC_d @TEXT("nx2", size=0.8, halign="start", dy=0.5);
//   %p_MNC_g=(30,-8);
//   &C @WIRE(mode="straight") {#MNC:g %p_MNC_g};
//   %p_MNC_g @TEXT("C", size=0.8, halign="end", dy=0);
//   %p_MNC_s=(36,-13);
//   &VSS @WIRE(mode="straight") {#MNC:s %p_MNC_s};
//   %p_MNC_s @TEXT("VSS", size=0.8, halign="start", dy=0.5);
//   %p_MNC_b=(40,-8);
//   &VSS @WIRE(mode="straight") {#MNC:b %p_MNC_b};
//   %p_MNC_b @TEXT("VSS", size=0.8, halign="start", dy=0);
//   {#MPA #MNA #MPB #MNB #MPC #MNC} @GROUP;
//   {#MNA #MNB #MNC} @AS $MATCHED;
//   {#MPA #MPB #MPC} @AS $MATCHED;
//   {&A &B &C &Y &VDD &VSS} @REMOVE-FROM $PORT_FILL_SET;
//   %port0=$IO_PORT @ATTACH &A => @PLACE(-28,0) => @ORIENT("R0");
//   %port1=$IO_PORT @ATTACH &B => @PLACE(-28,-3) => @ORIENT("R0");
//   %port2=$IO_PORT @ATTACH &C => @PLACE(-28,-6) => @ORIENT("R0");
//   %port3=$IO_PORT @ATTACH &Y => @PLACE(-28,-9) => @ORIENT("R0");
//   %port4=$IO_PORT @ATTACH &VDD => @PLACE(-28,-12) => @ORIENT("R0");
//   %port5=$IO_PORT @ATTACH &VSS => @PLACE(-28,-15) => @ORIENT("R0");
//   (-28,24) @TEXT("adc_sarlogic_nand3", size=1.2, bold=true);
//   (-28,20) @TEXT("Parallel pull-up, series pull-down; full static CMOS.", size=0.7);
//   (-28,16) @TEXT("Defaults: wn=1200n wp=600n", size=0.8);
// }
ends adc_sarlogic_nand3

// Parallel pull-up, series pull-down; full static CMOS.
subckt adc_sarlogic_nand4 (A B C D Y VDD VSS)
parameters wn=1600n wp=600n
MPA (Y A VDD VDD) pch_ulvt_mac w=wp l=30n nf=2
MNA (Y A nx1 VSS) nch_ulvt_mac w=wn l=30n nf=2
MPB (Y B VDD VDD) pch_ulvt_mac w=wp l=30n nf=2
MNB (nx1 B nx2 VSS) nch_ulvt_mac w=wn l=30n nf=2
MPC (Y C VDD VDD) pch_ulvt_mac w=wp l=30n nf=2
MNC (nx2 C nx3 VSS) nch_ulvt_mac w=wn l=30n nf=2
MPD (Y D VDD VDD) pch_ulvt_mac w=wp l=30n nf=2
MND (nx3 D VSS VSS) nch_ulvt_mac w=wn l=30n nf=2
// @RNL {
//   %symbol = @DEFINE-SYMBOL(box=[-9,-6.0,9,6.0]) {
//     @LINE {(-7,-5.0) (7,-5.0) (7,5.0) (-7,5.0) (-7,-5.0)};
//     (-9,3) @PIN(terminal="A", direction="left");
//     @LINE {(-9,3) (-7,3)};
//     (-6.5,3) @TEXT("A", size=0.7, halign="start");
//     (-9,1) @PIN(terminal="B", direction="left");
//     @LINE {(-9,1) (-7,1)};
//     (-6.5,1) @TEXT("B", size=0.7, halign="start");
//     (-9,-1) @PIN(terminal="C", direction="left");
//     @LINE {(-9,-1) (-7,-1)};
//     (-6.5,-1) @TEXT("C", size=0.7, halign="start");
//     (-9,-3) @PIN(terminal="D", direction="left");
//     @LINE {(-9,-3) (-7,-3)};
//     (-6.5,-3) @TEXT("D", size=0.7, halign="start");
//     (9,0) @PIN(terminal="Y", direction="right");
//     @LINE {(9,0) (7,0)};
//     (6.5,0) @TEXT("Y", size=0.7, halign="end");
//     (0,6.0) @PIN(terminal="VDD", direction="up");
//     (0,-6.0) @PIN(terminal="VSS", direction="down");
//     ? @TEXT("${name}", key="name", dx=-6, dy=8.0, size=1, halign="start");
//   };
//   # @SET-SYMBOL %symbol;
//   &VDD @ADD-TO $SUPPLY_NET_SET; &VSS @ADD-TO $GROUND_NET_SET;
//   $LABEL_TERMINAL_SET @TEXT("${net}", key="netname", size=0.6);
//   #MPA @TEXT("W=${w}, L=${l}, nf=${nf}", key="wl", dx=5, dy=4, size=0.7, halign="start");
//   #MPA @PLACE(0,6) => @ORIENT("R0");
//   %p_MPA_d=(0,1);
//   &Y @WIRE(mode="straight") {#MPA:d %p_MPA_d};
//   %p_MPA_d @TEXT("Y", size=0.8, halign="start", dy=0.5);
//   %p_MPA_g=(-6,6);
//   &A @WIRE(mode="straight") {#MPA:g %p_MPA_g};
//   %p_MPA_g @TEXT("A", size=0.8, halign="end", dy=0);
//   %p_MPA_s=(0,11);
//   &VDD @WIRE(mode="straight") {#MPA:s %p_MPA_s};
//   %p_MPA_s @TEXT("VDD", size=0.8, halign="start", dy=0.5);
//   %p_MPA_b=(4,6);
//   &VDD @WIRE(mode="straight") {#MPA:b %p_MPA_b};
//   %p_MPA_b @TEXT("VDD", size=0.8, halign="start", dy=0);
//   #MNA @TEXT("W=${w}, L=${l}, nf=${nf}", key="wl", dx=5, dy=-4, size=0.7, halign="start");
//   #MNA @PLACE(0,-8) => @ORIENT("R0");
//   %p_MNA_d=(0,-3);
//   &Y @WIRE(mode="straight") {#MNA:d %p_MNA_d};
//   %p_MNA_d @TEXT("Y", size=0.8, halign="start", dy=0.5);
//   %p_MNA_g=(-6,-8);
//   &A @WIRE(mode="straight") {#MNA:g %p_MNA_g};
//   %p_MNA_g @TEXT("A", size=0.8, halign="end", dy=0);
//   %p_MNA_s=(0,-13);
//   &nx1 @WIRE(mode="straight") {#MNA:s %p_MNA_s};
//   %p_MNA_s @TEXT("nx1", size=0.8, halign="start", dy=0.5);
//   %p_MNA_b=(4,-8);
//   &VSS @WIRE(mode="straight") {#MNA:b %p_MNA_b};
//   %p_MNA_b @TEXT("VSS", size=0.8, halign="start", dy=0);
//   #MPB @TEXT("W=${w}, L=${l}, nf=${nf}", key="wl", dx=5, dy=4, size=0.7, halign="start");
//   #MPB @PLACE(18,6) => @ORIENT("R0");
//   %p_MPB_d=(18,1);
//   &Y @WIRE(mode="straight") {#MPB:d %p_MPB_d};
//   %p_MPB_d @TEXT("Y", size=0.8, halign="start", dy=0.5);
//   %p_MPB_g=(12,6);
//   &B @WIRE(mode="straight") {#MPB:g %p_MPB_g};
//   %p_MPB_g @TEXT("B", size=0.8, halign="end", dy=0);
//   %p_MPB_s=(18,11);
//   &VDD @WIRE(mode="straight") {#MPB:s %p_MPB_s};
//   %p_MPB_s @TEXT("VDD", size=0.8, halign="start", dy=0.5);
//   %p_MPB_b=(22,6);
//   &VDD @WIRE(mode="straight") {#MPB:b %p_MPB_b};
//   %p_MPB_b @TEXT("VDD", size=0.8, halign="start", dy=0);
//   #MNB @TEXT("W=${w}, L=${l}, nf=${nf}", key="wl", dx=5, dy=-4, size=0.7, halign="start");
//   #MNB @PLACE(18,-8) => @ORIENT("R0");
//   %p_MNB_d=(18,-3);
//   &nx1 @WIRE(mode="straight") {#MNB:d %p_MNB_d};
//   %p_MNB_d @TEXT("nx1", size=0.8, halign="start", dy=0.5);
//   %p_MNB_g=(12,-8);
//   &B @WIRE(mode="straight") {#MNB:g %p_MNB_g};
//   %p_MNB_g @TEXT("B", size=0.8, halign="end", dy=0);
//   %p_MNB_s=(18,-13);
//   &nx2 @WIRE(mode="straight") {#MNB:s %p_MNB_s};
//   %p_MNB_s @TEXT("nx2", size=0.8, halign="start", dy=0.5);
//   %p_MNB_b=(22,-8);
//   &VSS @WIRE(mode="straight") {#MNB:b %p_MNB_b};
//   %p_MNB_b @TEXT("VSS", size=0.8, halign="start", dy=0);
//   #MPC @TEXT("W=${w}, L=${l}, nf=${nf}", key="wl", dx=5, dy=4, size=0.7, halign="start");
//   #MPC @PLACE(36,6) => @ORIENT("R0");
//   %p_MPC_d=(36,1);
//   &Y @WIRE(mode="straight") {#MPC:d %p_MPC_d};
//   %p_MPC_d @TEXT("Y", size=0.8, halign="start", dy=0.5);
//   %p_MPC_g=(30,6);
//   &C @WIRE(mode="straight") {#MPC:g %p_MPC_g};
//   %p_MPC_g @TEXT("C", size=0.8, halign="end", dy=0);
//   %p_MPC_s=(36,11);
//   &VDD @WIRE(mode="straight") {#MPC:s %p_MPC_s};
//   %p_MPC_s @TEXT("VDD", size=0.8, halign="start", dy=0.5);
//   %p_MPC_b=(40,6);
//   &VDD @WIRE(mode="straight") {#MPC:b %p_MPC_b};
//   %p_MPC_b @TEXT("VDD", size=0.8, halign="start", dy=0);
//   #MNC @TEXT("W=${w}, L=${l}, nf=${nf}", key="wl", dx=5, dy=-4, size=0.7, halign="start");
//   #MNC @PLACE(36,-8) => @ORIENT("R0");
//   %p_MNC_d=(36,-3);
//   &nx2 @WIRE(mode="straight") {#MNC:d %p_MNC_d};
//   %p_MNC_d @TEXT("nx2", size=0.8, halign="start", dy=0.5);
//   %p_MNC_g=(30,-8);
//   &C @WIRE(mode="straight") {#MNC:g %p_MNC_g};
//   %p_MNC_g @TEXT("C", size=0.8, halign="end", dy=0);
//   %p_MNC_s=(36,-13);
//   &nx3 @WIRE(mode="straight") {#MNC:s %p_MNC_s};
//   %p_MNC_s @TEXT("nx3", size=0.8, halign="start", dy=0.5);
//   %p_MNC_b=(40,-8);
//   &VSS @WIRE(mode="straight") {#MNC:b %p_MNC_b};
//   %p_MNC_b @TEXT("VSS", size=0.8, halign="start", dy=0);
//   #MPD @TEXT("W=${w}, L=${l}, nf=${nf}", key="wl", dx=5, dy=4, size=0.7, halign="start");
//   #MPD @PLACE(54,6) => @ORIENT("R0");
//   %p_MPD_d=(54,1);
//   &Y @WIRE(mode="straight") {#MPD:d %p_MPD_d};
//   %p_MPD_d @TEXT("Y", size=0.8, halign="start", dy=0.5);
//   %p_MPD_g=(48,6);
//   &D @WIRE(mode="straight") {#MPD:g %p_MPD_g};
//   %p_MPD_g @TEXT("D", size=0.8, halign="end", dy=0);
//   %p_MPD_s=(54,11);
//   &VDD @WIRE(mode="straight") {#MPD:s %p_MPD_s};
//   %p_MPD_s @TEXT("VDD", size=0.8, halign="start", dy=0.5);
//   %p_MPD_b=(58,6);
//   &VDD @WIRE(mode="straight") {#MPD:b %p_MPD_b};
//   %p_MPD_b @TEXT("VDD", size=0.8, halign="start", dy=0);
//   #MND @TEXT("W=${w}, L=${l}, nf=${nf}", key="wl", dx=5, dy=-4, size=0.7, halign="start");
//   #MND @PLACE(54,-8) => @ORIENT("R0");
//   %p_MND_d=(54,-3);
//   &nx3 @WIRE(mode="straight") {#MND:d %p_MND_d};
//   %p_MND_d @TEXT("nx3", size=0.8, halign="start", dy=0.5);
//   %p_MND_g=(48,-8);
//   &D @WIRE(mode="straight") {#MND:g %p_MND_g};
//   %p_MND_g @TEXT("D", size=0.8, halign="end", dy=0);
//   %p_MND_s=(54,-13);
//   &VSS @WIRE(mode="straight") {#MND:s %p_MND_s};
//   %p_MND_s @TEXT("VSS", size=0.8, halign="start", dy=0.5);
//   %p_MND_b=(58,-8);
//   &VSS @WIRE(mode="straight") {#MND:b %p_MND_b};
//   %p_MND_b @TEXT("VSS", size=0.8, halign="start", dy=0);
//   {#MPA #MNA #MPB #MNB #MPC #MNC #MPD #MND} @GROUP;
//   {#MNA #MNB #MNC #MND} @AS $MATCHED;
//   {#MPA #MPB #MPC #MPD} @AS $MATCHED;
//   {&A &B &C &D &Y &VDD &VSS} @REMOVE-FROM $PORT_FILL_SET;
//   %port0=$IO_PORT @ATTACH &A => @PLACE(-28,0) => @ORIENT("R0");
//   %port1=$IO_PORT @ATTACH &B => @PLACE(-28,-3) => @ORIENT("R0");
//   %port2=$IO_PORT @ATTACH &C => @PLACE(-28,-6) => @ORIENT("R0");
//   %port3=$IO_PORT @ATTACH &D => @PLACE(-28,-9) => @ORIENT("R0");
//   %port4=$IO_PORT @ATTACH &Y => @PLACE(-28,-12) => @ORIENT("R0");
//   %port5=$IO_PORT @ATTACH &VDD => @PLACE(-28,-15) => @ORIENT("R0");
//   %port6=$IO_PORT @ATTACH &VSS => @PLACE(-28,-18) => @ORIENT("R0");
//   (-28,24) @TEXT("adc_sarlogic_nand4", size=1.2, bold=true);
//   (-28,20) @TEXT("Parallel pull-up, series pull-down; full static CMOS.", size=0.7);
//   (-28,16) @TEXT("Defaults: wn=1600n wp=600n", size=0.8);
// }
ends adc_sarlogic_nand4

// Parallel pull-up, series pull-down; full static CMOS.
subckt adc_sarlogic_nand5 (A B C D E Y VDD VSS)
parameters wn=16u wp=2400n
MPA (Y A VDD VDD) pch_ulvt_mac w=wp l=30n nf=2
MNA (Y A nx1 VSS) nch_ulvt_mac w=wn l=30n nf=8
MPB (Y B VDD VDD) pch_ulvt_mac w=wp l=30n nf=2
MNB (nx1 B nx2 VSS) nch_ulvt_mac w=wn l=30n nf=8
MPC (Y C VDD VDD) pch_ulvt_mac w=wp l=30n nf=2
MNC (nx2 C nx3 VSS) nch_ulvt_mac w=wn l=30n nf=8
MPD (Y D VDD VDD) pch_ulvt_mac w=wp l=30n nf=2
MND (nx3 D nx4 VSS) nch_ulvt_mac w=wn l=30n nf=8
MPE (Y E VDD VDD) pch_ulvt_mac w=wp l=30n nf=2
MNE (nx4 E VSS VSS) nch_ulvt_mac w=wn l=30n nf=8
// @RNL {
//   %symbol = @DEFINE-SYMBOL(box=[-9,-7.0,9,7.0]) {
//     @LINE {(-7,-6.0) (7,-6.0) (7,6.0) (-7,6.0) (-7,-6.0)};
//     (-9,4) @PIN(terminal="A", direction="left");
//     @LINE {(-9,4) (-7,4)};
//     (-6.5,4) @TEXT("A", size=0.7, halign="start");
//     (-9,2) @PIN(terminal="B", direction="left");
//     @LINE {(-9,2) (-7,2)};
//     (-6.5,2) @TEXT("B", size=0.7, halign="start");
//     (-9,0) @PIN(terminal="C", direction="left");
//     @LINE {(-9,0) (-7,0)};
//     (-6.5,0) @TEXT("C", size=0.7, halign="start");
//     (-9,-2) @PIN(terminal="D", direction="left");
//     @LINE {(-9,-2) (-7,-2)};
//     (-6.5,-2) @TEXT("D", size=0.7, halign="start");
//     (-9,-4) @PIN(terminal="E", direction="left");
//     @LINE {(-9,-4) (-7,-4)};
//     (-6.5,-4) @TEXT("E", size=0.7, halign="start");
//     (9,0) @PIN(terminal="Y", direction="right");
//     @LINE {(9,0) (7,0)};
//     (6.5,0) @TEXT("Y", size=0.7, halign="end");
//     (0,7.0) @PIN(terminal="VDD", direction="up");
//     (0,-7.0) @PIN(terminal="VSS", direction="down");
//     ? @TEXT("${name}", key="name", dx=-6, dy=9.0, size=1, halign="start");
//   };
//   # @SET-SYMBOL %symbol;
//   &VDD @ADD-TO $SUPPLY_NET_SET; &VSS @ADD-TO $GROUND_NET_SET;
//   $LABEL_TERMINAL_SET @TEXT("${net}", key="netname", size=0.6);
//   #MPA @TEXT("W=${w}, L=${l}, nf=${nf}", key="wl", dx=5, dy=4, size=0.7, halign="start");
//   #MPA @PLACE(0,6) => @ORIENT("R0");
//   %p_MPA_d=(0,1);
//   &Y @WIRE(mode="straight") {#MPA:d %p_MPA_d};
//   %p_MPA_d @TEXT("Y", size=0.8, halign="start", dy=0.5);
//   %p_MPA_g=(-6,6);
//   &A @WIRE(mode="straight") {#MPA:g %p_MPA_g};
//   %p_MPA_g @TEXT("A", size=0.8, halign="end", dy=0);
//   %p_MPA_s=(0,11);
//   &VDD @WIRE(mode="straight") {#MPA:s %p_MPA_s};
//   %p_MPA_s @TEXT("VDD", size=0.8, halign="start", dy=0.5);
//   %p_MPA_b=(4,6);
//   &VDD @WIRE(mode="straight") {#MPA:b %p_MPA_b};
//   %p_MPA_b @TEXT("VDD", size=0.8, halign="start", dy=0);
//   #MNA @TEXT("W=${w}, L=${l}, nf=${nf}", key="wl", dx=5, dy=-4, size=0.7, halign="start");
//   #MNA @PLACE(0,-8) => @ORIENT("R0");
//   %p_MNA_d=(0,-3);
//   &Y @WIRE(mode="straight") {#MNA:d %p_MNA_d};
//   %p_MNA_d @TEXT("Y", size=0.8, halign="start", dy=0.5);
//   %p_MNA_g=(-6,-8);
//   &A @WIRE(mode="straight") {#MNA:g %p_MNA_g};
//   %p_MNA_g @TEXT("A", size=0.8, halign="end", dy=0);
//   %p_MNA_s=(0,-13);
//   &nx1 @WIRE(mode="straight") {#MNA:s %p_MNA_s};
//   %p_MNA_s @TEXT("nx1", size=0.8, halign="start", dy=0.5);
//   %p_MNA_b=(4,-8);
//   &VSS @WIRE(mode="straight") {#MNA:b %p_MNA_b};
//   %p_MNA_b @TEXT("VSS", size=0.8, halign="start", dy=0);
//   #MPB @TEXT("W=${w}, L=${l}, nf=${nf}", key="wl", dx=5, dy=4, size=0.7, halign="start");
//   #MPB @PLACE(18,6) => @ORIENT("R0");
//   %p_MPB_d=(18,1);
//   &Y @WIRE(mode="straight") {#MPB:d %p_MPB_d};
//   %p_MPB_d @TEXT("Y", size=0.8, halign="start", dy=0.5);
//   %p_MPB_g=(12,6);
//   &B @WIRE(mode="straight") {#MPB:g %p_MPB_g};
//   %p_MPB_g @TEXT("B", size=0.8, halign="end", dy=0);
//   %p_MPB_s=(18,11);
//   &VDD @WIRE(mode="straight") {#MPB:s %p_MPB_s};
//   %p_MPB_s @TEXT("VDD", size=0.8, halign="start", dy=0.5);
//   %p_MPB_b=(22,6);
//   &VDD @WIRE(mode="straight") {#MPB:b %p_MPB_b};
//   %p_MPB_b @TEXT("VDD", size=0.8, halign="start", dy=0);
//   #MNB @TEXT("W=${w}, L=${l}, nf=${nf}", key="wl", dx=5, dy=-4, size=0.7, halign="start");
//   #MNB @PLACE(18,-8) => @ORIENT("R0");
//   %p_MNB_d=(18,-3);
//   &nx1 @WIRE(mode="straight") {#MNB:d %p_MNB_d};
//   %p_MNB_d @TEXT("nx1", size=0.8, halign="start", dy=0.5);
//   %p_MNB_g=(12,-8);
//   &B @WIRE(mode="straight") {#MNB:g %p_MNB_g};
//   %p_MNB_g @TEXT("B", size=0.8, halign="end", dy=0);
//   %p_MNB_s=(18,-13);
//   &nx2 @WIRE(mode="straight") {#MNB:s %p_MNB_s};
//   %p_MNB_s @TEXT("nx2", size=0.8, halign="start", dy=0.5);
//   %p_MNB_b=(22,-8);
//   &VSS @WIRE(mode="straight") {#MNB:b %p_MNB_b};
//   %p_MNB_b @TEXT("VSS", size=0.8, halign="start", dy=0);
//   #MPC @TEXT("W=${w}, L=${l}, nf=${nf}", key="wl", dx=5, dy=4, size=0.7, halign="start");
//   #MPC @PLACE(36,6) => @ORIENT("R0");
//   %p_MPC_d=(36,1);
//   &Y @WIRE(mode="straight") {#MPC:d %p_MPC_d};
//   %p_MPC_d @TEXT("Y", size=0.8, halign="start", dy=0.5);
//   %p_MPC_g=(30,6);
//   &C @WIRE(mode="straight") {#MPC:g %p_MPC_g};
//   %p_MPC_g @TEXT("C", size=0.8, halign="end", dy=0);
//   %p_MPC_s=(36,11);
//   &VDD @WIRE(mode="straight") {#MPC:s %p_MPC_s};
//   %p_MPC_s @TEXT("VDD", size=0.8, halign="start", dy=0.5);
//   %p_MPC_b=(40,6);
//   &VDD @WIRE(mode="straight") {#MPC:b %p_MPC_b};
//   %p_MPC_b @TEXT("VDD", size=0.8, halign="start", dy=0);
//   #MNC @TEXT("W=${w}, L=${l}, nf=${nf}", key="wl", dx=5, dy=-4, size=0.7, halign="start");
//   #MNC @PLACE(36,-8) => @ORIENT("R0");
//   %p_MNC_d=(36,-3);
//   &nx2 @WIRE(mode="straight") {#MNC:d %p_MNC_d};
//   %p_MNC_d @TEXT("nx2", size=0.8, halign="start", dy=0.5);
//   %p_MNC_g=(30,-8);
//   &C @WIRE(mode="straight") {#MNC:g %p_MNC_g};
//   %p_MNC_g @TEXT("C", size=0.8, halign="end", dy=0);
//   %p_MNC_s=(36,-13);
//   &nx3 @WIRE(mode="straight") {#MNC:s %p_MNC_s};
//   %p_MNC_s @TEXT("nx3", size=0.8, halign="start", dy=0.5);
//   %p_MNC_b=(40,-8);
//   &VSS @WIRE(mode="straight") {#MNC:b %p_MNC_b};
//   %p_MNC_b @TEXT("VSS", size=0.8, halign="start", dy=0);
//   #MPD @TEXT("W=${w}, L=${l}, nf=${nf}", key="wl", dx=5, dy=4, size=0.7, halign="start");
//   #MPD @PLACE(54,6) => @ORIENT("R0");
//   %p_MPD_d=(54,1);
//   &Y @WIRE(mode="straight") {#MPD:d %p_MPD_d};
//   %p_MPD_d @TEXT("Y", size=0.8, halign="start", dy=0.5);
//   %p_MPD_g=(48,6);
//   &D @WIRE(mode="straight") {#MPD:g %p_MPD_g};
//   %p_MPD_g @TEXT("D", size=0.8, halign="end", dy=0);
//   %p_MPD_s=(54,11);
//   &VDD @WIRE(mode="straight") {#MPD:s %p_MPD_s};
//   %p_MPD_s @TEXT("VDD", size=0.8, halign="start", dy=0.5);
//   %p_MPD_b=(58,6);
//   &VDD @WIRE(mode="straight") {#MPD:b %p_MPD_b};
//   %p_MPD_b @TEXT("VDD", size=0.8, halign="start", dy=0);
//   #MND @TEXT("W=${w}, L=${l}, nf=${nf}", key="wl", dx=5, dy=-4, size=0.7, halign="start");
//   #MND @PLACE(54,-8) => @ORIENT("R0");
//   %p_MND_d=(54,-3);
//   &nx3 @WIRE(mode="straight") {#MND:d %p_MND_d};
//   %p_MND_d @TEXT("nx3", size=0.8, halign="start", dy=0.5);
//   %p_MND_g=(48,-8);
//   &D @WIRE(mode="straight") {#MND:g %p_MND_g};
//   %p_MND_g @TEXT("D", size=0.8, halign="end", dy=0);
//   %p_MND_s=(54,-13);
//   &nx4 @WIRE(mode="straight") {#MND:s %p_MND_s};
//   %p_MND_s @TEXT("nx4", size=0.8, halign="start", dy=0.5);
//   %p_MND_b=(58,-8);
//   &VSS @WIRE(mode="straight") {#MND:b %p_MND_b};
//   %p_MND_b @TEXT("VSS", size=0.8, halign="start", dy=0);
//   #MPE @TEXT("W=${w}, L=${l}, nf=${nf}", key="wl", dx=5, dy=4, size=0.7, halign="start");
//   #MPE @PLACE(72,6) => @ORIENT("R0");
//   %p_MPE_d=(72,1);
//   &Y @WIRE(mode="straight") {#MPE:d %p_MPE_d};
//   %p_MPE_d @TEXT("Y", size=0.8, halign="start", dy=0.5);
//   %p_MPE_g=(66,6);
//   &E @WIRE(mode="straight") {#MPE:g %p_MPE_g};
//   %p_MPE_g @TEXT("E", size=0.8, halign="end", dy=0);
//   %p_MPE_s=(72,11);
//   &VDD @WIRE(mode="straight") {#MPE:s %p_MPE_s};
//   %p_MPE_s @TEXT("VDD", size=0.8, halign="start", dy=0.5);
//   %p_MPE_b=(76,6);
//   &VDD @WIRE(mode="straight") {#MPE:b %p_MPE_b};
//   %p_MPE_b @TEXT("VDD", size=0.8, halign="start", dy=0);
//   #MNE @TEXT("W=${w}, L=${l}, nf=${nf}", key="wl", dx=5, dy=-4, size=0.7, halign="start");
//   #MNE @PLACE(72,-8) => @ORIENT("R0");
//   %p_MNE_d=(72,-3);
//   &nx4 @WIRE(mode="straight") {#MNE:d %p_MNE_d};
//   %p_MNE_d @TEXT("nx4", size=0.8, halign="start", dy=0.5);
//   %p_MNE_g=(66,-8);
//   &E @WIRE(mode="straight") {#MNE:g %p_MNE_g};
//   %p_MNE_g @TEXT("E", size=0.8, halign="end", dy=0);
//   %p_MNE_s=(72,-13);
//   &VSS @WIRE(mode="straight") {#MNE:s %p_MNE_s};
//   %p_MNE_s @TEXT("VSS", size=0.8, halign="start", dy=0.5);
//   %p_MNE_b=(76,-8);
//   &VSS @WIRE(mode="straight") {#MNE:b %p_MNE_b};
//   %p_MNE_b @TEXT("VSS", size=0.8, halign="start", dy=0);
//   {#MPA #MNA #MPB #MNB #MPC #MNC #MPD #MND #MPE #MNE} @GROUP;
//   {#MNA #MNB #MNC #MND #MNE} @AS $MATCHED;
//   {#MPA #MPB #MPC #MPD #MPE} @AS $MATCHED;
//   {&A &B &C &D &E &Y &VDD &VSS} @REMOVE-FROM $PORT_FILL_SET;
//   %port0=$IO_PORT @ATTACH &A => @PLACE(-28,0) => @ORIENT("R0");
//   %port1=$IO_PORT @ATTACH &B => @PLACE(-28,-3) => @ORIENT("R0");
//   %port2=$IO_PORT @ATTACH &C => @PLACE(-28,-6) => @ORIENT("R0");
//   %port3=$IO_PORT @ATTACH &D => @PLACE(-28,-9) => @ORIENT("R0");
//   %port4=$IO_PORT @ATTACH &E => @PLACE(-28,-12) => @ORIENT("R0");
//   %port5=$IO_PORT @ATTACH &Y => @PLACE(-28,-15) => @ORIENT("R0");
//   %port6=$IO_PORT @ATTACH &VDD => @PLACE(-28,-18) => @ORIENT("R0");
//   %port7=$IO_PORT @ATTACH &VSS => @PLACE(-28,-21) => @ORIENT("R0");
//   (-28,24) @TEXT("adc_sarlogic_nand5", size=1.2, bold=true);
//   (-28,20) @TEXT("Parallel pull-up, series pull-down; full static CMOS.", size=0.7);
//   (-28,16) @TEXT("Defaults: wn=16u wp=2400n", size=0.8);
// }
ends adc_sarlogic_nand5

// Series pull-up, parallel pull-down; full static CMOS.
subckt adc_sarlogic_nor2 (A B Y VDD VSS)
parameters wn=400n wp=1200n drive=1
MPA (px A VDD VDD) pch_ulvt_mac w=wp l=30n nf=2 m=drive
MPB (Y B px VDD) pch_ulvt_mac w=wp l=30n nf=2 m=drive
MNA (Y A VSS VSS) nch_ulvt_mac w=wn l=30n nf=2 m=drive
MNB (Y B VSS VSS) nch_ulvt_mac w=wn l=30n nf=2 m=drive
// @RNL {
//   %symbol = @DEFINE-SYMBOL(box=[-9,-4.0,9,4.0]) {
//     @LINE {(-7,-3.0) (7,-3.0) (7,3.0) (-7,3.0) (-7,-3.0)};
//     (-9,1) @PIN(terminal="A", direction="left");
//     @LINE {(-9,1) (-7,1)};
//     (-6.5,1) @TEXT("A", size=0.7, halign="start");
//     (-9,-1) @PIN(terminal="B", direction="left");
//     @LINE {(-9,-1) (-7,-1)};
//     (-6.5,-1) @TEXT("B", size=0.7, halign="start");
//     (9,0) @PIN(terminal="Y", direction="right");
//     @LINE {(9,0) (7,0)};
//     (6.5,0) @TEXT("Y", size=0.7, halign="end");
//     (0,4.0) @PIN(terminal="VDD", direction="up");
//     (0,-4.0) @PIN(terminal="VSS", direction="down");
//     ? @TEXT("${name}", key="name", dx=-6, dy=6.0, size=1, halign="start");
//   };
//   # @SET-SYMBOL %symbol;
//   &VDD @ADD-TO $SUPPLY_NET_SET; &VSS @ADD-TO $GROUND_NET_SET;
//   $LABEL_TERMINAL_SET @TEXT("${net}", key="netname", size=0.6);
//   #MPA @TEXT("W=${w}, L=${l}, nf=${nf}, m=${m}", key="wl", dx=5, dy=4, size=0.7, halign="start");
//   #MPA @PLACE(0,6) => @ORIENT("R0");
//   %p_MPA_d=(0,1);
//   &px @WIRE(mode="straight") {#MPA:d %p_MPA_d};
//   %p_MPA_d @TEXT("px", size=0.8, halign="start", dy=0.5);
//   %p_MPA_g=(-6,6);
//   &A @WIRE(mode="straight") {#MPA:g %p_MPA_g};
//   %p_MPA_g @TEXT("A", size=0.8, halign="end", dy=0);
//   %p_MPA_s=(0,11);
//   &VDD @WIRE(mode="straight") {#MPA:s %p_MPA_s};
//   %p_MPA_s @TEXT("VDD", size=0.8, halign="start", dy=0.5);
//   %p_MPA_b=(4,6);
//   &VDD @WIRE(mode="straight") {#MPA:b %p_MPA_b};
//   %p_MPA_b @TEXT("VDD", size=0.8, halign="start", dy=0);
//   #MPB @TEXT("W=${w}, L=${l}, nf=${nf}, m=${m}", key="wl", dx=5, dy=4, size=0.7, halign="start");
//   #MPB @PLACE(0,6) => @ORIENT("R0");
//   %p_MPB_d=(0,1);
//   &Y @WIRE(mode="straight") {#MPB:d %p_MPB_d};
//   %p_MPB_d @TEXT("Y", size=0.8, halign="start", dy=0.5);
//   %p_MPB_g=(-6,6);
//   &B @WIRE(mode="straight") {#MPB:g %p_MPB_g};
//   %p_MPB_g @TEXT("B", size=0.8, halign="end", dy=0);
//   %p_MPB_s=(0,11);
//   &px @WIRE(mode="straight") {#MPB:s %p_MPB_s};
//   %p_MPB_s @TEXT("px", size=0.8, halign="start", dy=0.5);
//   %p_MPB_b=(4,6);
//   &VDD @WIRE(mode="straight") {#MPB:b %p_MPB_b};
//   %p_MPB_b @TEXT("VDD", size=0.8, halign="start", dy=0);
//   #MNA @TEXT("W=${w}, L=${l}, nf=${nf}, m=${m}", key="wl", dx=5, dy=-4, size=0.7, halign="start");
//   #MNA @PLACE(18,-8) => @ORIENT("R0");
//   %p_MNA_d=(18,-3);
//   &Y @WIRE(mode="straight") {#MNA:d %p_MNA_d};
//   %p_MNA_d @TEXT("Y", size=0.8, halign="start", dy=0.5);
//   %p_MNA_g=(12,-8);
//   &A @WIRE(mode="straight") {#MNA:g %p_MNA_g};
//   %p_MNA_g @TEXT("A", size=0.8, halign="end", dy=0);
//   %p_MNA_s=(18,-13);
//   &VSS @WIRE(mode="straight") {#MNA:s %p_MNA_s};
//   %p_MNA_s @TEXT("VSS", size=0.8, halign="start", dy=0.5);
//   %p_MNA_b=(22,-8);
//   &VSS @WIRE(mode="straight") {#MNA:b %p_MNA_b};
//   %p_MNA_b @TEXT("VSS", size=0.8, halign="start", dy=0);
//   #MNB @TEXT("W=${w}, L=${l}, nf=${nf}, m=${m}", key="wl", dx=5, dy=-4, size=0.7, halign="start");
//   #MNB @PLACE(18,-8) => @ORIENT("R0");
//   %p_MNB_d=(18,-3);
//   &Y @WIRE(mode="straight") {#MNB:d %p_MNB_d};
//   %p_MNB_d @TEXT("Y", size=0.8, halign="start", dy=0.5);
//   %p_MNB_g=(12,-8);
//   &B @WIRE(mode="straight") {#MNB:g %p_MNB_g};
//   %p_MNB_g @TEXT("B", size=0.8, halign="end", dy=0);
//   %p_MNB_s=(18,-13);
//   &VSS @WIRE(mode="straight") {#MNB:s %p_MNB_s};
//   %p_MNB_s @TEXT("VSS", size=0.8, halign="start", dy=0.5);
//   %p_MNB_b=(22,-8);
//   &VSS @WIRE(mode="straight") {#MNB:b %p_MNB_b};
//   %p_MNB_b @TEXT("VSS", size=0.8, halign="start", dy=0);
//   {#MPA #MPB #MNA #MNB} @GROUP;
//   {#MNA #MNB} @AS $MATCHED;
//   {#MPA #MPB} @AS $MATCHED;
//   {&A &B &Y &VDD &VSS} @REMOVE-FROM $PORT_FILL_SET;
//   %port0=$IO_PORT @ATTACH &A => @PLACE(-28,0) => @ORIENT("R0");
//   %port1=$IO_PORT @ATTACH &B => @PLACE(-28,-3) => @ORIENT("R0");
//   %port2=$IO_PORT @ATTACH &Y => @PLACE(-28,-6) => @ORIENT("R0");
//   %port3=$IO_PORT @ATTACH &VDD => @PLACE(-28,-9) => @ORIENT("R0");
//   %port4=$IO_PORT @ATTACH &VSS => @PLACE(-28,-12) => @ORIENT("R0");
//   (-28,24) @TEXT("adc_sarlogic_nor2", size=1.2, bold=true);
//   (-28,20) @TEXT("Series pull-up, parallel pull-down; full static CMOS.", size=0.7);
//   (-28,16) @TEXT("Defaults: wn=400n wp=1200n drive=1", size=0.8);
// }
ends adc_sarlogic_nor2

// Non-inverting static AND.
subckt adc_sarlogic_and2 (A B Y VDD VSS)
IN (A B nb VDD VSS) adc_sarlogic_nand2
IO (nb Y VDD VSS) adc_sarlogic_inv
// @RNL {
//   %symbol = @DEFINE-SYMBOL(box=[-9,-4.0,9,4.0]) {
//     @LINE {(-7,-3.0) (7,-3.0) (7,3.0) (-7,3.0) (-7,-3.0)};
//     (-9,1) @PIN(terminal="A", direction="left");
//     @LINE {(-9,1) (-7,1)};
//     (-6.5,1) @TEXT("A", size=0.7, halign="start");
//     (-9,-1) @PIN(terminal="B", direction="left");
//     @LINE {(-9,-1) (-7,-1)};
//     (-6.5,-1) @TEXT("B", size=0.7, halign="start");
//     (9,0) @PIN(terminal="Y", direction="right");
//     @LINE {(9,0) (7,0)};
//     (6.5,0) @TEXT("Y", size=0.7, halign="end");
//     (0,4.0) @PIN(terminal="VDD", direction="up");
//     (0,-4.0) @PIN(terminal="VSS", direction="down");
//     ? @TEXT("${name}", key="name", dx=-6, dy=6.0, size=1, halign="start");
//   };
//   # @SET-SYMBOL %symbol;
//   &VDD @ADD-TO $SUPPLY_NET_SET; &VSS @ADD-TO $GROUND_NET_SET;
//   $LABEL_TERMINAL_SET @TEXT("${net}", key="netname", size=0.6);
//   #IN @PLACE(0,0) => @ORIENT("R0");
//   %p_IN_A=(-12,1);
//   &A @WIRE(mode="straight") {#IN:A %p_IN_A};
//   %p_IN_A @TEXT("A", size=0.8, halign="end", dy=0);
//   %p_IN_B=(-12,-1);
//   &B @WIRE(mode="straight") {#IN:B %p_IN_B};
//   %p_IN_B @TEXT("B", size=0.8, halign="end", dy=0);
//   %p_IN_Y=(12,0);
//   &nb @WIRE(mode="straight") {#IN:Y %p_IN_Y};
//   %p_IN_Y @TEXT("nb", size=0.8, halign="start", dy=0);
//   %p_IN_VDD=(0,7.0);
//   &VDD @WIRE(mode="straight") {#IN:VDD %p_IN_VDD};
//   %p_IN_VDD @TEXT("VDD", size=0.8, halign="start", dy=0.5);
//   %p_IN_VSS=(0,-7.0);
//   &VSS @WIRE(mode="straight") {#IN:VSS %p_IN_VSS};
//   %p_IN_VSS @TEXT("VSS", size=0.8, halign="start", dy=0.5);
//   #IO @PLACE(42,0) => @ORIENT("R0");
//   %p_IO_A=(30,0);
//   &nb @WIRE(mode="straight") {#IO:A %p_IO_A};
//   %p_IO_A @TEXT("nb", size=0.8, halign="end", dy=0);
//   %p_IO_Y=(54,0);
//   &Y @WIRE(mode="straight") {#IO:Y %p_IO_Y};
//   %p_IO_Y @TEXT("Y", size=0.8, halign="start", dy=0);
//   %p_IO_VDD=(42,6.0);
//   &VDD @WIRE(mode="straight") {#IO:VDD %p_IO_VDD};
//   %p_IO_VDD @TEXT("VDD", size=0.8, halign="start", dy=0.5);
//   %p_IO_VSS=(42,-6.0);
//   &VSS @WIRE(mode="straight") {#IO:VSS %p_IO_VSS};
//   %p_IO_VSS @TEXT("VSS", size=0.8, halign="start", dy=0.5);
//   {#IN #IO} @GROUP;
//   {&A &B &Y &VDD &VSS} @REMOVE-FROM $PORT_FILL_SET;
//   %port0=$IO_PORT @ATTACH &A => @PLACE(-28,0) => @ORIENT("R0");
//   %port1=$IO_PORT @ATTACH &B => @PLACE(-28,-3) => @ORIENT("R0");
//   %port2=$IO_PORT @ATTACH &Y => @PLACE(-28,-6) => @ORIENT("R0");
//   %port3=$IO_PORT @ATTACH &VDD => @PLACE(-28,-9) => @ORIENT("R0");
//   %port4=$IO_PORT @ATTACH &VSS => @PLACE(-28,-12) => @ORIENT("R0");
//   (-28,24) @TEXT("adc_sarlogic_and2", size=1.2, bold=true);
//   (-28,20) @TEXT("Non-inverting static AND.", size=0.7);
// }
ends adc_sarlogic_and2

// Non-inverting static OR.
subckt adc_sarlogic_or2 (A B Y VDD VSS)
IN (A B nb VDD VSS) adc_sarlogic_nor2
IO (nb Y VDD VSS) adc_sarlogic_inv
// @RNL {
//   %symbol = @DEFINE-SYMBOL(box=[-9,-4.0,9,4.0]) {
//     @LINE {(-7,-3.0) (7,-3.0) (7,3.0) (-7,3.0) (-7,-3.0)};
//     (-9,1) @PIN(terminal="A", direction="left");
//     @LINE {(-9,1) (-7,1)};
//     (-6.5,1) @TEXT("A", size=0.7, halign="start");
//     (-9,-1) @PIN(terminal="B", direction="left");
//     @LINE {(-9,-1) (-7,-1)};
//     (-6.5,-1) @TEXT("B", size=0.7, halign="start");
//     (9,0) @PIN(terminal="Y", direction="right");
//     @LINE {(9,0) (7,0)};
//     (6.5,0) @TEXT("Y", size=0.7, halign="end");
//     (0,4.0) @PIN(terminal="VDD", direction="up");
//     (0,-4.0) @PIN(terminal="VSS", direction="down");
//     ? @TEXT("${name}", key="name", dx=-6, dy=6.0, size=1, halign="start");
//   };
//   # @SET-SYMBOL %symbol;
//   &VDD @ADD-TO $SUPPLY_NET_SET; &VSS @ADD-TO $GROUND_NET_SET;
//   $LABEL_TERMINAL_SET @TEXT("${net}", key="netname", size=0.6);
//   #IN @PLACE(0,0) => @ORIENT("R0");
//   %p_IN_A=(-12,1);
//   &A @WIRE(mode="straight") {#IN:A %p_IN_A};
//   %p_IN_A @TEXT("A", size=0.8, halign="end", dy=0);
//   %p_IN_B=(-12,-1);
//   &B @WIRE(mode="straight") {#IN:B %p_IN_B};
//   %p_IN_B @TEXT("B", size=0.8, halign="end", dy=0);
//   %p_IN_Y=(12,0);
//   &nb @WIRE(mode="straight") {#IN:Y %p_IN_Y};
//   %p_IN_Y @TEXT("nb", size=0.8, halign="start", dy=0);
//   %p_IN_VDD=(0,7.0);
//   &VDD @WIRE(mode="straight") {#IN:VDD %p_IN_VDD};
//   %p_IN_VDD @TEXT("VDD", size=0.8, halign="start", dy=0.5);
//   %p_IN_VSS=(0,-7.0);
//   &VSS @WIRE(mode="straight") {#IN:VSS %p_IN_VSS};
//   %p_IN_VSS @TEXT("VSS", size=0.8, halign="start", dy=0.5);
//   #IO @PLACE(42,0) => @ORIENT("R0");
//   %p_IO_A=(30,0);
//   &nb @WIRE(mode="straight") {#IO:A %p_IO_A};
//   %p_IO_A @TEXT("nb", size=0.8, halign="end", dy=0);
//   %p_IO_Y=(54,0);
//   &Y @WIRE(mode="straight") {#IO:Y %p_IO_Y};
//   %p_IO_Y @TEXT("Y", size=0.8, halign="start", dy=0);
//   %p_IO_VDD=(42,6.0);
//   &VDD @WIRE(mode="straight") {#IO:VDD %p_IO_VDD};
//   %p_IO_VDD @TEXT("VDD", size=0.8, halign="start", dy=0.5);
//   %p_IO_VSS=(42,-6.0);
//   &VSS @WIRE(mode="straight") {#IO:VSS %p_IO_VSS};
//   %p_IO_VSS @TEXT("VSS", size=0.8, halign="start", dy=0.5);
//   {#IN #IO} @GROUP;
//   {&A &B &Y &VDD &VSS} @REMOVE-FROM $PORT_FILL_SET;
//   %port0=$IO_PORT @ATTACH &A => @PLACE(-28,0) => @ORIENT("R0");
//   %port1=$IO_PORT @ATTACH &B => @PLACE(-28,-3) => @ORIENT("R0");
//   %port2=$IO_PORT @ATTACH &Y => @PLACE(-28,-6) => @ORIENT("R0");
//   %port3=$IO_PORT @ATTACH &VDD => @PLACE(-28,-9) => @ORIENT("R0");
//   %port4=$IO_PORT @ATTACH &VSS => @PLACE(-28,-12) => @ORIENT("R0");
//   (-28,24) @TEXT("adc_sarlogic_or2", size=1.2, bold=true);
//   (-28,20) @TEXT("Non-inverting static OR.", size=0.7);
// }
ends adc_sarlogic_or2

// Two-stage output buffer; scale only the final device widths.
subckt adc_sarlogic_buf (A Y VDD VSS)
parameters drive=1
I0 (A nb VDD VSS) adc_sarlogic_inv wn=1200n wp=1800n
MNOUT (Y nb VSS VSS) nch_ulvt_mac w=800n l=30n nf=2 m=drive
MPOUT (Y nb VDD VDD) pch_ulvt_mac w=1200n l=30n nf=2 m=drive
// @RNL {
//   %symbol = @DEFINE-SYMBOL(box=[-9,-3.0,9,3.0]) {
//     @LINE {(-7,-2.0) (7,-2.0) (7,2.0) (-7,2.0) (-7,-2.0)};
//     (-9,0) @PIN(terminal="A", direction="left");
//     @LINE {(-9,0) (-7,0)};
//     (-6.5,0) @TEXT("A", size=0.7, halign="start");
//     (9,0) @PIN(terminal="Y", direction="right");
//     @LINE {(9,0) (7,0)};
//     (6.5,0) @TEXT("Y", size=0.7, halign="end");
//     (0,3.0) @PIN(terminal="VDD", direction="up");
//     (0,-3.0) @PIN(terminal="VSS", direction="down");
//     ? @TEXT("${name}", key="name", dx=-6, dy=5.0, size=1, halign="start");
//   };
//   # @SET-SYMBOL %symbol;
//   &VDD @ADD-TO $SUPPLY_NET_SET; &VSS @ADD-TO $GROUND_NET_SET;
//   $LABEL_TERMINAL_SET @TEXT("${net}", key="netname", size=0.6);
//   #I0 @TEXT("wn=1200n wp=1800n", key="sizing", dy=-8.0, size=0.7);
//   #I0 @PLACE(0,0) => @ORIENT("R0");
//   %p_I0_A=(-12,0);
//   &A @WIRE(mode="straight") {#I0:A %p_I0_A};
//   %p_I0_A @TEXT("A", size=0.8, halign="end", dy=0);
//   %p_I0_Y=(12,0);
//   &nb @WIRE(mode="straight") {#I0:Y %p_I0_Y};
//   %p_I0_Y @TEXT("nb", size=0.8, halign="start", dy=0);
//   %p_I0_VDD=(0,6.0);
//   &VDD @WIRE(mode="straight") {#I0:VDD %p_I0_VDD};
//   %p_I0_VDD @TEXT("VDD", size=0.8, halign="start", dy=0.5);
//   %p_I0_VSS=(0,-6.0);
//   &VSS @WIRE(mode="straight") {#I0:VSS %p_I0_VSS};
//   %p_I0_VSS @TEXT("VSS", size=0.8, halign="start", dy=0.5);
//   #MNOUT @TEXT("W=${w}, L=${l}, nf=${nf}, m=${m}", key="wl", dx=5, dy=-4, size=0.7, halign="start");
//   #MNOUT @PLACE(30,-6) => @ORIENT("R0");
//   %p_MNOUT_d=(30,-1);
//   &Y @WIRE(mode="straight") {#MNOUT:d %p_MNOUT_d};
//   %p_MNOUT_d @TEXT("Y", size=0.8, halign="start", dy=0.5);
//   %p_MNOUT_g=(24,-6);
//   &nb @WIRE(mode="straight") {#MNOUT:g %p_MNOUT_g};
//   %p_MNOUT_g @TEXT("nb", size=0.8, halign="end", dy=0);
//   %p_MNOUT_s=(30,-11);
//   &VSS @WIRE(mode="straight") {#MNOUT:s %p_MNOUT_s};
//   %p_MNOUT_s @TEXT("VSS", size=0.8, halign="start", dy=0.5);
//   %p_MNOUT_b=(34,-6);
//   &VSS @WIRE(mode="straight") {#MNOUT:b %p_MNOUT_b};
//   %p_MNOUT_b @TEXT("VSS", size=0.8, halign="start", dy=0);
//   #MPOUT @TEXT("W=${w}, L=${l}, nf=${nf}, m=${m}", key="wl", dx=5, dy=4, size=0.7, halign="start");
//   #MPOUT @PLACE(30,6) => @ORIENT("R0");
//   %p_MPOUT_d=(30,1);
//   &Y @WIRE(mode="straight") {#MPOUT:d %p_MPOUT_d};
//   %p_MPOUT_d @TEXT("Y", size=0.8, halign="start", dy=0.5);
//   %p_MPOUT_g=(24,6);
//   &nb @WIRE(mode="straight") {#MPOUT:g %p_MPOUT_g};
//   %p_MPOUT_g @TEXT("nb", size=0.8, halign="end", dy=0);
//   %p_MPOUT_s=(30,11);
//   &VDD @WIRE(mode="straight") {#MPOUT:s %p_MPOUT_s};
//   %p_MPOUT_s @TEXT("VDD", size=0.8, halign="start", dy=0.5);
//   %p_MPOUT_b=(34,6);
//   &VDD @WIRE(mode="straight") {#MPOUT:b %p_MPOUT_b};
//   %p_MPOUT_b @TEXT("VDD", size=0.8, halign="start", dy=0);
//   {#I0 #MNOUT #MPOUT} @GROUP;
//   {&A &Y &VDD &VSS} @REMOVE-FROM $PORT_FILL_SET;
//   %port0=$IO_PORT @ATTACH &A => @PLACE(-28,0) => @ORIENT("R0");
//   %port1=$IO_PORT @ATTACH &Y => @PLACE(-28,-3) => @ORIENT("R0");
//   %port2=$IO_PORT @ATTACH &VDD => @PLACE(-28,-6) => @ORIENT("R0");
//   %port3=$IO_PORT @ATTACH &VSS => @PLACE(-28,-9) => @ORIENT("R0");
//   (-28,24) @TEXT("adc_sarlogic_buf", size=1.2, bold=true);
//   (-28,20) @TEXT("Two-stage output buffer; scale only the final device widths.", size=0.7);
//   (-28,16) @TEXT("Defaults: drive=1", size=0.8);
// }
ends adc_sarlogic_buf

// Balanced comparator receiver. YB resets the comparator clock directly; Y drives the decision cells.
subckt adc_sarlogic_cmpbuf (A Y YB VDD VSS)
IPRE (A YB VDD VSS) adc_sarlogic_inv wn=2400n wp=3600n
MNOUT (Y YB VSS VSS) nch_ulvt_mac w=800n l=30n nf=2 m=10
MPOUT (Y YB VDD VDD) pch_ulvt_mac w=1200n l=30n nf=2 m=10
// @RNL {
//   %symbol = @DEFINE-SYMBOL(box=[-9,-4.0,9,4.0]) {
//     @LINE {(-7,-3.0) (7,-3.0) (7,3.0) (-7,3.0) (-7,-3.0)};
//     (-9,0) @PIN(terminal="A", direction="left");
//     @LINE {(-9,0) (-7,0)};
//     (-6.5,0) @TEXT("A", size=0.7, halign="start");
//     (9,1) @PIN(terminal="Y", direction="right");
//     @LINE {(9,1) (7,1)};
//     (6.5,1) @TEXT("Y", size=0.7, halign="end");
//     (9,-1) @PIN(terminal="YB", direction="right");
//     @LINE {(9,-1) (7,-1)};
//     (6.5,-1) @TEXT("YB", size=0.7, halign="end");
//     (0,4.0) @PIN(terminal="VDD", direction="up");
//     (0,-4.0) @PIN(terminal="VSS", direction="down");
//     ? @TEXT("${name}", key="name", dx=-6, dy=6.0, size=1, halign="start");
//   };
//   # @SET-SYMBOL %symbol;
//   &VDD @ADD-TO $SUPPLY_NET_SET; &VSS @ADD-TO $GROUND_NET_SET;
//   $LABEL_TERMINAL_SET @TEXT("${net}", key="netname", size=0.6);
//   #IPRE @TEXT("wn=2400n wp=3600n", key="sizing", dy=-8.0, size=0.7);
//   #IPRE @PLACE(0,0) => @ORIENT("R0");
//   %p_IPRE_A=(-12,0);
//   &A @WIRE(mode="straight") {#IPRE:A %p_IPRE_A};
//   %p_IPRE_A @TEXT("A", size=0.8, halign="end", dy=0);
//   %p_IPRE_Y=(12,0);
//   &YB @WIRE(mode="straight") {#IPRE:Y %p_IPRE_Y};
//   %p_IPRE_Y @TEXT("YB", size=0.8, halign="start", dy=0);
//   %p_IPRE_VDD=(0,6.0);
//   &VDD @WIRE(mode="straight") {#IPRE:VDD %p_IPRE_VDD};
//   %p_IPRE_VDD @TEXT("VDD", size=0.8, halign="start", dy=0.5);
//   %p_IPRE_VSS=(0,-6.0);
//   &VSS @WIRE(mode="straight") {#IPRE:VSS %p_IPRE_VSS};
//   %p_IPRE_VSS @TEXT("VSS", size=0.8, halign="start", dy=0.5);
//   #MNOUT @TEXT("W=${w}, L=${l}, nf=${nf}, m=${m}", key="wl", dx=5, dy=-4, size=0.7, halign="start");
//   #MNOUT @PLACE(30,-6) => @ORIENT("R0");
//   %p_MNOUT_d=(30,-1);
//   &Y @WIRE(mode="straight") {#MNOUT:d %p_MNOUT_d};
//   %p_MNOUT_d @TEXT("Y", size=0.8, halign="start", dy=0.5);
//   %p_MNOUT_g=(24,-6);
//   &YB @WIRE(mode="straight") {#MNOUT:g %p_MNOUT_g};
//   %p_MNOUT_g @TEXT("YB", size=0.8, halign="end", dy=0);
//   %p_MNOUT_s=(30,-11);
//   &VSS @WIRE(mode="straight") {#MNOUT:s %p_MNOUT_s};
//   %p_MNOUT_s @TEXT("VSS", size=0.8, halign="start", dy=0.5);
//   %p_MNOUT_b=(34,-6);
//   &VSS @WIRE(mode="straight") {#MNOUT:b %p_MNOUT_b};
//   %p_MNOUT_b @TEXT("VSS", size=0.8, halign="start", dy=0);
//   #MPOUT @TEXT("W=${w}, L=${l}, nf=${nf}, m=${m}", key="wl", dx=5, dy=4, size=0.7, halign="start");
//   #MPOUT @PLACE(30,6) => @ORIENT("R0");
//   %p_MPOUT_d=(30,1);
//   &Y @WIRE(mode="straight") {#MPOUT:d %p_MPOUT_d};
//   %p_MPOUT_d @TEXT("Y", size=0.8, halign="start", dy=0.5);
//   %p_MPOUT_g=(24,6);
//   &YB @WIRE(mode="straight") {#MPOUT:g %p_MPOUT_g};
//   %p_MPOUT_g @TEXT("YB", size=0.8, halign="end", dy=0);
//   %p_MPOUT_s=(30,11);
//   &VDD @WIRE(mode="straight") {#MPOUT:s %p_MPOUT_s};
//   %p_MPOUT_s @TEXT("VDD", size=0.8, halign="start", dy=0.5);
//   %p_MPOUT_b=(34,6);
//   &VDD @WIRE(mode="straight") {#MPOUT:b %p_MPOUT_b};
//   %p_MPOUT_b @TEXT("VDD", size=0.8, halign="start", dy=0);
//   {#IPRE #MNOUT #MPOUT} @GROUP;
//   {&A &Y &YB &VDD &VSS} @REMOVE-FROM $PORT_FILL_SET;
//   %port0=$IO_PORT @ATTACH &A => @PLACE(-28,0) => @ORIENT("R0");
//   %port1=$IO_PORT @ATTACH &Y => @PLACE(-28,-3) => @ORIENT("R0");
//   %port2=$IO_PORT @ATTACH &YB => @PLACE(-28,-6) => @ORIENT("R0");
//   %port3=$IO_PORT @ATTACH &VDD => @PLACE(-28,-9) => @ORIENT("R0");
//   %port4=$IO_PORT @ATTACH &VSS => @PLACE(-28,-12) => @ORIENT("R0");
//   (-28,24) @TEXT("adc_sarlogic_cmpbuf", size=1.2, bold=true);
//   (-28,20) @TEXT("Balanced comparator receiver. YB resets the comparator clock directly; Y drives the decision cells.", size=0.7);
// }
ends adc_sarlogic_cmpbuf

// PDK MOS gate load, with each drain/source/body tied to its own rail.
subckt adc_sarlogic_gatecap (A VDD VSS)
parameters cw=1u
MN (VSS A VSS VSS) nch_ulvt_mac w=200n l=90n nf=2 m=cw/200n
MP (VDD A VDD VDD) pch_ulvt_mac w=300n l=90n nf=2 m=cw/200n
// @RNL {
//   %symbol = @DEFINE-SYMBOL(box=[-9,-3.0,9,3.0]) {
//     @LINE {(-7,-2.0) (7,-2.0) (7,2.0) (-7,2.0) (-7,-2.0)};
//     (-9,0) @PIN(terminal="A", direction="left");
//     @LINE {(-9,0) (-7,0)};
//     (-6.5,0) @TEXT("A", size=0.7, halign="start");
//     (0,3.0) @PIN(terminal="VDD", direction="up");
//     (0,-3.0) @PIN(terminal="VSS", direction="down");
//     ? @TEXT("${name}", key="name", dx=-6, dy=5.0, size=1, halign="start");
//   };
//   # @SET-SYMBOL %symbol;
//   &VDD @ADD-TO $SUPPLY_NET_SET; &VSS @ADD-TO $GROUND_NET_SET;
//   $LABEL_TERMINAL_SET @TEXT("${net}", key="netname", size=0.6);
//   #MN @TEXT("W=${w}, L=${l}, nf=${nf}, m=${m}", key="wl", dx=5, dy=-4, size=0.7, halign="start");
//   #MN @PLACE(0,-8) => @ORIENT("R0");
//   %p_MN_d=(0,-3);
//   &VSS @WIRE(mode="straight") {#MN:d %p_MN_d};
//   %p_MN_d @TEXT("VSS", size=0.8, halign="start", dy=0.5);
//   %p_MN_g=(-6,-8);
//   &A @WIRE(mode="straight") {#MN:g %p_MN_g};
//   %p_MN_g @TEXT("A", size=0.8, halign="end", dy=0);
//   %p_MN_s=(0,-13);
//   &VSS @WIRE(mode="straight") {#MN:s %p_MN_s};
//   %p_MN_s @TEXT("VSS", size=0.8, halign="start", dy=0.5);
//   %p_MN_b=(4,-8);
//   &VSS @WIRE(mode="straight") {#MN:b %p_MN_b};
//   %p_MN_b @TEXT("VSS", size=0.8, halign="start", dy=0);
//   #MP @TEXT("W=${w}, L=${l}, nf=${nf}, m=${m}", key="wl", dx=5, dy=4, size=0.7, halign="start");
//   #MP @PLACE(0,6) => @ORIENT("R0");
//   %p_MP_d=(0,1);
//   &VDD @WIRE(mode="straight") {#MP:d %p_MP_d};
//   %p_MP_d @TEXT("VDD", size=0.8, halign="start", dy=0.5);
//   %p_MP_g=(-6,6);
//   &A @WIRE(mode="straight") {#MP:g %p_MP_g};
//   %p_MP_g @TEXT("A", size=0.8, halign="end", dy=0);
//   %p_MP_s=(0,11);
//   &VDD @WIRE(mode="straight") {#MP:s %p_MP_s};
//   %p_MP_s @TEXT("VDD", size=0.8, halign="start", dy=0.5);
//   %p_MP_b=(4,6);
//   &VDD @WIRE(mode="straight") {#MP:b %p_MP_b};
//   %p_MP_b @TEXT("VDD", size=0.8, halign="start", dy=0);
//   {#MN #MP} @GROUP;
//   {&A &VDD &VSS} @REMOVE-FROM $PORT_FILL_SET;
//   %port0=$IO_PORT @ATTACH &A => @PLACE(-28,0) => @ORIENT("R0");
//   %port1=$IO_PORT @ATTACH &VDD => @PLACE(-28,-3) => @ORIENT("R0");
//   %port2=$IO_PORT @ATTACH &VSS => @PLACE(-28,-6) => @ORIENT("R0");
//   (-28,24) @TEXT("adc_sarlogic_gatecap", size=1.2, bold=true);
//   (-28,20) @TEXT("PDK MOS gate load, with each drain/source/body tied to its own rail.", size=0.7);
//   (-28,16) @TEXT("Defaults: cw=1u", size=0.8);
// }
ends adc_sarlogic_gatecap

// Non-inverting CMOS delay; MOS gate load controls the rising-edge wait.
subckt adc_sarlogic_delay (A Y VDD VSS)
parameters cw=1u
I0 (A nb VDD VSS) adc_sarlogic_inv
ILOAD (nb VDD VSS) adc_sarlogic_gatecap cw=cw
I1 (nb Y VDD VSS) adc_sarlogic_inv
// @RNL {
//   %symbol = @DEFINE-SYMBOL(box=[-9,-3.0,9,3.0]) {
//     @LINE {(-7,-2.0) (7,-2.0) (7,2.0) (-7,2.0) (-7,-2.0)};
//     (-9,0) @PIN(terminal="A", direction="left");
//     @LINE {(-9,0) (-7,0)};
//     (-6.5,0) @TEXT("A", size=0.7, halign="start");
//     (9,0) @PIN(terminal="Y", direction="right");
//     @LINE {(9,0) (7,0)};
//     (6.5,0) @TEXT("Y", size=0.7, halign="end");
//     (0,3.0) @PIN(terminal="VDD", direction="up");
//     (0,-3.0) @PIN(terminal="VSS", direction="down");
//     ? @TEXT("${name}", key="name", dx=-6, dy=5.0, size=1, halign="start");
//   };
//   # @SET-SYMBOL %symbol;
//   &VDD @ADD-TO $SUPPLY_NET_SET; &VSS @ADD-TO $GROUND_NET_SET;
//   $LABEL_TERMINAL_SET @TEXT("${net}", key="netname", size=0.6);
//   #I0 @PLACE(0,0) => @ORIENT("R0");
//   %p_I0_A=(-12,0);
//   &A @WIRE(mode="straight") {#I0:A %p_I0_A};
//   %p_I0_A @TEXT("A", size=0.8, halign="end", dy=0);
//   %p_I0_Y=(12,0);
//   &nb @WIRE(mode="straight") {#I0:Y %p_I0_Y};
//   %p_I0_Y @TEXT("nb", size=0.8, halign="start", dy=0);
//   %p_I0_VDD=(0,6.0);
//   &VDD @WIRE(mode="straight") {#I0:VDD %p_I0_VDD};
//   %p_I0_VDD @TEXT("VDD", size=0.8, halign="start", dy=0.5);
//   %p_I0_VSS=(0,-6.0);
//   &VSS @WIRE(mode="straight") {#I0:VSS %p_I0_VSS};
//   %p_I0_VSS @TEXT("VSS", size=0.8, halign="start", dy=0.5);
//   #ILOAD @TEXT("cw=cw", key="sizing", dy=-8.0, size=0.7);
//   #ILOAD @PLACE(42,0) => @ORIENT("R0");
//   %p_ILOAD_A=(30,0);
//   &nb @WIRE(mode="straight") {#ILOAD:A %p_ILOAD_A};
//   %p_ILOAD_A @TEXT("nb", size=0.8, halign="end", dy=0);
//   %p_ILOAD_VDD=(42,6.0);
//   &VDD @WIRE(mode="straight") {#ILOAD:VDD %p_ILOAD_VDD};
//   %p_ILOAD_VDD @TEXT("VDD", size=0.8, halign="start", dy=0.5);
//   %p_ILOAD_VSS=(42,-6.0);
//   &VSS @WIRE(mode="straight") {#ILOAD:VSS %p_ILOAD_VSS};
//   %p_ILOAD_VSS @TEXT("VSS", size=0.8, halign="start", dy=0.5);
//   #I1 @PLACE(84,0) => @ORIENT("R0");
//   %p_I1_A=(72,0);
//   &nb @WIRE(mode="straight") {#I1:A %p_I1_A};
//   %p_I1_A @TEXT("nb", size=0.8, halign="end", dy=0);
//   %p_I1_Y=(96,0);
//   &Y @WIRE(mode="straight") {#I1:Y %p_I1_Y};
//   %p_I1_Y @TEXT("Y", size=0.8, halign="start", dy=0);
//   %p_I1_VDD=(84,6.0);
//   &VDD @WIRE(mode="straight") {#I1:VDD %p_I1_VDD};
//   %p_I1_VDD @TEXT("VDD", size=0.8, halign="start", dy=0.5);
//   %p_I1_VSS=(84,-6.0);
//   &VSS @WIRE(mode="straight") {#I1:VSS %p_I1_VSS};
//   %p_I1_VSS @TEXT("VSS", size=0.8, halign="start", dy=0.5);
//   {#I0 #ILOAD #I1} @GROUP;
//   {&A &Y &VDD &VSS} @REMOVE-FROM $PORT_FILL_SET;
//   %port0=$IO_PORT @ATTACH &A => @PLACE(-28,0) => @ORIENT("R0");
//   %port1=$IO_PORT @ATTACH &Y => @PLACE(-28,-3) => @ORIENT("R0");
//   %port2=$IO_PORT @ATTACH &VDD => @PLACE(-28,-6) => @ORIENT("R0");
//   %port3=$IO_PORT @ATTACH &VSS => @PLACE(-28,-9) => @ORIENT("R0");
//   (-28,24) @TEXT("adc_sarlogic_delay", size=1.2, bold=true);
//   (-28,20) @TEXT("Non-inverting CMOS delay; MOS gate load controls the rising-edge wait.", size=0.7);
//   (-28,16) @TEXT("Defaults: cw=1u", size=0.8);
// }
ends adc_sarlogic_delay

// Timeout tap: every node is asynchronously cleared while EN is low.
subckt adc_sarlogic_resetdelay (A EN Y VDD VSS)
parameters cw=1u
I0 (A EN nb VDD VSS) adc_sarlogic_nand2
ILOAD (nb VDD VSS) adc_sarlogic_gatecap cw=cw
I1 (nb Y VDD VSS) adc_sarlogic_inv
// @RNL {
//   %symbol = @DEFINE-SYMBOL(box=[-9,-4.0,9,4.0]) {
//     @LINE {(-7,-3.0) (7,-3.0) (7,3.0) (-7,3.0) (-7,-3.0)};
//     (-9,1) @PIN(terminal="A", direction="left");
//     @LINE {(-9,1) (-7,1)};
//     (-6.5,1) @TEXT("A", size=0.7, halign="start");
//     (-9,-1) @PIN(terminal="EN", direction="left");
//     @LINE {(-9,-1) (-7,-1)};
//     (-6.5,-1) @TEXT("EN", size=0.7, halign="start");
//     (9,0) @PIN(terminal="Y", direction="right");
//     @LINE {(9,0) (7,0)};
//     (6.5,0) @TEXT("Y", size=0.7, halign="end");
//     (0,4.0) @PIN(terminal="VDD", direction="up");
//     (0,-4.0) @PIN(terminal="VSS", direction="down");
//     ? @TEXT("${name}", key="name", dx=-6, dy=6.0, size=1, halign="start");
//   };
//   # @SET-SYMBOL %symbol;
//   &VDD @ADD-TO $SUPPLY_NET_SET; &VSS @ADD-TO $GROUND_NET_SET;
//   $LABEL_TERMINAL_SET @TEXT("${net}", key="netname", size=0.6);
//   #I0 @PLACE(0,0) => @ORIENT("R0");
//   %p_I0_A=(-12,1);
//   &A @WIRE(mode="straight") {#I0:A %p_I0_A};
//   %p_I0_A @TEXT("A", size=0.8, halign="end", dy=0);
//   %p_I0_B=(-12,-1);
//   &EN @WIRE(mode="straight") {#I0:B %p_I0_B};
//   %p_I0_B @TEXT("EN", size=0.8, halign="end", dy=0);
//   %p_I0_Y=(12,0);
//   &nb @WIRE(mode="straight") {#I0:Y %p_I0_Y};
//   %p_I0_Y @TEXT("nb", size=0.8, halign="start", dy=0);
//   %p_I0_VDD=(0,7.0);
//   &VDD @WIRE(mode="straight") {#I0:VDD %p_I0_VDD};
//   %p_I0_VDD @TEXT("VDD", size=0.8, halign="start", dy=0.5);
//   %p_I0_VSS=(0,-7.0);
//   &VSS @WIRE(mode="straight") {#I0:VSS %p_I0_VSS};
//   %p_I0_VSS @TEXT("VSS", size=0.8, halign="start", dy=0.5);
//   #ILOAD @TEXT("cw=cw", key="sizing", dy=-8.0, size=0.7);
//   #ILOAD @PLACE(42,0) => @ORIENT("R0");
//   %p_ILOAD_A=(30,0);
//   &nb @WIRE(mode="straight") {#ILOAD:A %p_ILOAD_A};
//   %p_ILOAD_A @TEXT("nb", size=0.8, halign="end", dy=0);
//   %p_ILOAD_VDD=(42,6.0);
//   &VDD @WIRE(mode="straight") {#ILOAD:VDD %p_ILOAD_VDD};
//   %p_ILOAD_VDD @TEXT("VDD", size=0.8, halign="start", dy=0.5);
//   %p_ILOAD_VSS=(42,-6.0);
//   &VSS @WIRE(mode="straight") {#ILOAD:VSS %p_ILOAD_VSS};
//   %p_ILOAD_VSS @TEXT("VSS", size=0.8, halign="start", dy=0.5);
//   #I1 @PLACE(84,0) => @ORIENT("R0");
//   %p_I1_A=(72,0);
//   &nb @WIRE(mode="straight") {#I1:A %p_I1_A};
//   %p_I1_A @TEXT("nb", size=0.8, halign="end", dy=0);
//   %p_I1_Y=(96,0);
//   &Y @WIRE(mode="straight") {#I1:Y %p_I1_Y};
//   %p_I1_Y @TEXT("Y", size=0.8, halign="start", dy=0);
//   %p_I1_VDD=(84,6.0);
//   &VDD @WIRE(mode="straight") {#I1:VDD %p_I1_VDD};
//   %p_I1_VDD @TEXT("VDD", size=0.8, halign="start", dy=0.5);
//   %p_I1_VSS=(84,-6.0);
//   &VSS @WIRE(mode="straight") {#I1:VSS %p_I1_VSS};
//   %p_I1_VSS @TEXT("VSS", size=0.8, halign="start", dy=0.5);
//   {#I0 #ILOAD #I1} @GROUP;
//   {&A &EN &Y &VDD &VSS} @REMOVE-FROM $PORT_FILL_SET;
//   %port0=$IO_PORT @ATTACH &A => @PLACE(-28,0) => @ORIENT("R0");
//   %port1=$IO_PORT @ATTACH &EN => @PLACE(-28,-3) => @ORIENT("R0");
//   %port2=$IO_PORT @ATTACH &Y => @PLACE(-28,-6) => @ORIENT("R0");
//   %port3=$IO_PORT @ATTACH &VDD => @PLACE(-28,-9) => @ORIENT("R0");
//   %port4=$IO_PORT @ATTACH &VSS => @PLACE(-28,-12) => @ORIENT("R0");
//   (-28,24) @TEXT("adc_sarlogic_resetdelay", size=1.2, bold=true);
//   (-28,20) @TEXT("Timeout tap: every node is asynchronously cleared while EN is low.", size=0.7);
//   (-28,16) @TEXT("Defaults: cw=1u", size=0.8);
// }
ends adc_sarlogic_resetdelay

// Cross-coupled NOR storage; S and R are kept mutually exclusive by the enclosing logic.
subckt adc_sarlogic_sr (S R Q QB VDD VSS)
parameters drive=1
IQ (R QB Q VDD VSS) adc_sarlogic_nor2 wn=800n wp=2400n drive=drive
IQB (S Q QB VDD VSS) adc_sarlogic_nor2 wn=800n wp=2400n drive=drive
// @RNL {
//   %symbol = @DEFINE-SYMBOL(box=[-9,-4.0,9,4.0]) {
//     @LINE {(-7,-3.0) (7,-3.0) (7,3.0) (-7,3.0) (-7,-3.0)};
//     (-9,1) @PIN(terminal="S", direction="left");
//     @LINE {(-9,1) (-7,1)};
//     (-6.5,1) @TEXT("S", size=0.7, halign="start");
//     (-9,-1) @PIN(terminal="R", direction="left");
//     @LINE {(-9,-1) (-7,-1)};
//     (-6.5,-1) @TEXT("R", size=0.7, halign="start");
//     (9,1) @PIN(terminal="Q", direction="right");
//     @LINE {(9,1) (7,1)};
//     (6.5,1) @TEXT("Q", size=0.7, halign="end");
//     (9,-1) @PIN(terminal="QB", direction="right");
//     @LINE {(9,-1) (7,-1)};
//     (6.5,-1) @TEXT("QB", size=0.7, halign="end");
//     (0,4.0) @PIN(terminal="VDD", direction="up");
//     (0,-4.0) @PIN(terminal="VSS", direction="down");
//     ? @TEXT("${name}", key="name", dx=-6, dy=6.0, size=1, halign="start");
//   };
//   # @SET-SYMBOL %symbol;
//   &VDD @ADD-TO $SUPPLY_NET_SET; &VSS @ADD-TO $GROUND_NET_SET;
//   $LABEL_TERMINAL_SET @TEXT("${net}", key="netname", size=0.6);
//   #IQ @TEXT("wn=800n wp=2400n drive=drive", key="sizing", dy=-9.0, size=0.7);
//   #IQ @PLACE(0,0) => @ORIENT("R0");
//   %p_IQ_A=(-12,1);
//   &R @WIRE(mode="straight") {#IQ:A %p_IQ_A};
//   %p_IQ_A @TEXT("R", size=0.8, halign="end", dy=0);
//   %p_IQ_B=(-12,-1);
//   &QB @WIRE(mode="straight") {#IQ:B %p_IQ_B};
//   %p_IQ_B @TEXT("QB", size=0.8, halign="end", dy=0);
//   %p_IQ_Y=(12,0);
//   &Q @WIRE(mode="straight") {#IQ:Y %p_IQ_Y};
//   %p_IQ_Y @TEXT("Q", size=0.8, halign="start", dy=0);
//   %p_IQ_VDD=(0,7.0);
//   &VDD @WIRE(mode="straight") {#IQ:VDD %p_IQ_VDD};
//   %p_IQ_VDD @TEXT("VDD", size=0.8, halign="start", dy=0.5);
//   %p_IQ_VSS=(0,-7.0);
//   &VSS @WIRE(mode="straight") {#IQ:VSS %p_IQ_VSS};
//   %p_IQ_VSS @TEXT("VSS", size=0.8, halign="start", dy=0.5);
//   #IQB @TEXT("wn=800n wp=2400n drive=drive", key="sizing", dy=-9.0, size=0.7);
//   #IQB @PLACE(42,0) => @ORIENT("R0");
//   %p_IQB_A=(30,1);
//   &S @WIRE(mode="straight") {#IQB:A %p_IQB_A};
//   %p_IQB_A @TEXT("S", size=0.8, halign="end", dy=0);
//   %p_IQB_B=(30,-1);
//   &Q @WIRE(mode="straight") {#IQB:B %p_IQB_B};
//   %p_IQB_B @TEXT("Q", size=0.8, halign="end", dy=0);
//   %p_IQB_Y=(54,0);
//   &QB @WIRE(mode="straight") {#IQB:Y %p_IQB_Y};
//   %p_IQB_Y @TEXT("QB", size=0.8, halign="start", dy=0);
//   %p_IQB_VDD=(42,7.0);
//   &VDD @WIRE(mode="straight") {#IQB:VDD %p_IQB_VDD};
//   %p_IQB_VDD @TEXT("VDD", size=0.8, halign="start", dy=0.5);
//   %p_IQB_VSS=(42,-7.0);
//   &VSS @WIRE(mode="straight") {#IQB:VSS %p_IQB_VSS};
//   %p_IQB_VSS @TEXT("VSS", size=0.8, halign="start", dy=0.5);
//   {#IQ #IQB} @GROUP;
//   {#IQ #IQB} @AS $MATCHED;
//   {&S &R &Q &QB &VDD &VSS} @REMOVE-FROM $PORT_FILL_SET;
//   %port0=$IO_PORT @ATTACH &S => @PLACE(-28,0) => @ORIENT("R0");
//   %port1=$IO_PORT @ATTACH &R => @PLACE(-28,-3) => @ORIENT("R0");
//   %port2=$IO_PORT @ATTACH &Q => @PLACE(-28,-6) => @ORIENT("R0");
//   %port3=$IO_PORT @ATTACH &QB => @PLACE(-28,-9) => @ORIENT("R0");
//   %port4=$IO_PORT @ATTACH &VDD => @PLACE(-28,-12) => @ORIENT("R0");
//   %port5=$IO_PORT @ATTACH &VSS => @PLACE(-28,-15) => @ORIENT("R0");
//   (-28,24) @TEXT("adc_sarlogic_sr", size=1.2, bold=true);
//   (-28,20) @TEXT("Cross-coupled NOR storage; S and R are kept mutually exclusive by the enclosing logic.", size=0.7);
//   (-28,16) @TEXT("Defaults: drive=1", size=0.8);
// }
ends adc_sarlogic_sr

// Clock holding latch. Reset is asserted by CV low, comparator valid or timeout. Each stage withdraws its request once ACTIVE is set.
subckt adc_sarlogic_clock (SETB CV PB NB FB CK VDD VSS)
IQ (SETB ckbar q VDD VSS) adc_sarlogic_nand2 wn=2400n wp=4800n
IQB (CV PB NB FB q ckbar VDD VSS) adc_sarlogic_nand5
IDRV (ckbar CK VDD VSS) adc_sarlogic_inv wn=4u wp=6u drive=2
// @RNL {
//   %symbol = @DEFINE-SYMBOL(box=[-9,-7.0,9,7.0]) {
//     @LINE {(-7,-6.0) (7,-6.0) (7,6.0) (-7,6.0) (-7,-6.0)};
//     (-9,4) @PIN(terminal="SETB", direction="left");
//     @LINE {(-9,4) (-7,4)};
//     (-6.5,4) @TEXT("SETB", size=0.7, halign="start");
//     (-9,2) @PIN(terminal="CV", direction="left");
//     @LINE {(-9,2) (-7,2)};
//     (-6.5,2) @TEXT("CV", size=0.7, halign="start");
//     (-9,0) @PIN(terminal="PB", direction="left");
//     @LINE {(-9,0) (-7,0)};
//     (-6.5,0) @TEXT("PB", size=0.7, halign="start");
//     (-9,-2) @PIN(terminal="NB", direction="left");
//     @LINE {(-9,-2) (-7,-2)};
//     (-6.5,-2) @TEXT("NB", size=0.7, halign="start");
//     (-9,-4) @PIN(terminal="FB", direction="left");
//     @LINE {(-9,-4) (-7,-4)};
//     (-6.5,-4) @TEXT("FB", size=0.7, halign="start");
//     (9,0) @PIN(terminal="CK", direction="right");
//     @LINE {(9,0) (7,0)};
//     (6.5,0) @TEXT("CK", size=0.7, halign="end");
//     (0,7.0) @PIN(terminal="VDD", direction="up");
//     (0,-7.0) @PIN(terminal="VSS", direction="down");
//     ? @TEXT("${name}", key="name", dx=-6, dy=9.0, size=1, halign="start");
//   };
//   # @SET-SYMBOL %symbol;
//   &VDD @ADD-TO $SUPPLY_NET_SET; &VSS @ADD-TO $GROUND_NET_SET;
//   $LABEL_TERMINAL_SET @TEXT("${net}", key="netname", size=0.6);
//   #IQ @TEXT("wn=2400n wp=4800n", key="sizing", dy=-9.0, size=0.7);
//   #IQ @PLACE(0,0) => @ORIENT("R0");
//   %p_IQ_A=(-12,1);
//   &SETB @WIRE(mode="straight") {#IQ:A %p_IQ_A};
//   %p_IQ_A @TEXT("SETB", size=0.8, halign="end", dy=0);
//   %p_IQ_B=(-12,-1);
//   &ckbar @WIRE(mode="straight") {#IQ:B %p_IQ_B};
//   %p_IQ_B @TEXT("ckbar", size=0.8, halign="end", dy=0);
//   %p_IQ_Y=(12,0);
//   &q @WIRE(mode="straight") {#IQ:Y %p_IQ_Y};
//   %p_IQ_Y @TEXT("q", size=0.8, halign="start", dy=0);
//   %p_IQ_VDD=(0,7.0);
//   &VDD @WIRE(mode="straight") {#IQ:VDD %p_IQ_VDD};
//   %p_IQ_VDD @TEXT("VDD", size=0.8, halign="start", dy=0.5);
//   %p_IQ_VSS=(0,-7.0);
//   &VSS @WIRE(mode="straight") {#IQ:VSS %p_IQ_VSS};
//   %p_IQ_VSS @TEXT("VSS", size=0.8, halign="start", dy=0.5);
//   #IQB @PLACE(42,0) => @ORIENT("R0");
//   %p_IQB_A=(30,4);
//   &CV @WIRE(mode="straight") {#IQB:A %p_IQB_A};
//   %p_IQB_A @TEXT("CV", size=0.8, halign="end", dy=0);
//   %p_IQB_B=(30,2);
//   &PB @WIRE(mode="straight") {#IQB:B %p_IQB_B};
//   %p_IQB_B @TEXT("PB", size=0.8, halign="end", dy=0);
//   %p_IQB_C=(30,0);
//   &NB @WIRE(mode="straight") {#IQB:C %p_IQB_C};
//   %p_IQB_C @TEXT("NB", size=0.8, halign="end", dy=0);
//   %p_IQB_D=(30,-2);
//   &FB @WIRE(mode="straight") {#IQB:D %p_IQB_D};
//   %p_IQB_D @TEXT("FB", size=0.8, halign="end", dy=0);
//   %p_IQB_E=(30,-4);
//   &q @WIRE(mode="straight") {#IQB:E %p_IQB_E};
//   %p_IQB_E @TEXT("q", size=0.8, halign="end", dy=0);
//   %p_IQB_Y=(54,0);
//   &ckbar @WIRE(mode="straight") {#IQB:Y %p_IQB_Y};
//   %p_IQB_Y @TEXT("ckbar", size=0.8, halign="start", dy=0);
//   %p_IQB_VDD=(42,10.0);
//   &VDD @WIRE(mode="straight") {#IQB:VDD %p_IQB_VDD};
//   %p_IQB_VDD @TEXT("VDD", size=0.8, halign="start", dy=0.5);
//   %p_IQB_VSS=(42,-10.0);
//   &VSS @WIRE(mode="straight") {#IQB:VSS %p_IQB_VSS};
//   %p_IQB_VSS @TEXT("VSS", size=0.8, halign="start", dy=0.5);
//   #IDRV @TEXT("wn=4u wp=6u drive=2", key="sizing", dy=-8.0, size=0.7);
//   #IDRV @PLACE(84,0) => @ORIENT("R0");
//   %p_IDRV_A=(72,0);
//   &ckbar @WIRE(mode="straight") {#IDRV:A %p_IDRV_A};
//   %p_IDRV_A @TEXT("ckbar", size=0.8, halign="end", dy=0);
//   %p_IDRV_Y=(96,0);
//   &CK @WIRE(mode="straight") {#IDRV:Y %p_IDRV_Y};
//   %p_IDRV_Y @TEXT("CK", size=0.8, halign="start", dy=0);
//   %p_IDRV_VDD=(84,6.0);
//   &VDD @WIRE(mode="straight") {#IDRV:VDD %p_IDRV_VDD};
//   %p_IDRV_VDD @TEXT("VDD", size=0.8, halign="start", dy=0.5);
//   %p_IDRV_VSS=(84,-6.0);
//   &VSS @WIRE(mode="straight") {#IDRV:VSS %p_IDRV_VSS};
//   %p_IDRV_VSS @TEXT("VSS", size=0.8, halign="start", dy=0.5);
//   {#IQ #IQB #IDRV} @GROUP;
//   {&SETB &CV &PB &NB &FB &CK &VDD &VSS} @REMOVE-FROM $PORT_FILL_SET;
//   %port0=$IO_PORT @ATTACH &SETB => @PLACE(-28,0) => @ORIENT("R0");
//   %port1=$IO_PORT @ATTACH &CV => @PLACE(-28,-3) => @ORIENT("R0");
//   %port2=$IO_PORT @ATTACH &PB => @PLACE(-28,-6) => @ORIENT("R0");
//   %port3=$IO_PORT @ATTACH &NB => @PLACE(-28,-9) => @ORIENT("R0");
//   %port4=$IO_PORT @ATTACH &FB => @PLACE(-28,-12) => @ORIENT("R0");
//   %port5=$IO_PORT @ATTACH &CK => @PLACE(-28,-15) => @ORIENT("R0");
//   %port6=$IO_PORT @ATTACH &VDD => @PLACE(-28,-18) => @ORIENT("R0");
//   %port7=$IO_PORT @ATTACH &VSS => @PLACE(-28,-21) => @ORIENT("R0");
//   (-28,24) @TEXT("adc_sarlogic_clock", size=1.2, bold=true);
//   (-28,20) @TEXT("Clock holding latch. Reset is asserted by CV low, comparator valid or timeout. Each stage withdraws its request once ACTIVE is set.", size=0.7);
// }
ends adc_sarlogic_clock

// Static transmission-gate latch. EN=1 tracks A; EN=0 closes the feedback path.
subckt adc_sarlogic_latch (A EN ENB Q VDD VSS)
MNI (x EN A VSS) nch_ulvt_mac w=600n l=30n nf=2
MPI (x ENB A VDD) pch_ulvt_mac w=900n l=30n nf=2
I0 (x qb VDD VSS) adc_sarlogic_inv
I1 (qb qhold VDD VSS) adc_sarlogic_inv
MNF (x ENB qhold VSS) nch_ulvt_mac w=400n l=30n nf=2
MPF (x EN qhold VDD) pch_ulvt_mac w=600n l=30n nf=2
IB (qhold Q VDD VSS) adc_sarlogic_buf drive=4
// @RNL {
//   %symbol = @DEFINE-SYMBOL(box=[-9,-5.0,9,5.0]) {
//     @LINE {(-7,-4.0) (7,-4.0) (7,4.0) (-7,4.0) (-7,-4.0)};
//     (-9,2) @PIN(terminal="A", direction="left");
//     @LINE {(-9,2) (-7,2)};
//     (-6.5,2) @TEXT("A", size=0.7, halign="start");
//     (-9,0) @PIN(terminal="EN", direction="left");
//     @LINE {(-9,0) (-7,0)};
//     (-6.5,0) @TEXT("EN", size=0.7, halign="start");
//     (-9,-2) @PIN(terminal="ENB", direction="left");
//     @LINE {(-9,-2) (-7,-2)};
//     (-6.5,-2) @TEXT("ENB", size=0.7, halign="start");
//     (9,0) @PIN(terminal="Q", direction="right");
//     @LINE {(9,0) (7,0)};
//     (6.5,0) @TEXT("Q", size=0.7, halign="end");
//     (0,5.0) @PIN(terminal="VDD", direction="up");
//     (0,-5.0) @PIN(terminal="VSS", direction="down");
//     ? @TEXT("${name}", key="name", dx=-6, dy=7.0, size=1, halign="start");
//   };
//   # @SET-SYMBOL %symbol;
//   &VDD @ADD-TO $SUPPLY_NET_SET; &VSS @ADD-TO $GROUND_NET_SET;
//   $LABEL_TERMINAL_SET @TEXT("${net}", key="netname", size=0.6);
//   #MNI @TEXT("W=${w}, L=${l}, nf=${nf}", key="wl", dx=5, dy=-4, size=0.7, halign="start");
//   #MNI @PLACE(0,-6) => @ORIENT("R0");
//   %p_MNI_d=(0,-1);
//   &x @WIRE(mode="straight") {#MNI:d %p_MNI_d};
//   %p_MNI_d @TEXT("x", size=0.8, halign="start", dy=0.5);
//   %p_MNI_g=(-6,-6);
//   &EN @WIRE(mode="straight") {#MNI:g %p_MNI_g};
//   %p_MNI_g @TEXT("EN", size=0.8, halign="end", dy=0);
//   %p_MNI_s=(0,-11);
//   &A @WIRE(mode="straight") {#MNI:s %p_MNI_s};
//   %p_MNI_s @TEXT("A", size=0.8, halign="start", dy=0.5);
//   %p_MNI_b=(4,-6);
//   &VSS @WIRE(mode="straight") {#MNI:b %p_MNI_b};
//   %p_MNI_b @TEXT("VSS", size=0.8, halign="start", dy=0);
//   #MPI @TEXT("W=${w}, L=${l}, nf=${nf}", key="wl", dx=5, dy=4, size=0.7, halign="start");
//   #MPI @PLACE(0,6) => @ORIENT("R0");
//   %p_MPI_d=(0,1);
//   &x @WIRE(mode="straight") {#MPI:d %p_MPI_d};
//   %p_MPI_d @TEXT("x", size=0.8, halign="start", dy=0.5);
//   %p_MPI_g=(-6,6);
//   &ENB @WIRE(mode="straight") {#MPI:g %p_MPI_g};
//   %p_MPI_g @TEXT("ENB", size=0.8, halign="end", dy=0);
//   %p_MPI_s=(0,11);
//   &A @WIRE(mode="straight") {#MPI:s %p_MPI_s};
//   %p_MPI_s @TEXT("A", size=0.8, halign="start", dy=0.5);
//   %p_MPI_b=(4,6);
//   &VDD @WIRE(mode="straight") {#MPI:b %p_MPI_b};
//   %p_MPI_b @TEXT("VDD", size=0.8, halign="start", dy=0);
//   #I0 @PLACE(30,0) => @ORIENT("R0");
//   %p_I0_A=(18,0);
//   &x @WIRE(mode="straight") {#I0:A %p_I0_A};
//   %p_I0_A @TEXT("x", size=0.8, halign="end", dy=0);
//   %p_I0_Y=(42,0);
//   &qb @WIRE(mode="straight") {#I0:Y %p_I0_Y};
//   %p_I0_Y @TEXT("qb", size=0.8, halign="start", dy=0);
//   %p_I0_VDD=(30,6.0);
//   &VDD @WIRE(mode="straight") {#I0:VDD %p_I0_VDD};
//   %p_I0_VDD @TEXT("VDD", size=0.8, halign="start", dy=0.5);
//   %p_I0_VSS=(30,-6.0);
//   &VSS @WIRE(mode="straight") {#I0:VSS %p_I0_VSS};
//   %p_I0_VSS @TEXT("VSS", size=0.8, halign="start", dy=0.5);
//   #I1 @PLACE(60,0) => @ORIENT("R0");
//   %p_I1_A=(48,0);
//   &qb @WIRE(mode="straight") {#I1:A %p_I1_A};
//   %p_I1_A @TEXT("qb", size=0.8, halign="end", dy=0);
//   %p_I1_Y=(72,0);
//   &qhold @WIRE(mode="straight") {#I1:Y %p_I1_Y};
//   %p_I1_Y @TEXT("qhold", size=0.8, halign="start", dy=0);
//   %p_I1_VDD=(60,6.0);
//   &VDD @WIRE(mode="straight") {#I1:VDD %p_I1_VDD};
//   %p_I1_VDD @TEXT("VDD", size=0.8, halign="start", dy=0.5);
//   %p_I1_VSS=(60,-6.0);
//   &VSS @WIRE(mode="straight") {#I1:VSS %p_I1_VSS};
//   %p_I1_VSS @TEXT("VSS", size=0.8, halign="start", dy=0.5);
//   #MNF @TEXT("W=${w}, L=${l}, nf=${nf}", key="wl", dx=5, dy=-4, size=0.7, halign="start");
//   #MNF @PLACE(46,-24) => @ORIENT("R0");
//   %p_MNF_d=(46,-19);
//   &x @WIRE(mode="straight") {#MNF:d %p_MNF_d};
//   %p_MNF_d @TEXT("x", size=0.8, halign="start", dy=0.5);
//   %p_MNF_g=(40,-24);
//   &ENB @WIRE(mode="straight") {#MNF:g %p_MNF_g};
//   %p_MNF_g @TEXT("ENB", size=0.8, halign="end", dy=0);
//   %p_MNF_s=(46,-29);
//   &qhold @WIRE(mode="straight") {#MNF:s %p_MNF_s};
//   %p_MNF_s @TEXT("qhold", size=0.8, halign="start", dy=0.5);
//   %p_MNF_b=(50,-24);
//   &VSS @WIRE(mode="straight") {#MNF:b %p_MNF_b};
//   %p_MNF_b @TEXT("VSS", size=0.8, halign="start", dy=0);
//   #MPF @TEXT("W=${w}, L=${l}, nf=${nf}", key="wl", dx=5, dy=4, size=0.7, halign="start");
//   #MPF @PLACE(46,-12) => @ORIENT("R0");
//   %p_MPF_d=(46,-17);
//   &x @WIRE(mode="straight") {#MPF:d %p_MPF_d};
//   %p_MPF_d @TEXT("x", size=0.8, halign="start", dy=0.5);
//   %p_MPF_g=(40,-12);
//   &EN @WIRE(mode="straight") {#MPF:g %p_MPF_g};
//   %p_MPF_g @TEXT("EN", size=0.8, halign="end", dy=0);
//   %p_MPF_s=(46,-7);
//   &qhold @WIRE(mode="straight") {#MPF:s %p_MPF_s};
//   %p_MPF_s @TEXT("qhold", size=0.8, halign="start", dy=0.5);
//   %p_MPF_b=(50,-12);
//   &VDD @WIRE(mode="straight") {#MPF:b %p_MPF_b};
//   %p_MPF_b @TEXT("VDD", size=0.8, halign="start", dy=0);
//   #IB @TEXT("drive=4", key="sizing", dy=-8.0, size=0.7);
//   #IB @PLACE(90,0) => @ORIENT("R0");
//   %p_IB_A=(78,0);
//   &qhold @WIRE(mode="straight") {#IB:A %p_IB_A};
//   %p_IB_A @TEXT("qhold", size=0.8, halign="end", dy=0);
//   %p_IB_Y=(102,0);
//   &Q @WIRE(mode="straight") {#IB:Y %p_IB_Y};
//   %p_IB_Y @TEXT("Q", size=0.8, halign="start", dy=0);
//   %p_IB_VDD=(90,6.0);
//   &VDD @WIRE(mode="straight") {#IB:VDD %p_IB_VDD};
//   %p_IB_VDD @TEXT("VDD", size=0.8, halign="start", dy=0.5);
//   %p_IB_VSS=(90,-6.0);
//   &VSS @WIRE(mode="straight") {#IB:VSS %p_IB_VSS};
//   %p_IB_VSS @TEXT("VSS", size=0.8, halign="start", dy=0.5);
//   {#MNI #MPI #I0 #I1 #MNF #MPF #IB} @GROUP;
//   {&A &EN &ENB &Q &VDD &VSS} @REMOVE-FROM $PORT_FILL_SET;
//   %port0=$IO_PORT @ATTACH &A => @PLACE(-28,0) => @ORIENT("R0");
//   %port1=$IO_PORT @ATTACH &EN => @PLACE(-28,-3) => @ORIENT("R0");
//   %port2=$IO_PORT @ATTACH &ENB => @PLACE(-28,-6) => @ORIENT("R0");
//   %port3=$IO_PORT @ATTACH &Q => @PLACE(-28,-9) => @ORIENT("R0");
//   %port4=$IO_PORT @ATTACH &VDD => @PLACE(-28,-12) => @ORIENT("R0");
//   %port5=$IO_PORT @ATTACH &VSS => @PLACE(-28,-15) => @ORIENT("R0");
//   (-28,24) @TEXT("adc_sarlogic_latch", size=1.2, bold=true);
//   (-28,20) @TEXT("Static transmission-gate latch. EN=1 tracks A; EN=0 closes the feedback path.", size=0.7);
// }
ends adc_sarlogic_latch

// One RTZ decision stage. Local ACTIVE stores evaluation permission; dual rails retain the result; delayed completion prepares the next stage.
subckt adc_sarlogic_step (PREV CV CVB RESET P N FORCE CK REQ NEXT BIT UP DN DONE VDD VSS)
parameters cw=1u
IEN (PREV CV doneb activeb enb VDD VSS) adc_sarlogic_nand4
IE (enb REQ VDD VSS) adc_sarlogic_inv wn=800n wp=1200n
IASET (REQ CK aset VDD VSS) adc_sarlogic_and2
IARESET (DONE RESET areset VDD VSS) adc_sarlogic_or2
IACTIVE (aset areset active activeb VDD VSS) adc_sarlogic_sr drive=3
IGRANT (active CV grant VDD VSS) adc_sarlogic_and2
ISP (grant P spb VDD VSS) adc_sarlogic_nand2 wn=1600n wp=1200n
ISTO (grant FORCE stb VDD VSS) adc_sarlogic_nand2 wn=1600n wp=1200n
ISPI (spb stb sp VDD VSS) adc_sarlogic_nand2 wn=1600n wp=1200n
ISN (grant N snb VDD VSS) adc_sarlogic_nand2 wn=1600n wp=1200n
ISNI (snb sn VDD VSS) adc_sarlogic_inv wn=1200n wp=1800n
ILP (sp RESET BIT pb VDD VSS) adc_sarlogic_sr drive=2
ILN (sn RESET nb nbb VDD VSS) adc_sarlogic_sr drive=2
ID (pb nbb DONE VDD VSS) adc_sarlogic_nand2 wn=1600n wp=1200n
IDB (DONE doneb VDD VSS) adc_sarlogic_inv wn=800n wp=1200n
IUP (pb CVB UP VDD VSS) adc_sarlogic_nor2 wn=1600n wp=4800n
IDN (nbb CVB DN VDD VSS) adc_sarlogic_nor2 wn=1600n wp=4800n
IW (DONE NEXT VDD VSS) adc_sarlogic_delay cw=cw
// @RNL {
//   %symbol = @DEFINE-SYMBOL(box=[-9,-9.0,9,9.0]) {
//     @LINE {(-7,-8.0) (7,-8.0) (7,8.0) (-7,8.0) (-7,-8.0)};
//     (-9,6) @PIN(terminal="PREV", direction="left");
//     @LINE {(-9,6) (-7,6)};
//     (-6.5,6) @TEXT("PREV", size=0.7, halign="start");
//     (-9,4) @PIN(terminal="CV", direction="left");
//     @LINE {(-9,4) (-7,4)};
//     (-6.5,4) @TEXT("CV", size=0.7, halign="start");
//     (-9,2) @PIN(terminal="CVB", direction="left");
//     @LINE {(-9,2) (-7,2)};
//     (-6.5,2) @TEXT("CVB", size=0.7, halign="start");
//     (-9,0) @PIN(terminal="RESET", direction="left");
//     @LINE {(-9,0) (-7,0)};
//     (-6.5,0) @TEXT("RESET", size=0.7, halign="start");
//     (-9,-2) @PIN(terminal="P", direction="left");
//     @LINE {(-9,-2) (-7,-2)};
//     (-6.5,-2) @TEXT("P", size=0.7, halign="start");
//     (-9,-4) @PIN(terminal="N", direction="left");
//     @LINE {(-9,-4) (-7,-4)};
//     (-6.5,-4) @TEXT("N", size=0.7, halign="start");
//     (-9,-6) @PIN(terminal="FORCE", direction="left");
//     @LINE {(-9,-6) (-7,-6)};
//     (-6.5,-6) @TEXT("FORCE", size=0.7, halign="start");
//     (9,6) @PIN(terminal="CK", direction="right");
//     @LINE {(9,6) (7,6)};
//     (6.5,6) @TEXT("CK", size=0.7, halign="end");
//     (9,4) @PIN(terminal="REQ", direction="right");
//     @LINE {(9,4) (7,4)};
//     (6.5,4) @TEXT("REQ", size=0.7, halign="end");
//     (9,2) @PIN(terminal="NEXT", direction="right");
//     @LINE {(9,2) (7,2)};
//     (6.5,2) @TEXT("NEXT", size=0.7, halign="end");
//     (9,0) @PIN(terminal="BIT", direction="right");
//     @LINE {(9,0) (7,0)};
//     (6.5,0) @TEXT("BIT", size=0.7, halign="end");
//     (9,-2) @PIN(terminal="UP", direction="right");
//     @LINE {(9,-2) (7,-2)};
//     (6.5,-2) @TEXT("UP", size=0.7, halign="end");
//     (9,-4) @PIN(terminal="DN", direction="right");
//     @LINE {(9,-4) (7,-4)};
//     (6.5,-4) @TEXT("DN", size=0.7, halign="end");
//     (9,-6) @PIN(terminal="DONE", direction="right");
//     @LINE {(9,-6) (7,-6)};
//     (6.5,-6) @TEXT("DONE", size=0.7, halign="end");
//     (0,9.0) @PIN(terminal="VDD", direction="up");
//     (0,-9.0) @PIN(terminal="VSS", direction="down");
//     ? @TEXT("${name}", key="name", dx=-6, dy=11.0, size=1, halign="start");
//   };
//   # @SET-SYMBOL %symbol;
//   &VDD @ADD-TO $SUPPLY_NET_SET; &VSS @ADD-TO $GROUND_NET_SET;
//   $LABEL_TERMINAL_SET @TEXT("${net}", key="netname", size=0.6);
//   #IEN @PLACE(0,0) => @ORIENT("R0");
//   %p_IEN_A=(-12,3);
//   &PREV @WIRE(mode="straight") {#IEN:A %p_IEN_A};
//   %p_IEN_A @TEXT("PREV", size=0.8, halign="end", dy=0);
//   %p_IEN_B=(-12,1);
//   &CV @WIRE(mode="straight") {#IEN:B %p_IEN_B};
//   %p_IEN_B @TEXT("CV", size=0.8, halign="end", dy=0);
//   %p_IEN_C=(-12,-1);
//   &doneb @WIRE(mode="straight") {#IEN:C %p_IEN_C};
//   %p_IEN_C @TEXT("doneb", size=0.8, halign="end", dy=0);
//   %p_IEN_D=(-12,-3);
//   &activeb @WIRE(mode="straight") {#IEN:D %p_IEN_D};
//   %p_IEN_D @TEXT("activeb", size=0.8, halign="end", dy=0);
//   %p_IEN_Y=(12,0);
//   &enb @WIRE(mode="straight") {#IEN:Y %p_IEN_Y};
//   %p_IEN_Y @TEXT("enb", size=0.8, halign="start", dy=0);
//   %p_IEN_VDD=(0,9.0);
//   &VDD @WIRE(mode="straight") {#IEN:VDD %p_IEN_VDD};
//   %p_IEN_VDD @TEXT("VDD", size=0.8, halign="start", dy=0.5);
//   %p_IEN_VSS=(0,-9.0);
//   &VSS @WIRE(mode="straight") {#IEN:VSS %p_IEN_VSS};
//   %p_IEN_VSS @TEXT("VSS", size=0.8, halign="start", dy=0.5);
//   #IE @TEXT("wn=800n wp=1200n", key="sizing", dy=-8.0, size=0.7);
//   #IE @PLACE(42,0) => @ORIENT("R0");
//   %p_IE_A=(30,0);
//   &enb @WIRE(mode="straight") {#IE:A %p_IE_A};
//   %p_IE_A @TEXT("enb", size=0.8, halign="end", dy=0);
//   %p_IE_Y=(54,0);
//   &REQ @WIRE(mode="straight") {#IE:Y %p_IE_Y};
//   %p_IE_Y @TEXT("REQ", size=0.8, halign="start", dy=0);
//   %p_IE_VDD=(42,6.0);
//   &VDD @WIRE(mode="straight") {#IE:VDD %p_IE_VDD};
//   %p_IE_VDD @TEXT("VDD", size=0.8, halign="start", dy=0.5);
//   %p_IE_VSS=(42,-6.0);
//   &VSS @WIRE(mode="straight") {#IE:VSS %p_IE_VSS};
//   %p_IE_VSS @TEXT("VSS", size=0.8, halign="start", dy=0.5);
//   #IASET @PLACE(84,0) => @ORIENT("R0");
//   %p_IASET_A=(72,1);
//   &REQ @WIRE(mode="straight") {#IASET:A %p_IASET_A};
//   %p_IASET_A @TEXT("REQ", size=0.8, halign="end", dy=0);
//   %p_IASET_B=(72,-1);
//   &CK @WIRE(mode="straight") {#IASET:B %p_IASET_B};
//   %p_IASET_B @TEXT("CK", size=0.8, halign="end", dy=0);
//   %p_IASET_Y=(96,0);
//   &aset @WIRE(mode="straight") {#IASET:Y %p_IASET_Y};
//   %p_IASET_Y @TEXT("aset", size=0.8, halign="start", dy=0);
//   %p_IASET_VDD=(84,7.0);
//   &VDD @WIRE(mode="straight") {#IASET:VDD %p_IASET_VDD};
//   %p_IASET_VDD @TEXT("VDD", size=0.8, halign="start", dy=0.5);
//   %p_IASET_VSS=(84,-7.0);
//   &VSS @WIRE(mode="straight") {#IASET:VSS %p_IASET_VSS};
//   %p_IASET_VSS @TEXT("VSS", size=0.8, halign="start", dy=0.5);
//   #IARESET @PLACE(0,-24.0) => @ORIENT("R0");
//   %p_IARESET_A=(-12,-23.0);
//   &DONE @WIRE(mode="straight") {#IARESET:A %p_IARESET_A};
//   %p_IARESET_A @TEXT("DONE", size=0.8, halign="end", dy=0);
//   %p_IARESET_B=(-12,-25.0);
//   &RESET @WIRE(mode="straight") {#IARESET:B %p_IARESET_B};
//   %p_IARESET_B @TEXT("RESET", size=0.8, halign="end", dy=0);
//   %p_IARESET_Y=(12,-24.0);
//   &areset @WIRE(mode="straight") {#IARESET:Y %p_IARESET_Y};
//   %p_IARESET_Y @TEXT("areset", size=0.8, halign="start", dy=0);
//   %p_IARESET_VDD=(0,-17.0);
//   &VDD @WIRE(mode="straight") {#IARESET:VDD %p_IARESET_VDD};
//   %p_IARESET_VDD @TEXT("VDD", size=0.8, halign="start", dy=0.5);
//   %p_IARESET_VSS=(0,-31.0);
//   &VSS @WIRE(mode="straight") {#IARESET:VSS %p_IARESET_VSS};
//   %p_IARESET_VSS @TEXT("VSS", size=0.8, halign="start", dy=0.5);
//   #IACTIVE @TEXT("drive=3", key="sizing", dy=-9.0, size=0.7);
//   #IACTIVE @PLACE(42,-24.0) => @ORIENT("R0");
//   %p_IACTIVE_S=(30,-23.0);
//   &aset @WIRE(mode="straight") {#IACTIVE:S %p_IACTIVE_S};
//   %p_IACTIVE_S @TEXT("aset", size=0.8, halign="end", dy=0);
//   %p_IACTIVE_R=(30,-25.0);
//   &areset @WIRE(mode="straight") {#IACTIVE:R %p_IACTIVE_R};
//   %p_IACTIVE_R @TEXT("areset", size=0.8, halign="end", dy=0);
//   %p_IACTIVE_Q=(54,-23.0);
//   &active @WIRE(mode="straight") {#IACTIVE:Q %p_IACTIVE_Q};
//   %p_IACTIVE_Q @TEXT("active", size=0.8, halign="start", dy=0);
//   %p_IACTIVE_QB=(54,-25.0);
//   &activeb @WIRE(mode="straight") {#IACTIVE:QB %p_IACTIVE_QB};
//   %p_IACTIVE_QB @TEXT("activeb", size=0.8, halign="start", dy=0);
//   %p_IACTIVE_VDD=(42,-17.0);
//   &VDD @WIRE(mode="straight") {#IACTIVE:VDD %p_IACTIVE_VDD};
//   %p_IACTIVE_VDD @TEXT("VDD", size=0.8, halign="start", dy=0.5);
//   %p_IACTIVE_VSS=(42,-31.0);
//   &VSS @WIRE(mode="straight") {#IACTIVE:VSS %p_IACTIVE_VSS};
//   %p_IACTIVE_VSS @TEXT("VSS", size=0.8, halign="start", dy=0.5);
//   #IGRANT @PLACE(84,-24.0) => @ORIENT("R0");
//   %p_IGRANT_A=(72,-23.0);
//   &active @WIRE(mode="straight") {#IGRANT:A %p_IGRANT_A};
//   %p_IGRANT_A @TEXT("active", size=0.8, halign="end", dy=0);
//   %p_IGRANT_B=(72,-25.0);
//   &CV @WIRE(mode="straight") {#IGRANT:B %p_IGRANT_B};
//   %p_IGRANT_B @TEXT("CV", size=0.8, halign="end", dy=0);
//   %p_IGRANT_Y=(96,-24.0);
//   &grant @WIRE(mode="straight") {#IGRANT:Y %p_IGRANT_Y};
//   %p_IGRANT_Y @TEXT("grant", size=0.8, halign="start", dy=0);
//   %p_IGRANT_VDD=(84,-17.0);
//   &VDD @WIRE(mode="straight") {#IGRANT:VDD %p_IGRANT_VDD};
//   %p_IGRANT_VDD @TEXT("VDD", size=0.8, halign="start", dy=0.5);
//   %p_IGRANT_VSS=(84,-31.0);
//   &VSS @WIRE(mode="straight") {#IGRANT:VSS %p_IGRANT_VSS};
//   %p_IGRANT_VSS @TEXT("VSS", size=0.8, halign="start", dy=0.5);
//   #ISP @TEXT("wn=1600n wp=1200n", key="sizing", dy=-9.0, size=0.7);
//   #ISP @PLACE(0,-46.0) => @ORIENT("R0");
//   %p_ISP_A=(-12,-45.0);
//   &grant @WIRE(mode="straight") {#ISP:A %p_ISP_A};
//   %p_ISP_A @TEXT("grant", size=0.8, halign="end", dy=0);
//   %p_ISP_B=(-12,-47.0);
//   &P @WIRE(mode="straight") {#ISP:B %p_ISP_B};
//   %p_ISP_B @TEXT("P", size=0.8, halign="end", dy=0);
//   %p_ISP_Y=(12,-46.0);
//   &spb @WIRE(mode="straight") {#ISP:Y %p_ISP_Y};
//   %p_ISP_Y @TEXT("spb", size=0.8, halign="start", dy=0);
//   %p_ISP_VDD=(0,-39.0);
//   &VDD @WIRE(mode="straight") {#ISP:VDD %p_ISP_VDD};
//   %p_ISP_VDD @TEXT("VDD", size=0.8, halign="start", dy=0.5);
//   %p_ISP_VSS=(0,-53.0);
//   &VSS @WIRE(mode="straight") {#ISP:VSS %p_ISP_VSS};
//   %p_ISP_VSS @TEXT("VSS", size=0.8, halign="start", dy=0.5);
//   #ISTO @TEXT("wn=1600n wp=1200n", key="sizing", dy=-9.0, size=0.7);
//   #ISTO @PLACE(42,-46.0) => @ORIENT("R0");
//   %p_ISTO_A=(30,-45.0);
//   &grant @WIRE(mode="straight") {#ISTO:A %p_ISTO_A};
//   %p_ISTO_A @TEXT("grant", size=0.8, halign="end", dy=0);
//   %p_ISTO_B=(30,-47.0);
//   &FORCE @WIRE(mode="straight") {#ISTO:B %p_ISTO_B};
//   %p_ISTO_B @TEXT("FORCE", size=0.8, halign="end", dy=0);
//   %p_ISTO_Y=(54,-46.0);
//   &stb @WIRE(mode="straight") {#ISTO:Y %p_ISTO_Y};
//   %p_ISTO_Y @TEXT("stb", size=0.8, halign="start", dy=0);
//   %p_ISTO_VDD=(42,-39.0);
//   &VDD @WIRE(mode="straight") {#ISTO:VDD %p_ISTO_VDD};
//   %p_ISTO_VDD @TEXT("VDD", size=0.8, halign="start", dy=0.5);
//   %p_ISTO_VSS=(42,-53.0);
//   &VSS @WIRE(mode="straight") {#ISTO:VSS %p_ISTO_VSS};
//   %p_ISTO_VSS @TEXT("VSS", size=0.8, halign="start", dy=0.5);
//   #ISPI @TEXT("wn=1600n wp=1200n", key="sizing", dy=-9.0, size=0.7);
//   #ISPI @PLACE(84,-46.0) => @ORIENT("R0");
//   %p_ISPI_A=(72,-45.0);
//   &spb @WIRE(mode="straight") {#ISPI:A %p_ISPI_A};
//   %p_ISPI_A @TEXT("spb", size=0.8, halign="end", dy=0);
//   %p_ISPI_B=(72,-47.0);
//   &stb @WIRE(mode="straight") {#ISPI:B %p_ISPI_B};
//   %p_ISPI_B @TEXT("stb", size=0.8, halign="end", dy=0);
//   %p_ISPI_Y=(96,-46.0);
//   &sp @WIRE(mode="straight") {#ISPI:Y %p_ISPI_Y};
//   %p_ISPI_Y @TEXT("sp", size=0.8, halign="start", dy=0);
//   %p_ISPI_VDD=(84,-39.0);
//   &VDD @WIRE(mode="straight") {#ISPI:VDD %p_ISPI_VDD};
//   %p_ISPI_VDD @TEXT("VDD", size=0.8, halign="start", dy=0.5);
//   %p_ISPI_VSS=(84,-53.0);
//   &VSS @WIRE(mode="straight") {#ISPI:VSS %p_ISPI_VSS};
//   %p_ISPI_VSS @TEXT("VSS", size=0.8, halign="start", dy=0.5);
//   #ISN @TEXT("wn=1600n wp=1200n", key="sizing", dy=-9.0, size=0.7);
//   #ISN @PLACE(0,-68.0) => @ORIENT("R0");
//   %p_ISN_A=(-12,-67.0);
//   &grant @WIRE(mode="straight") {#ISN:A %p_ISN_A};
//   %p_ISN_A @TEXT("grant", size=0.8, halign="end", dy=0);
//   %p_ISN_B=(-12,-69.0);
//   &N @WIRE(mode="straight") {#ISN:B %p_ISN_B};
//   %p_ISN_B @TEXT("N", size=0.8, halign="end", dy=0);
//   %p_ISN_Y=(12,-68.0);
//   &snb @WIRE(mode="straight") {#ISN:Y %p_ISN_Y};
//   %p_ISN_Y @TEXT("snb", size=0.8, halign="start", dy=0);
//   %p_ISN_VDD=(0,-61.0);
//   &VDD @WIRE(mode="straight") {#ISN:VDD %p_ISN_VDD};
//   %p_ISN_VDD @TEXT("VDD", size=0.8, halign="start", dy=0.5);
//   %p_ISN_VSS=(0,-75.0);
//   &VSS @WIRE(mode="straight") {#ISN:VSS %p_ISN_VSS};
//   %p_ISN_VSS @TEXT("VSS", size=0.8, halign="start", dy=0.5);
//   #ISNI @TEXT("wn=1200n wp=1800n", key="sizing", dy=-8.0, size=0.7);
//   #ISNI @PLACE(42,-68.0) => @ORIENT("R0");
//   %p_ISNI_A=(30,-68.0);
//   &snb @WIRE(mode="straight") {#ISNI:A %p_ISNI_A};
//   %p_ISNI_A @TEXT("snb", size=0.8, halign="end", dy=0);
//   %p_ISNI_Y=(54,-68.0);
//   &sn @WIRE(mode="straight") {#ISNI:Y %p_ISNI_Y};
//   %p_ISNI_Y @TEXT("sn", size=0.8, halign="start", dy=0);
//   %p_ISNI_VDD=(42,-62.0);
//   &VDD @WIRE(mode="straight") {#ISNI:VDD %p_ISNI_VDD};
//   %p_ISNI_VDD @TEXT("VDD", size=0.8, halign="start", dy=0.5);
//   %p_ISNI_VSS=(42,-74.0);
//   &VSS @WIRE(mode="straight") {#ISNI:VSS %p_ISNI_VSS};
//   %p_ISNI_VSS @TEXT("VSS", size=0.8, halign="start", dy=0.5);
//   #ILP @TEXT("drive=2", key="sizing", dy=-9.0, size=0.7);
//   #ILP @PLACE(84,-68.0) => @ORIENT("R0");
//   %p_ILP_S=(72,-67.0);
//   &sp @WIRE(mode="straight") {#ILP:S %p_ILP_S};
//   %p_ILP_S @TEXT("sp", size=0.8, halign="end", dy=0);
//   %p_ILP_R=(72,-69.0);
//   &RESET @WIRE(mode="straight") {#ILP:R %p_ILP_R};
//   %p_ILP_R @TEXT("RESET", size=0.8, halign="end", dy=0);
//   %p_ILP_Q=(96,-67.0);
//   &BIT @WIRE(mode="straight") {#ILP:Q %p_ILP_Q};
//   %p_ILP_Q @TEXT("BIT", size=0.8, halign="start", dy=0);
//   %p_ILP_QB=(96,-69.0);
//   &pb @WIRE(mode="straight") {#ILP:QB %p_ILP_QB};
//   %p_ILP_QB @TEXT("pb", size=0.8, halign="start", dy=0);
//   %p_ILP_VDD=(84,-61.0);
//   &VDD @WIRE(mode="straight") {#ILP:VDD %p_ILP_VDD};
//   %p_ILP_VDD @TEXT("VDD", size=0.8, halign="start", dy=0.5);
//   %p_ILP_VSS=(84,-75.0);
//   &VSS @WIRE(mode="straight") {#ILP:VSS %p_ILP_VSS};
//   %p_ILP_VSS @TEXT("VSS", size=0.8, halign="start", dy=0.5);
//   #ILN @TEXT("drive=2", key="sizing", dy=-9.0, size=0.7);
//   #ILN @PLACE(0,-90.0) => @ORIENT("R0");
//   %p_ILN_S=(-12,-89.0);
//   &sn @WIRE(mode="straight") {#ILN:S %p_ILN_S};
//   %p_ILN_S @TEXT("sn", size=0.8, halign="end", dy=0);
//   %p_ILN_R=(-12,-91.0);
//   &RESET @WIRE(mode="straight") {#ILN:R %p_ILN_R};
//   %p_ILN_R @TEXT("RESET", size=0.8, halign="end", dy=0);
//   %p_ILN_Q=(12,-89.0);
//   &nb @WIRE(mode="straight") {#ILN:Q %p_ILN_Q};
//   %p_ILN_Q @TEXT("nb", size=0.8, halign="start", dy=0);
//   %p_ILN_QB=(12,-91.0);
//   &nbb @WIRE(mode="straight") {#ILN:QB %p_ILN_QB};
//   %p_ILN_QB @TEXT("nbb", size=0.8, halign="start", dy=0);
//   %p_ILN_VDD=(0,-83.0);
//   &VDD @WIRE(mode="straight") {#ILN:VDD %p_ILN_VDD};
//   %p_ILN_VDD @TEXT("VDD", size=0.8, halign="start", dy=0.5);
//   %p_ILN_VSS=(0,-97.0);
//   &VSS @WIRE(mode="straight") {#ILN:VSS %p_ILN_VSS};
//   %p_ILN_VSS @TEXT("VSS", size=0.8, halign="start", dy=0.5);
//   #ID @TEXT("wn=1600n wp=1200n", key="sizing", dy=-9.0, size=0.7);
//   #ID @PLACE(42,-90.0) => @ORIENT("R0");
//   %p_ID_A=(30,-89.0);
//   &pb @WIRE(mode="straight") {#ID:A %p_ID_A};
//   %p_ID_A @TEXT("pb", size=0.8, halign="end", dy=0);
//   %p_ID_B=(30,-91.0);
//   &nbb @WIRE(mode="straight") {#ID:B %p_ID_B};
//   %p_ID_B @TEXT("nbb", size=0.8, halign="end", dy=0);
//   %p_ID_Y=(54,-90.0);
//   &DONE @WIRE(mode="straight") {#ID:Y %p_ID_Y};
//   %p_ID_Y @TEXT("DONE", size=0.8, halign="start", dy=0);
//   %p_ID_VDD=(42,-83.0);
//   &VDD @WIRE(mode="straight") {#ID:VDD %p_ID_VDD};
//   %p_ID_VDD @TEXT("VDD", size=0.8, halign="start", dy=0.5);
//   %p_ID_VSS=(42,-97.0);
//   &VSS @WIRE(mode="straight") {#ID:VSS %p_ID_VSS};
//   %p_ID_VSS @TEXT("VSS", size=0.8, halign="start", dy=0.5);
//   #IDB @TEXT("wn=800n wp=1200n", key="sizing", dy=-8.0, size=0.7);
//   #IDB @PLACE(84,-90.0) => @ORIENT("R0");
//   %p_IDB_A=(72,-90.0);
//   &DONE @WIRE(mode="straight") {#IDB:A %p_IDB_A};
//   %p_IDB_A @TEXT("DONE", size=0.8, halign="end", dy=0);
//   %p_IDB_Y=(96,-90.0);
//   &doneb @WIRE(mode="straight") {#IDB:Y %p_IDB_Y};
//   %p_IDB_Y @TEXT("doneb", size=0.8, halign="start", dy=0);
//   %p_IDB_VDD=(84,-84.0);
//   &VDD @WIRE(mode="straight") {#IDB:VDD %p_IDB_VDD};
//   %p_IDB_VDD @TEXT("VDD", size=0.8, halign="start", dy=0.5);
//   %p_IDB_VSS=(84,-96.0);
//   &VSS @WIRE(mode="straight") {#IDB:VSS %p_IDB_VSS};
//   %p_IDB_VSS @TEXT("VSS", size=0.8, halign="start", dy=0.5);
//   #IUP @TEXT("wn=1600n wp=4800n", key="sizing", dy=-9.0, size=0.7);
//   #IUP @PLACE(0,-112.0) => @ORIENT("R0");
//   %p_IUP_A=(-12,-111.0);
//   &pb @WIRE(mode="straight") {#IUP:A %p_IUP_A};
//   %p_IUP_A @TEXT("pb", size=0.8, halign="end", dy=0);
//   %p_IUP_B=(-12,-113.0);
//   &CVB @WIRE(mode="straight") {#IUP:B %p_IUP_B};
//   %p_IUP_B @TEXT("CVB", size=0.8, halign="end", dy=0);
//   %p_IUP_Y=(12,-112.0);
//   &UP @WIRE(mode="straight") {#IUP:Y %p_IUP_Y};
//   %p_IUP_Y @TEXT("UP", size=0.8, halign="start", dy=0);
//   %p_IUP_VDD=(0,-105.0);
//   &VDD @WIRE(mode="straight") {#IUP:VDD %p_IUP_VDD};
//   %p_IUP_VDD @TEXT("VDD", size=0.8, halign="start", dy=0.5);
//   %p_IUP_VSS=(0,-119.0);
//   &VSS @WIRE(mode="straight") {#IUP:VSS %p_IUP_VSS};
//   %p_IUP_VSS @TEXT("VSS", size=0.8, halign="start", dy=0.5);
//   #IDN @TEXT("wn=1600n wp=4800n", key="sizing", dy=-9.0, size=0.7);
//   #IDN @PLACE(42,-112.0) => @ORIENT("R0");
//   %p_IDN_A=(30,-111.0);
//   &nbb @WIRE(mode="straight") {#IDN:A %p_IDN_A};
//   %p_IDN_A @TEXT("nbb", size=0.8, halign="end", dy=0);
//   %p_IDN_B=(30,-113.0);
//   &CVB @WIRE(mode="straight") {#IDN:B %p_IDN_B};
//   %p_IDN_B @TEXT("CVB", size=0.8, halign="end", dy=0);
//   %p_IDN_Y=(54,-112.0);
//   &DN @WIRE(mode="straight") {#IDN:Y %p_IDN_Y};
//   %p_IDN_Y @TEXT("DN", size=0.8, halign="start", dy=0);
//   %p_IDN_VDD=(42,-105.0);
//   &VDD @WIRE(mode="straight") {#IDN:VDD %p_IDN_VDD};
//   %p_IDN_VDD @TEXT("VDD", size=0.8, halign="start", dy=0.5);
//   %p_IDN_VSS=(42,-119.0);
//   &VSS @WIRE(mode="straight") {#IDN:VSS %p_IDN_VSS};
//   %p_IDN_VSS @TEXT("VSS", size=0.8, halign="start", dy=0.5);
//   #IW @TEXT("cw=cw", key="sizing", dy=-8.0, size=0.7);
//   #IW @PLACE(84,-112.0) => @ORIENT("R0");
//   %p_IW_A=(72,-112.0);
//   &DONE @WIRE(mode="straight") {#IW:A %p_IW_A};
//   %p_IW_A @TEXT("DONE", size=0.8, halign="end", dy=0);
//   %p_IW_Y=(96,-112.0);
//   &NEXT @WIRE(mode="straight") {#IW:Y %p_IW_Y};
//   %p_IW_Y @TEXT("NEXT", size=0.8, halign="start", dy=0);
//   %p_IW_VDD=(84,-106.0);
//   &VDD @WIRE(mode="straight") {#IW:VDD %p_IW_VDD};
//   %p_IW_VDD @TEXT("VDD", size=0.8, halign="start", dy=0.5);
//   %p_IW_VSS=(84,-118.0);
//   &VSS @WIRE(mode="straight") {#IW:VSS %p_IW_VSS};
//   %p_IW_VSS @TEXT("VSS", size=0.8, halign="start", dy=0.5);
//   {#IEN #IE #IASET #IARESET #IACTIVE #IGRANT #ISP #ISTO #ISPI #ISN #ISNI #ILP #ILN #ID #IDB #IUP #IDN #IW} @GROUP;
//   {#ILP #ILN} @AS $MATCHED;
//   {&PREV &CV &CVB &RESET &P &N &FORCE &CK &REQ &NEXT &BIT &UP &DN &DONE &VDD &VSS} @REMOVE-FROM $PORT_FILL_SET;
//   %port0=$IO_PORT @ATTACH &PREV => @PLACE(-28,0) => @ORIENT("R0");
//   %port1=$IO_PORT @ATTACH &CV => @PLACE(-28,-3) => @ORIENT("R0");
//   %port2=$IO_PORT @ATTACH &CVB => @PLACE(-28,-6) => @ORIENT("R0");
//   %port3=$IO_PORT @ATTACH &RESET => @PLACE(-28,-9) => @ORIENT("R0");
//   %port4=$IO_PORT @ATTACH &P => @PLACE(-28,-12) => @ORIENT("R0");
//   %port5=$IO_PORT @ATTACH &N => @PLACE(-28,-15) => @ORIENT("R0");
//   %port6=$IO_PORT @ATTACH &FORCE => @PLACE(-28,-18) => @ORIENT("R0");
//   %port7=$IO_PORT @ATTACH &CK => @PLACE(-28,-21) => @ORIENT("R0");
//   %port8=$IO_PORT @ATTACH &REQ => @PLACE(-28,-24) => @ORIENT("R0");
//   %port9=$IO_PORT @ATTACH &NEXT => @PLACE(-28,-27) => @ORIENT("R0");
//   %port10=$IO_PORT @ATTACH &BIT => @PLACE(-28,-30) => @ORIENT("R0");
//   %port11=$IO_PORT @ATTACH &UP => @PLACE(-28,-33) => @ORIENT("R0");
//   %port12=$IO_PORT @ATTACH &DN => @PLACE(-28,-36) => @ORIENT("R0");
//   %port13=$IO_PORT @ATTACH &DONE => @PLACE(-28,-39) => @ORIENT("R0");
//   %port14=$IO_PORT @ATTACH &VDD => @PLACE(-28,-42) => @ORIENT("R0");
//   %port15=$IO_PORT @ATTACH &VSS => @PLACE(-28,-45) => @ORIENT("R0");
//   (-28,24) @TEXT("adc_sarlogic_step", size=1.2, bold=true);
//   (-28,20) @TEXT("One RTZ decision stage. Local ACTIVE stores evaluation permission; dual rails retain the result; delayed completion prepares the next stage.", size=0.7);
//   (-28,16) @TEXT("Defaults: cw=1u", size=0.8);
// }
ends adc_sarlogic_step

// 14-decision asynchronous SAR, 13 split-CDAC updates, parallel output storage and persistent RDY.
subckt adc_sarlogic (CONV OUTP OUTN CLKC UP12 UP11 UP10 UP9 UP8 UP7 UP6 UP5 UP4 UP3 UP2 UP1 UP0 DN12 DN11 DN10 DN9 DN8 DN7 DN6 DN5 DN4 DN3 DN2 DN1 DN0 D13 D12 D11 D10 D9 D8 D7 D6 D5 D4 D3 D2 D1 D0 RDY DVDD VSS)
parameters wait_fast=400n wait_slow=9400n extra3=1800n extra456=6u extra9=8u timer_load=1400n reset_load=3u start_load=3600n ready_load=5u
ICV (CONV cv DVDD VSS) adc_sarlogic_buf drive=4
ICB (cv cvb DVDD VSS) adc_sarlogic_inv wn=1600n wp=2400n drive=4
IP (OUTP pi pib DVDD VSS) adc_sarlogic_cmpbuf
IN (OUTN ni nib DVDD VSS) adc_sarlogic_cmpbuf
IAB0 (cv ab0 DVDD VSS) adc_sarlogic_delay cw=2u
IAB1 (ab0 ab1 DVDD VSS) adc_sarlogic_delay cw=2u
IAB2 (ab1 ab2 DVDD VSS) adc_sarlogic_delay cw=2u
IAB3 (ab2 cv_abort DVDD VSS) adc_sarlogic_delay cw=2u
IACB (cv acvb DVDD VSS) adc_sarlogic_inv
IAP (acvb cv_abort abort DVDD VSS) adc_sarlogic_and2
IRC0 (cv cr0 DVDD VSS) adc_sarlogic_delay cw=reset_load
IRC1 (cr0 cr1 DVDD VSS) adc_sarlogic_delay cw=reset_load
IRC2 (cr1 cr2 DVDD VSS) adc_sarlogic_delay cw=reset_load
IRC3 (cr2 cr3 DVDD VSS) adc_sarlogic_delay cw=reset_load
IRC4 (cr3 cr4 DVDD VSS) adc_sarlogic_delay cw=reset_load
IRC5 (cr4 cv_resetwait DVDD VSS) adc_sarlogic_delay cw=reset_load
IRB (cv cv_resetwait reset DVDD VSS) adc_sarlogic_nor2 wn=1200n wp=3600n drive=6
IST0 (cv st0 DVDD VSS) adc_sarlogic_delay cw=start_load
IST1 (st0 start DVDD VSS) adc_sarlogic_delay cw=start_load
IS1 (start cv cvb reset pi ni force CLKC req1 next1 raw13 UP12 DN12 done1 DVDD VSS) adc_sarlogic_step cw=wait_fast
IS2 (next1 cv cvb reset pi ni force CLKC req2 next2 raw12 UP11 DN11 done2 DVDD VSS) adc_sarlogic_step cw=wait_fast
IS3 (next2 cv cvb reset pi ni force CLKC req3 next3 raw11 UP10 DN10 done3 DVDD VSS) adc_sarlogic_step cw=wait_fast+extra3
IS4 (next3 cv cvb reset pi ni force CLKC req4 next4 raw10 UP9 DN9 done4 DVDD VSS) adc_sarlogic_step cw=wait_fast+extra456
IS5 (next4 cv cvb reset pi ni force CLKC req5 next5 raw9 UP8 DN8 done5 DVDD VSS) adc_sarlogic_step cw=wait_fast+extra456
IS6 (next5 cv cvb reset pi ni force CLKC req6 next6 raw8 UP7 DN7 done6 DVDD VSS) adc_sarlogic_step cw=wait_fast+extra456
IS7 (next6 cv cvb reset pi ni force CLKC req7 next7 raw7 UP6 DN6 done7 DVDD VSS) adc_sarlogic_step cw=wait_slow
IS8 (next7 cv cvb reset pi ni force CLKC req8 next8 raw6 UP5 DN5 done8 DVDD VSS) adc_sarlogic_step cw=wait_slow
IS9 (next8 cv cvb reset pi ni force CLKC req9 next9 raw5 UP4 DN4 done9 DVDD VSS) adc_sarlogic_step cw=wait_slow+extra9
IS10 (next9 cv cvb reset pi ni force CLKC req10 next10 raw4 UP3 DN3 done10 DVDD VSS) adc_sarlogic_step cw=wait_slow
IS11 (next10 cv cvb reset pi ni force CLKC req11 next11 raw3 UP2 DN2 done11 DVDD VSS) adc_sarlogic_step cw=wait_slow
IS12 (next11 cv cvb reset pi ni force CLKC req12 next12 raw2 UP1 DN1 done12 DVDD VSS) adc_sarlogic_step cw=wait_slow
IS13 (next12 cv cvb reset pi ni force CLKC req13 next13 raw1 UP0 DN0 done13 DVDD VSS) adc_sarlogic_step cw=wait_slow
IS14 (next13 cv cvb reset pi ni force CLKC req14 next14 raw0 lastup lastdn done14 DVDD VSS) adc_sarlogic_step cw=wait_slow
IR0 (req1 req2 rq0 DVDD VSS) adc_sarlogic_nor2 wn=800n wp=2400n
IR1 (req3 req4 rq1 DVDD VSS) adc_sarlogic_nor2 wn=800n wp=2400n
IR2 (req5 req6 rq2 DVDD VSS) adc_sarlogic_nor2 wn=800n wp=2400n
IR3 (req7 req8 rq3 DVDD VSS) adc_sarlogic_nor2 wn=800n wp=2400n
IR4 (req9 req10 rq4 DVDD VSS) adc_sarlogic_nor2 wn=800n wp=2400n
IR5 (req11 req12 rq5 DVDD VSS) adc_sarlogic_nor2 wn=800n wp=2400n
IR6 (req13 req14 rq6 DVDD VSS) adc_sarlogic_nor2 wn=800n wp=2400n
IRA (rq0 rq1 rq2 rq3 ra DVDD VSS) adc_sarlogic_nand4 wn=2400n wp=900n
IRZ (rq4 rq5 rq6 rz DVDD VSS) adc_sarlogic_nand3 wn=1800n wp=900n
IROR (ra rz rqbar DVDD VSS) adc_sarlogic_nor2 wn=1200n wp=3600n drive=2
IFB (force forceb DVDD VSS) adc_sarlogic_inv wn=1200n wp=1800n
ICKH (rqbar cv pib nib forceb CLKC DVDD VSS) adc_sarlogic_clock
IT0 (CLKC CLKC to0 DVDD VSS) adc_sarlogic_resetdelay cw=timer_load
IT1 (to0 CLKC to1 DVDD VSS) adc_sarlogic_resetdelay cw=timer_load
IT2 (to1 CLKC to2 DVDD VSS) adc_sarlogic_resetdelay cw=timer_load
IT3 (to2 CLKC to3 DVDD VSS) adc_sarlogic_resetdelay cw=timer_load
IT4 (to3 CLKC to4 DVDD VSS) adc_sarlogic_resetdelay cw=timer_load
IT5 (to4 CLKC to5 DVDD VSS) adc_sarlogic_resetdelay cw=timer_load
IT6 (to5 CLKC to6 DVDD VSS) adc_sarlogic_resetdelay cw=timer_load
IT7 (to6 CLKC to7 DVDD VSS) adc_sarlogic_resetdelay cw=timer_load
IT8 (to7 CLKC to8 DVDD VSS) adc_sarlogic_resetdelay cw=timer_load
IT9 (to8 CLKC to9 DVDD VSS) adc_sarlogic_resetdelay cw=timer_load
IT10 (to9 CLKC to10 DVDD VSS) adc_sarlogic_resetdelay cw=timer_load
IT11 (to10 CLKC to11 DVDD VSS) adc_sarlogic_resetdelay cw=timer_load
IT12 (to11 CLKC to12 DVDD VSS) adc_sarlogic_resetdelay cw=timer_load
IT13 (to12 CLKC to13 DVDD VSS) adc_sarlogic_resetdelay cw=timer_load
IT14 (to13 CLKC to14 DVDD VSS) adc_sarlogic_resetdelay cw=timer_load
IT15 (to14 CLKC to15 DVDD VSS) adc_sarlogic_resetdelay cw=timer_load
ITO (to15 CLKC force DVDD VSS) adc_sarlogic_and2
IEOC (done14 cv eoc DVDD VSS) adc_sarlogic_and2
IENREG (eoc abort load DVDD VSS) adc_sarlogic_or2
ILBUF (load loadp DVDD VSS) adc_sarlogic_buf drive=6
ILBAR (loadp loadb DVDD VSS) adc_sarlogic_inv wn=4u wp=6u
ID13 (raw13 loadp loadb D13 DVDD VSS) adc_sarlogic_latch
ID12 (raw12 loadp loadb D12 DVDD VSS) adc_sarlogic_latch
ID11 (raw11 loadp loadb D11 DVDD VSS) adc_sarlogic_latch
ID10 (raw10 loadp loadb D10 DVDD VSS) adc_sarlogic_latch
ID9 (raw9 loadp loadb D9 DVDD VSS) adc_sarlogic_latch
ID8 (raw8 loadp loadb D8 DVDD VSS) adc_sarlogic_latch
ID7 (raw7 loadp loadb D7 DVDD VSS) adc_sarlogic_latch
ID6 (raw6 loadp loadb D6 DVDD VSS) adc_sarlogic_latch
ID5 (raw5 loadp loadb D5 DVDD VSS) adc_sarlogic_latch
ID4 (raw4 loadp loadb D4 DVDD VSS) adc_sarlogic_latch
ID3 (raw3 loadp loadb D3 DVDD VSS) adc_sarlogic_latch
ID2 (raw2 loadp loadb D2 DVDD VSS) adc_sarlogic_latch
ID1 (raw1 loadp loadb D1 DVDD VSS) adc_sarlogic_latch
ID0 (raw0 loadp loadb D0 DVDD VSS) adc_sarlogic_latch
IRWB (cv_resetwait cv_resetwaitb DVDD VSS) adc_sarlogic_inv
IRSTP (cv cv_resetwaitb beginpulse DVDD VSS) adc_sarlogic_and2
IDONE (eoc abort committed DVDD VSS) adc_sarlogic_or2
ICOMMIT (committed beginpulse complete completeb DVDD VSS) adc_sarlogic_sr
IRD0 (complete rdywait0 DVDD VSS) adc_sarlogic_delay cw=ready_load
IRD1 (rdywait0 rdywait1 DVDD VSS) adc_sarlogic_delay cw=ready_load
IRD2 (rdywait1 rdywait2 DVDD VSS) adc_sarlogic_delay cw=ready_load
IRD3 (rdywait2 rdywait3 DVDD VSS) adc_sarlogic_delay cw=ready_load
IRD4 (rdywait3 rdywait4 DVDD VSS) adc_sarlogic_delay cw=ready_load
IRDS (rdywait4 complete setready DVDD VSS) adc_sarlogic_and2
IRDY (setready beginpulse ready readyb DVDD VSS) adc_sarlogic_sr
IRDB (ready RDY DVDD VSS) adc_sarlogic_buf drive=4
// @RNL {
//   %symbol = @DEFINE-SYMBOL(box=[-9,-44.0,9,44.0]) {
//     @LINE {(-7,-43.0) (7,-43.0) (7,43.0) (-7,43.0) (-7,-43.0)};
//     (-9,2) @PIN(terminal="CONV", direction="left");
//     @LINE {(-9,2) (-7,2)};
//     (-6.5,2) @TEXT("CONV", size=0.7, halign="start");
//     (-9,0) @PIN(terminal="OUTP", direction="left");
//     @LINE {(-9,0) (-7,0)};
//     (-6.5,0) @TEXT("OUTP", size=0.7, halign="start");
//     (-9,-2) @PIN(terminal="OUTN", direction="left");
//     @LINE {(-9,-2) (-7,-2)};
//     (-6.5,-2) @TEXT("OUTN", size=0.7, halign="start");
//     (9,41) @PIN(terminal="CLKC", direction="right");
//     @LINE {(9,41) (7,41)};
//     (6.5,41) @TEXT("CLKC", size=0.7, halign="end");
//     (9,39) @PIN(terminal="UP12", direction="right");
//     @LINE {(9,39) (7,39)};
//     (6.5,39) @TEXT("UP12", size=0.7, halign="end");
//     (9,37) @PIN(terminal="UP11", direction="right");
//     @LINE {(9,37) (7,37)};
//     (6.5,37) @TEXT("UP11", size=0.7, halign="end");
//     (9,35) @PIN(terminal="UP10", direction="right");
//     @LINE {(9,35) (7,35)};
//     (6.5,35) @TEXT("UP10", size=0.7, halign="end");
//     (9,33) @PIN(terminal="UP9", direction="right");
//     @LINE {(9,33) (7,33)};
//     (6.5,33) @TEXT("UP9", size=0.7, halign="end");
//     (9,31) @PIN(terminal="UP8", direction="right");
//     @LINE {(9,31) (7,31)};
//     (6.5,31) @TEXT("UP8", size=0.7, halign="end");
//     (9,29) @PIN(terminal="UP7", direction="right");
//     @LINE {(9,29) (7,29)};
//     (6.5,29) @TEXT("UP7", size=0.7, halign="end");
//     (9,27) @PIN(terminal="UP6", direction="right");
//     @LINE {(9,27) (7,27)};
//     (6.5,27) @TEXT("UP6", size=0.7, halign="end");
//     (9,25) @PIN(terminal="UP5", direction="right");
//     @LINE {(9,25) (7,25)};
//     (6.5,25) @TEXT("UP5", size=0.7, halign="end");
//     (9,23) @PIN(terminal="UP4", direction="right");
//     @LINE {(9,23) (7,23)};
//     (6.5,23) @TEXT("UP4", size=0.7, halign="end");
//     (9,21) @PIN(terminal="UP3", direction="right");
//     @LINE {(9,21) (7,21)};
//     (6.5,21) @TEXT("UP3", size=0.7, halign="end");
//     (9,19) @PIN(terminal="UP2", direction="right");
//     @LINE {(9,19) (7,19)};
//     (6.5,19) @TEXT("UP2", size=0.7, halign="end");
//     (9,17) @PIN(terminal="UP1", direction="right");
//     @LINE {(9,17) (7,17)};
//     (6.5,17) @TEXT("UP1", size=0.7, halign="end");
//     (9,15) @PIN(terminal="UP0", direction="right");
//     @LINE {(9,15) (7,15)};
//     (6.5,15) @TEXT("UP0", size=0.7, halign="end");
//     (9,13) @PIN(terminal="DN12", direction="right");
//     @LINE {(9,13) (7,13)};
//     (6.5,13) @TEXT("DN12", size=0.7, halign="end");
//     (9,11) @PIN(terminal="DN11", direction="right");
//     @LINE {(9,11) (7,11)};
//     (6.5,11) @TEXT("DN11", size=0.7, halign="end");
//     (9,9) @PIN(terminal="DN10", direction="right");
//     @LINE {(9,9) (7,9)};
//     (6.5,9) @TEXT("DN10", size=0.7, halign="end");
//     (9,7) @PIN(terminal="DN9", direction="right");
//     @LINE {(9,7) (7,7)};
//     (6.5,7) @TEXT("DN9", size=0.7, halign="end");
//     (9,5) @PIN(terminal="DN8", direction="right");
//     @LINE {(9,5) (7,5)};
//     (6.5,5) @TEXT("DN8", size=0.7, halign="end");
//     (9,3) @PIN(terminal="DN7", direction="right");
//     @LINE {(9,3) (7,3)};
//     (6.5,3) @TEXT("DN7", size=0.7, halign="end");
//     (9,1) @PIN(terminal="DN6", direction="right");
//     @LINE {(9,1) (7,1)};
//     (6.5,1) @TEXT("DN6", size=0.7, halign="end");
//     (9,-1) @PIN(terminal="DN5", direction="right");
//     @LINE {(9,-1) (7,-1)};
//     (6.5,-1) @TEXT("DN5", size=0.7, halign="end");
//     (9,-3) @PIN(terminal="DN4", direction="right");
//     @LINE {(9,-3) (7,-3)};
//     (6.5,-3) @TEXT("DN4", size=0.7, halign="end");
//     (9,-5) @PIN(terminal="DN3", direction="right");
//     @LINE {(9,-5) (7,-5)};
//     (6.5,-5) @TEXT("DN3", size=0.7, halign="end");
//     (9,-7) @PIN(terminal="DN2", direction="right");
//     @LINE {(9,-7) (7,-7)};
//     (6.5,-7) @TEXT("DN2", size=0.7, halign="end");
//     (9,-9) @PIN(terminal="DN1", direction="right");
//     @LINE {(9,-9) (7,-9)};
//     (6.5,-9) @TEXT("DN1", size=0.7, halign="end");
//     (9,-11) @PIN(terminal="DN0", direction="right");
//     @LINE {(9,-11) (7,-11)};
//     (6.5,-11) @TEXT("DN0", size=0.7, halign="end");
//     (9,-13) @PIN(terminal="D13", direction="right");
//     @LINE {(9,-13) (7,-13)};
//     (6.5,-13) @TEXT("D13", size=0.7, halign="end");
//     (9,-15) @PIN(terminal="D12", direction="right");
//     @LINE {(9,-15) (7,-15)};
//     (6.5,-15) @TEXT("D12", size=0.7, halign="end");
//     (9,-17) @PIN(terminal="D11", direction="right");
//     @LINE {(9,-17) (7,-17)};
//     (6.5,-17) @TEXT("D11", size=0.7, halign="end");
//     (9,-19) @PIN(terminal="D10", direction="right");
//     @LINE {(9,-19) (7,-19)};
//     (6.5,-19) @TEXT("D10", size=0.7, halign="end");
//     (9,-21) @PIN(terminal="D9", direction="right");
//     @LINE {(9,-21) (7,-21)};
//     (6.5,-21) @TEXT("D9", size=0.7, halign="end");
//     (9,-23) @PIN(terminal="D8", direction="right");
//     @LINE {(9,-23) (7,-23)};
//     (6.5,-23) @TEXT("D8", size=0.7, halign="end");
//     (9,-25) @PIN(terminal="D7", direction="right");
//     @LINE {(9,-25) (7,-25)};
//     (6.5,-25) @TEXT("D7", size=0.7, halign="end");
//     (9,-27) @PIN(terminal="D6", direction="right");
//     @LINE {(9,-27) (7,-27)};
//     (6.5,-27) @TEXT("D6", size=0.7, halign="end");
//     (9,-29) @PIN(terminal="D5", direction="right");
//     @LINE {(9,-29) (7,-29)};
//     (6.5,-29) @TEXT("D5", size=0.7, halign="end");
//     (9,-31) @PIN(terminal="D4", direction="right");
//     @LINE {(9,-31) (7,-31)};
//     (6.5,-31) @TEXT("D4", size=0.7, halign="end");
//     (9,-33) @PIN(terminal="D3", direction="right");
//     @LINE {(9,-33) (7,-33)};
//     (6.5,-33) @TEXT("D3", size=0.7, halign="end");
//     (9,-35) @PIN(terminal="D2", direction="right");
//     @LINE {(9,-35) (7,-35)};
//     (6.5,-35) @TEXT("D2", size=0.7, halign="end");
//     (9,-37) @PIN(terminal="D1", direction="right");
//     @LINE {(9,-37) (7,-37)};
//     (6.5,-37) @TEXT("D1", size=0.7, halign="end");
//     (9,-39) @PIN(terminal="D0", direction="right");
//     @LINE {(9,-39) (7,-39)};
//     (6.5,-39) @TEXT("D0", size=0.7, halign="end");
//     (9,-41) @PIN(terminal="RDY", direction="right");
//     @LINE {(9,-41) (7,-41)};
//     (6.5,-41) @TEXT("RDY", size=0.7, halign="end");
//     (0,44.0) @PIN(terminal="DVDD", direction="up");
//     (0,-44.0) @PIN(terminal="VSS", direction="down");
//     ? @TEXT("${name}", key="name", dx=-6, dy=46.0, size=1, halign="start");
//   };
//   # @SET-SYMBOL %symbol;
//   &DVDD @ADD-TO $SUPPLY_NET_SET; &VSS @ADD-TO $GROUND_NET_SET;
//   $LABEL_TERMINAL_SET @TEXT("${net}", key="netname", size=0.6);
//   #ICV @TEXT("drive=4", key="sizing", dy=-8.0, size=0.7);
//   #ICV @PLACE(0,0) => @ORIENT("R0");
//   %p_ICV_A=(-12,0);
//   &CONV @WIRE(mode="straight") {#ICV:A %p_ICV_A};
//   %p_ICV_A @TEXT("CONV", size=0.8, halign="end", dy=0);
//   %p_ICV_Y=(12,0);
//   &cv @WIRE(mode="straight") {#ICV:Y %p_ICV_Y};
//   %p_ICV_Y @TEXT("cv", size=0.8, halign="start", dy=0);
//   %p_ICV_VDD=(0,6.0);
//   &DVDD @WIRE(mode="straight") {#ICV:VDD %p_ICV_VDD};
//   %p_ICV_VDD @TEXT("DVDD", size=0.8, halign="start", dy=0.5);
//   %p_ICV_VSS=(0,-6.0);
//   &VSS @WIRE(mode="straight") {#ICV:VSS %p_ICV_VSS};
//   %p_ICV_VSS @TEXT("VSS", size=0.8, halign="start", dy=0.5);
//   #ICB @TEXT("wn=1600n wp=2400n drive=4", key="sizing", dy=-8.0, size=0.7);
//   #ICB @PLACE(42,0) => @ORIENT("R0");
//   %p_ICB_A=(30,0);
//   &cv @WIRE(mode="straight") {#ICB:A %p_ICB_A};
//   %p_ICB_A @TEXT("cv", size=0.8, halign="end", dy=0);
//   %p_ICB_Y=(54,0);
//   &cvb @WIRE(mode="straight") {#ICB:Y %p_ICB_Y};
//   %p_ICB_Y @TEXT("cvb", size=0.8, halign="start", dy=0);
//   %p_ICB_VDD=(42,6.0);
//   &DVDD @WIRE(mode="straight") {#ICB:VDD %p_ICB_VDD};
//   %p_ICB_VDD @TEXT("DVDD", size=0.8, halign="start", dy=0.5);
//   %p_ICB_VSS=(42,-6.0);
//   &VSS @WIRE(mode="straight") {#ICB:VSS %p_ICB_VSS};
//   %p_ICB_VSS @TEXT("VSS", size=0.8, halign="start", dy=0.5);
//   #IP @PLACE(84,0) => @ORIENT("R0");
//   %p_IP_A=(72,0);
//   &OUTP @WIRE(mode="straight") {#IP:A %p_IP_A};
//   %p_IP_A @TEXT("OUTP", size=0.8, halign="end", dy=0);
//   %p_IP_Y=(96,1);
//   &pi @WIRE(mode="straight") {#IP:Y %p_IP_Y};
//   %p_IP_Y @TEXT("pi", size=0.8, halign="start", dy=0);
//   %p_IP_YB=(96,-1);
//   &pib @WIRE(mode="straight") {#IP:YB %p_IP_YB};
//   %p_IP_YB @TEXT("pib", size=0.8, halign="start", dy=0);
//   %p_IP_VDD=(84,7.0);
//   &DVDD @WIRE(mode="straight") {#IP:VDD %p_IP_VDD};
//   %p_IP_VDD @TEXT("DVDD", size=0.8, halign="start", dy=0.5);
//   %p_IP_VSS=(84,-7.0);
//   &VSS @WIRE(mode="straight") {#IP:VSS %p_IP_VSS};
//   %p_IP_VSS @TEXT("VSS", size=0.8, halign="start", dy=0.5);
//   #IN @PLACE(126,0) => @ORIENT("R0");
//   %p_IN_A=(114,0);
//   &OUTN @WIRE(mode="straight") {#IN:A %p_IN_A};
//   %p_IN_A @TEXT("OUTN", size=0.8, halign="end", dy=0);
//   %p_IN_Y=(138,1);
//   &ni @WIRE(mode="straight") {#IN:Y %p_IN_Y};
//   %p_IN_Y @TEXT("ni", size=0.8, halign="start", dy=0);
//   %p_IN_YB=(138,-1);
//   &nib @WIRE(mode="straight") {#IN:YB %p_IN_YB};
//   %p_IN_YB @TEXT("nib", size=0.8, halign="start", dy=0);
//   %p_IN_VDD=(126,7.0);
//   &DVDD @WIRE(mode="straight") {#IN:VDD %p_IN_VDD};
//   %p_IN_VDD @TEXT("DVDD", size=0.8, halign="start", dy=0.5);
//   %p_IN_VSS=(126,-7.0);
//   &VSS @WIRE(mode="straight") {#IN:VSS %p_IN_VSS};
//   %p_IN_VSS @TEXT("VSS", size=0.8, halign="start", dy=0.5);
//   #IAB0 @TEXT("cw=2u", key="sizing", dy=-8.0, size=0.7);
//   #IAB0 @PLACE(168,0) => @ORIENT("R0");
//   %p_IAB0_A=(156,0);
//   &cv @WIRE(mode="straight") {#IAB0:A %p_IAB0_A};
//   %p_IAB0_A @TEXT("cv", size=0.8, halign="end", dy=0);
//   %p_IAB0_Y=(180,0);
//   &ab0 @WIRE(mode="straight") {#IAB0:Y %p_IAB0_Y};
//   %p_IAB0_Y @TEXT("ab0", size=0.8, halign="start", dy=0);
//   %p_IAB0_VDD=(168,6.0);
//   &DVDD @WIRE(mode="straight") {#IAB0:VDD %p_IAB0_VDD};
//   %p_IAB0_VDD @TEXT("DVDD", size=0.8, halign="start", dy=0.5);
//   %p_IAB0_VSS=(168,-6.0);
//   &VSS @WIRE(mode="straight") {#IAB0:VSS %p_IAB0_VSS};
//   %p_IAB0_VSS @TEXT("VSS", size=0.8, halign="start", dy=0.5);
//   #IAB1 @TEXT("cw=2u", key="sizing", dy=-8.0, size=0.7);
//   #IAB1 @PLACE(0,-22.0) => @ORIENT("R0");
//   %p_IAB1_A=(-12,-22.0);
//   &ab0 @WIRE(mode="straight") {#IAB1:A %p_IAB1_A};
//   %p_IAB1_A @TEXT("ab0", size=0.8, halign="end", dy=0);
//   %p_IAB1_Y=(12,-22.0);
//   &ab1 @WIRE(mode="straight") {#IAB1:Y %p_IAB1_Y};
//   %p_IAB1_Y @TEXT("ab1", size=0.8, halign="start", dy=0);
//   %p_IAB1_VDD=(0,-16.0);
//   &DVDD @WIRE(mode="straight") {#IAB1:VDD %p_IAB1_VDD};
//   %p_IAB1_VDD @TEXT("DVDD", size=0.8, halign="start", dy=0.5);
//   %p_IAB1_VSS=(0,-28.0);
//   &VSS @WIRE(mode="straight") {#IAB1:VSS %p_IAB1_VSS};
//   %p_IAB1_VSS @TEXT("VSS", size=0.8, halign="start", dy=0.5);
//   #IAB2 @TEXT("cw=2u", key="sizing", dy=-8.0, size=0.7);
//   #IAB2 @PLACE(42,-22.0) => @ORIENT("R0");
//   %p_IAB2_A=(30,-22.0);
//   &ab1 @WIRE(mode="straight") {#IAB2:A %p_IAB2_A};
//   %p_IAB2_A @TEXT("ab1", size=0.8, halign="end", dy=0);
//   %p_IAB2_Y=(54,-22.0);
//   &ab2 @WIRE(mode="straight") {#IAB2:Y %p_IAB2_Y};
//   %p_IAB2_Y @TEXT("ab2", size=0.8, halign="start", dy=0);
//   %p_IAB2_VDD=(42,-16.0);
//   &DVDD @WIRE(mode="straight") {#IAB2:VDD %p_IAB2_VDD};
//   %p_IAB2_VDD @TEXT("DVDD", size=0.8, halign="start", dy=0.5);
//   %p_IAB2_VSS=(42,-28.0);
//   &VSS @WIRE(mode="straight") {#IAB2:VSS %p_IAB2_VSS};
//   %p_IAB2_VSS @TEXT("VSS", size=0.8, halign="start", dy=0.5);
//   #IAB3 @TEXT("cw=2u", key="sizing", dy=-8.0, size=0.7);
//   #IAB3 @PLACE(84,-22.0) => @ORIENT("R0");
//   %p_IAB3_A=(72,-22.0);
//   &ab2 @WIRE(mode="straight") {#IAB3:A %p_IAB3_A};
//   %p_IAB3_A @TEXT("ab2", size=0.8, halign="end", dy=0);
//   %p_IAB3_Y=(96,-22.0);
//   &cv_abort @WIRE(mode="straight") {#IAB3:Y %p_IAB3_Y};
//   %p_IAB3_Y @TEXT("cv_abort", size=0.8, halign="start", dy=0);
//   %p_IAB3_VDD=(84,-16.0);
//   &DVDD @WIRE(mode="straight") {#IAB3:VDD %p_IAB3_VDD};
//   %p_IAB3_VDD @TEXT("DVDD", size=0.8, halign="start", dy=0.5);
//   %p_IAB3_VSS=(84,-28.0);
//   &VSS @WIRE(mode="straight") {#IAB3:VSS %p_IAB3_VSS};
//   %p_IAB3_VSS @TEXT("VSS", size=0.8, halign="start", dy=0.5);
//   #IACB @PLACE(126,-22.0) => @ORIENT("R0");
//   %p_IACB_A=(114,-22.0);
//   &cv @WIRE(mode="straight") {#IACB:A %p_IACB_A};
//   %p_IACB_A @TEXT("cv", size=0.8, halign="end", dy=0);
//   %p_IACB_Y=(138,-22.0);
//   &acvb @WIRE(mode="straight") {#IACB:Y %p_IACB_Y};
//   %p_IACB_Y @TEXT("acvb", size=0.8, halign="start", dy=0);
//   %p_IACB_VDD=(126,-16.0);
//   &DVDD @WIRE(mode="straight") {#IACB:VDD %p_IACB_VDD};
//   %p_IACB_VDD @TEXT("DVDD", size=0.8, halign="start", dy=0.5);
//   %p_IACB_VSS=(126,-28.0);
//   &VSS @WIRE(mode="straight") {#IACB:VSS %p_IACB_VSS};
//   %p_IACB_VSS @TEXT("VSS", size=0.8, halign="start", dy=0.5);
//   #IAP @PLACE(168,-22.0) => @ORIENT("R0");
//   %p_IAP_A=(156,-21.0);
//   &acvb @WIRE(mode="straight") {#IAP:A %p_IAP_A};
//   %p_IAP_A @TEXT("acvb", size=0.8, halign="end", dy=0);
//   %p_IAP_B=(156,-23.0);
//   &cv_abort @WIRE(mode="straight") {#IAP:B %p_IAP_B};
//   %p_IAP_B @TEXT("cv_abort", size=0.8, halign="end", dy=0);
//   %p_IAP_Y=(180,-22.0);
//   &abort @WIRE(mode="straight") {#IAP:Y %p_IAP_Y};
//   %p_IAP_Y @TEXT("abort", size=0.8, halign="start", dy=0);
//   %p_IAP_VDD=(168,-15.0);
//   &DVDD @WIRE(mode="straight") {#IAP:VDD %p_IAP_VDD};
//   %p_IAP_VDD @TEXT("DVDD", size=0.8, halign="start", dy=0.5);
//   %p_IAP_VSS=(168,-29.0);
//   &VSS @WIRE(mode="straight") {#IAP:VSS %p_IAP_VSS};
//   %p_IAP_VSS @TEXT("VSS", size=0.8, halign="start", dy=0.5);
//   #IRC0 @TEXT("cw=reset_load", key="sizing", dy=-8.0, size=0.7);
//   #IRC0 @PLACE(0,-43.0) => @ORIENT("R0");
//   %p_IRC0_A=(-12,-43.0);
//   &cv @WIRE(mode="straight") {#IRC0:A %p_IRC0_A};
//   %p_IRC0_A @TEXT("cv", size=0.8, halign="end", dy=0);
//   %p_IRC0_Y=(12,-43.0);
//   &cr0 @WIRE(mode="straight") {#IRC0:Y %p_IRC0_Y};
//   %p_IRC0_Y @TEXT("cr0", size=0.8, halign="start", dy=0);
//   %p_IRC0_VDD=(0,-37.0);
//   &DVDD @WIRE(mode="straight") {#IRC0:VDD %p_IRC0_VDD};
//   %p_IRC0_VDD @TEXT("DVDD", size=0.8, halign="start", dy=0.5);
//   %p_IRC0_VSS=(0,-49.0);
//   &VSS @WIRE(mode="straight") {#IRC0:VSS %p_IRC0_VSS};
//   %p_IRC0_VSS @TEXT("VSS", size=0.8, halign="start", dy=0.5);
//   #IRC1 @TEXT("cw=reset_load", key="sizing", dy=-8.0, size=0.7);
//   #IRC1 @PLACE(42,-43.0) => @ORIENT("R0");
//   %p_IRC1_A=(30,-43.0);
//   &cr0 @WIRE(mode="straight") {#IRC1:A %p_IRC1_A};
//   %p_IRC1_A @TEXT("cr0", size=0.8, halign="end", dy=0);
//   %p_IRC1_Y=(54,-43.0);
//   &cr1 @WIRE(mode="straight") {#IRC1:Y %p_IRC1_Y};
//   %p_IRC1_Y @TEXT("cr1", size=0.8, halign="start", dy=0);
//   %p_IRC1_VDD=(42,-37.0);
//   &DVDD @WIRE(mode="straight") {#IRC1:VDD %p_IRC1_VDD};
//   %p_IRC1_VDD @TEXT("DVDD", size=0.8, halign="start", dy=0.5);
//   %p_IRC1_VSS=(42,-49.0);
//   &VSS @WIRE(mode="straight") {#IRC1:VSS %p_IRC1_VSS};
//   %p_IRC1_VSS @TEXT("VSS", size=0.8, halign="start", dy=0.5);
//   #IRC2 @TEXT("cw=reset_load", key="sizing", dy=-8.0, size=0.7);
//   #IRC2 @PLACE(84,-43.0) => @ORIENT("R0");
//   %p_IRC2_A=(72,-43.0);
//   &cr1 @WIRE(mode="straight") {#IRC2:A %p_IRC2_A};
//   %p_IRC2_A @TEXT("cr1", size=0.8, halign="end", dy=0);
//   %p_IRC2_Y=(96,-43.0);
//   &cr2 @WIRE(mode="straight") {#IRC2:Y %p_IRC2_Y};
//   %p_IRC2_Y @TEXT("cr2", size=0.8, halign="start", dy=0);
//   %p_IRC2_VDD=(84,-37.0);
//   &DVDD @WIRE(mode="straight") {#IRC2:VDD %p_IRC2_VDD};
//   %p_IRC2_VDD @TEXT("DVDD", size=0.8, halign="start", dy=0.5);
//   %p_IRC2_VSS=(84,-49.0);
//   &VSS @WIRE(mode="straight") {#IRC2:VSS %p_IRC2_VSS};
//   %p_IRC2_VSS @TEXT("VSS", size=0.8, halign="start", dy=0.5);
//   #IRC3 @TEXT("cw=reset_load", key="sizing", dy=-8.0, size=0.7);
//   #IRC3 @PLACE(126,-43.0) => @ORIENT("R0");
//   %p_IRC3_A=(114,-43.0);
//   &cr2 @WIRE(mode="straight") {#IRC3:A %p_IRC3_A};
//   %p_IRC3_A @TEXT("cr2", size=0.8, halign="end", dy=0);
//   %p_IRC3_Y=(138,-43.0);
//   &cr3 @WIRE(mode="straight") {#IRC3:Y %p_IRC3_Y};
//   %p_IRC3_Y @TEXT("cr3", size=0.8, halign="start", dy=0);
//   %p_IRC3_VDD=(126,-37.0);
//   &DVDD @WIRE(mode="straight") {#IRC3:VDD %p_IRC3_VDD};
//   %p_IRC3_VDD @TEXT("DVDD", size=0.8, halign="start", dy=0.5);
//   %p_IRC3_VSS=(126,-49.0);
//   &VSS @WIRE(mode="straight") {#IRC3:VSS %p_IRC3_VSS};
//   %p_IRC3_VSS @TEXT("VSS", size=0.8, halign="start", dy=0.5);
//   #IRC4 @TEXT("cw=reset_load", key="sizing", dy=-8.0, size=0.7);
//   #IRC4 @PLACE(168,-43.0) => @ORIENT("R0");
//   %p_IRC4_A=(156,-43.0);
//   &cr3 @WIRE(mode="straight") {#IRC4:A %p_IRC4_A};
//   %p_IRC4_A @TEXT("cr3", size=0.8, halign="end", dy=0);
//   %p_IRC4_Y=(180,-43.0);
//   &cr4 @WIRE(mode="straight") {#IRC4:Y %p_IRC4_Y};
//   %p_IRC4_Y @TEXT("cr4", size=0.8, halign="start", dy=0);
//   %p_IRC4_VDD=(168,-37.0);
//   &DVDD @WIRE(mode="straight") {#IRC4:VDD %p_IRC4_VDD};
//   %p_IRC4_VDD @TEXT("DVDD", size=0.8, halign="start", dy=0.5);
//   %p_IRC4_VSS=(168,-49.0);
//   &VSS @WIRE(mode="straight") {#IRC4:VSS %p_IRC4_VSS};
//   %p_IRC4_VSS @TEXT("VSS", size=0.8, halign="start", dy=0.5);
//   #IRC5 @TEXT("cw=reset_load", key="sizing", dy=-8.0, size=0.7);
//   #IRC5 @PLACE(0,-69.0) => @ORIENT("R0");
//   %p_IRC5_A=(-12,-69.0);
//   &cr4 @WIRE(mode="straight") {#IRC5:A %p_IRC5_A};
//   %p_IRC5_A @TEXT("cr4", size=0.8, halign="end", dy=0);
//   %p_IRC5_Y=(12,-69.0);
//   &cv_resetwait @WIRE(mode="straight") {#IRC5:Y %p_IRC5_Y};
//   %p_IRC5_Y @TEXT("cv_resetwait", size=0.8, halign="start", dy=0);
//   %p_IRC5_VDD=(0,-63.0);
//   &DVDD @WIRE(mode="straight") {#IRC5:VDD %p_IRC5_VDD};
//   %p_IRC5_VDD @TEXT("DVDD", size=0.8, halign="start", dy=0.5);
//   %p_IRC5_VSS=(0,-75.0);
//   &VSS @WIRE(mode="straight") {#IRC5:VSS %p_IRC5_VSS};
//   %p_IRC5_VSS @TEXT("VSS", size=0.8, halign="start", dy=0.5);
//   #IRB @TEXT("wn=1200n wp=3600n drive=6", key="sizing", dy=-9.0, size=0.7);
//   #IRB @PLACE(42,-69.0) => @ORIENT("R0");
//   %p_IRB_A=(30,-68.0);
//   &cv @WIRE(mode="straight") {#IRB:A %p_IRB_A};
//   %p_IRB_A @TEXT("cv", size=0.8, halign="end", dy=0);
//   %p_IRB_B=(30,-70.0);
//   &cv_resetwait @WIRE(mode="straight") {#IRB:B %p_IRB_B};
//   %p_IRB_B @TEXT("cv_resetwait", size=0.8, halign="end", dy=0);
//   %p_IRB_Y=(54,-69.0);
//   &reset @WIRE(mode="straight") {#IRB:Y %p_IRB_Y};
//   %p_IRB_Y @TEXT("reset", size=0.8, halign="start", dy=0);
//   %p_IRB_VDD=(42,-62.0);
//   &DVDD @WIRE(mode="straight") {#IRB:VDD %p_IRB_VDD};
//   %p_IRB_VDD @TEXT("DVDD", size=0.8, halign="start", dy=0.5);
//   %p_IRB_VSS=(42,-76.0);
//   &VSS @WIRE(mode="straight") {#IRB:VSS %p_IRB_VSS};
//   %p_IRB_VSS @TEXT("VSS", size=0.8, halign="start", dy=0.5);
//   #IST0 @TEXT("cw=start_load", key="sizing", dy=-8.0, size=0.7);
//   #IST0 @PLACE(84,-69.0) => @ORIENT("R0");
//   %p_IST0_A=(72,-69.0);
//   &cv @WIRE(mode="straight") {#IST0:A %p_IST0_A};
//   %p_IST0_A @TEXT("cv", size=0.8, halign="end", dy=0);
//   %p_IST0_Y=(96,-69.0);
//   &st0 @WIRE(mode="straight") {#IST0:Y %p_IST0_Y};
//   %p_IST0_Y @TEXT("st0", size=0.8, halign="start", dy=0);
//   %p_IST0_VDD=(84,-63.0);
//   &DVDD @WIRE(mode="straight") {#IST0:VDD %p_IST0_VDD};
//   %p_IST0_VDD @TEXT("DVDD", size=0.8, halign="start", dy=0.5);
//   %p_IST0_VSS=(84,-75.0);
//   &VSS @WIRE(mode="straight") {#IST0:VSS %p_IST0_VSS};
//   %p_IST0_VSS @TEXT("VSS", size=0.8, halign="start", dy=0.5);
//   #IST1 @TEXT("cw=start_load", key="sizing", dy=-8.0, size=0.7);
//   #IST1 @PLACE(126,-69.0) => @ORIENT("R0");
//   %p_IST1_A=(114,-69.0);
//   &st0 @WIRE(mode="straight") {#IST1:A %p_IST1_A};
//   %p_IST1_A @TEXT("st0", size=0.8, halign="end", dy=0);
//   %p_IST1_Y=(138,-69.0);
//   &start @WIRE(mode="straight") {#IST1:Y %p_IST1_Y};
//   %p_IST1_Y @TEXT("start", size=0.8, halign="start", dy=0);
//   %p_IST1_VDD=(126,-63.0);
//   &DVDD @WIRE(mode="straight") {#IST1:VDD %p_IST1_VDD};
//   %p_IST1_VDD @TEXT("DVDD", size=0.8, halign="start", dy=0.5);
//   %p_IST1_VSS=(126,-75.0);
//   &VSS @WIRE(mode="straight") {#IST1:VSS %p_IST1_VSS};
//   %p_IST1_VSS @TEXT("VSS", size=0.8, halign="start", dy=0.5);
//   #IS1 @TEXT("cw=wait_fast", key="sizing", dy=-14.0, size=0.7);
//   #IS1 @PLACE(168,-69.0) => @ORIENT("R0");
//   %p_IS1_PREV=(156,-63.0);
//   &start @WIRE(mode="straight") {#IS1:PREV %p_IS1_PREV};
//   %p_IS1_PREV @TEXT("start", size=0.8, halign="end", dy=0);
//   %p_IS1_CV=(156,-65.0);
//   &cv @WIRE(mode="straight") {#IS1:CV %p_IS1_CV};
//   %p_IS1_CV @TEXT("cv", size=0.8, halign="end", dy=0);
//   %p_IS1_CVB=(156,-67.0);
//   &cvb @WIRE(mode="straight") {#IS1:CVB %p_IS1_CVB};
//   %p_IS1_CVB @TEXT("cvb", size=0.8, halign="end", dy=0);
//   %p_IS1_RESET=(156,-69.0);
//   &reset @WIRE(mode="straight") {#IS1:RESET %p_IS1_RESET};
//   %p_IS1_RESET @TEXT("reset", size=0.8, halign="end", dy=0);
//   %p_IS1_P=(156,-71.0);
//   &pi @WIRE(mode="straight") {#IS1:P %p_IS1_P};
//   %p_IS1_P @TEXT("pi", size=0.8, halign="end", dy=0);
//   %p_IS1_N=(156,-73.0);
//   &ni @WIRE(mode="straight") {#IS1:N %p_IS1_N};
//   %p_IS1_N @TEXT("ni", size=0.8, halign="end", dy=0);
//   %p_IS1_FORCE=(156,-75.0);
//   &force @WIRE(mode="straight") {#IS1:FORCE %p_IS1_FORCE};
//   %p_IS1_FORCE @TEXT("force", size=0.8, halign="end", dy=0);
//   %p_IS1_CK=(180,-63.0);
//   &CLKC @WIRE(mode="straight") {#IS1:CK %p_IS1_CK};
//   %p_IS1_CK @TEXT("CLKC", size=0.8, halign="start", dy=0);
//   %p_IS1_REQ=(180,-65.0);
//   &req1 @WIRE(mode="straight") {#IS1:REQ %p_IS1_REQ};
//   %p_IS1_REQ @TEXT("req1", size=0.8, halign="start", dy=0);
//   %p_IS1_NEXT=(180,-67.0);
//   &next1 @WIRE(mode="straight") {#IS1:NEXT %p_IS1_NEXT};
//   %p_IS1_NEXT @TEXT("next1", size=0.8, halign="start", dy=0);
//   %p_IS1_BIT=(180,-69.0);
//   &raw13 @WIRE(mode="straight") {#IS1:BIT %p_IS1_BIT};
//   %p_IS1_BIT @TEXT("raw13", size=0.8, halign="start", dy=0);
//   %p_IS1_UP=(180,-71.0);
//   &UP12 @WIRE(mode="straight") {#IS1:UP %p_IS1_UP};
//   %p_IS1_UP @TEXT("UP12", size=0.8, halign="start", dy=0);
//   %p_IS1_DN=(180,-73.0);
//   &DN12 @WIRE(mode="straight") {#IS1:DN %p_IS1_DN};
//   %p_IS1_DN @TEXT("DN12", size=0.8, halign="start", dy=0);
//   %p_IS1_DONE=(180,-75.0);
//   &done1 @WIRE(mode="straight") {#IS1:DONE %p_IS1_DONE};
//   %p_IS1_DONE @TEXT("done1", size=0.8, halign="start", dy=0);
//   %p_IS1_VDD=(168,-57.0);
//   &DVDD @WIRE(mode="straight") {#IS1:VDD %p_IS1_VDD};
//   %p_IS1_VDD @TEXT("DVDD", size=0.8, halign="start", dy=0.5);
//   %p_IS1_VSS=(168,-81.0);
//   &VSS @WIRE(mode="straight") {#IS1:VSS %p_IS1_VSS};
//   %p_IS1_VSS @TEXT("VSS", size=0.8, halign="start", dy=0.5);
//   #IS2 @TEXT("cw=wait_fast", key="sizing", dy=-14.0, size=0.7);
//   #IS2 @PLACE(0,-101.0) => @ORIENT("R0");
//   %p_IS2_PREV=(-12,-95.0);
//   &next1 @WIRE(mode="straight") {#IS2:PREV %p_IS2_PREV};
//   %p_IS2_PREV @TEXT("next1", size=0.8, halign="end", dy=0);
//   %p_IS2_CV=(-12,-97.0);
//   &cv @WIRE(mode="straight") {#IS2:CV %p_IS2_CV};
//   %p_IS2_CV @TEXT("cv", size=0.8, halign="end", dy=0);
//   %p_IS2_CVB=(-12,-99.0);
//   &cvb @WIRE(mode="straight") {#IS2:CVB %p_IS2_CVB};
//   %p_IS2_CVB @TEXT("cvb", size=0.8, halign="end", dy=0);
//   %p_IS2_RESET=(-12,-101.0);
//   &reset @WIRE(mode="straight") {#IS2:RESET %p_IS2_RESET};
//   %p_IS2_RESET @TEXT("reset", size=0.8, halign="end", dy=0);
//   %p_IS2_P=(-12,-103.0);
//   &pi @WIRE(mode="straight") {#IS2:P %p_IS2_P};
//   %p_IS2_P @TEXT("pi", size=0.8, halign="end", dy=0);
//   %p_IS2_N=(-12,-105.0);
//   &ni @WIRE(mode="straight") {#IS2:N %p_IS2_N};
//   %p_IS2_N @TEXT("ni", size=0.8, halign="end", dy=0);
//   %p_IS2_FORCE=(-12,-107.0);
//   &force @WIRE(mode="straight") {#IS2:FORCE %p_IS2_FORCE};
//   %p_IS2_FORCE @TEXT("force", size=0.8, halign="end", dy=0);
//   %p_IS2_CK=(12,-95.0);
//   &CLKC @WIRE(mode="straight") {#IS2:CK %p_IS2_CK};
//   %p_IS2_CK @TEXT("CLKC", size=0.8, halign="start", dy=0);
//   %p_IS2_REQ=(12,-97.0);
//   &req2 @WIRE(mode="straight") {#IS2:REQ %p_IS2_REQ};
//   %p_IS2_REQ @TEXT("req2", size=0.8, halign="start", dy=0);
//   %p_IS2_NEXT=(12,-99.0);
//   &next2 @WIRE(mode="straight") {#IS2:NEXT %p_IS2_NEXT};
//   %p_IS2_NEXT @TEXT("next2", size=0.8, halign="start", dy=0);
//   %p_IS2_BIT=(12,-101.0);
//   &raw12 @WIRE(mode="straight") {#IS2:BIT %p_IS2_BIT};
//   %p_IS2_BIT @TEXT("raw12", size=0.8, halign="start", dy=0);
//   %p_IS2_UP=(12,-103.0);
//   &UP11 @WIRE(mode="straight") {#IS2:UP %p_IS2_UP};
//   %p_IS2_UP @TEXT("UP11", size=0.8, halign="start", dy=0);
//   %p_IS2_DN=(12,-105.0);
//   &DN11 @WIRE(mode="straight") {#IS2:DN %p_IS2_DN};
//   %p_IS2_DN @TEXT("DN11", size=0.8, halign="start", dy=0);
//   %p_IS2_DONE=(12,-107.0);
//   &done2 @WIRE(mode="straight") {#IS2:DONE %p_IS2_DONE};
//   %p_IS2_DONE @TEXT("done2", size=0.8, halign="start", dy=0);
//   %p_IS2_VDD=(0,-89.0);
//   &DVDD @WIRE(mode="straight") {#IS2:VDD %p_IS2_VDD};
//   %p_IS2_VDD @TEXT("DVDD", size=0.8, halign="start", dy=0.5);
//   %p_IS2_VSS=(0,-113.0);
//   &VSS @WIRE(mode="straight") {#IS2:VSS %p_IS2_VSS};
//   %p_IS2_VSS @TEXT("VSS", size=0.8, halign="start", dy=0.5);
//   #IS3 @TEXT("cw=wait_fast+extra3", key="sizing", dy=-14.0, size=0.7);
//   #IS3 @PLACE(42,-101.0) => @ORIENT("R0");
//   %p_IS3_PREV=(30,-95.0);
//   &next2 @WIRE(mode="straight") {#IS3:PREV %p_IS3_PREV};
//   %p_IS3_PREV @TEXT("next2", size=0.8, halign="end", dy=0);
//   %p_IS3_CV=(30,-97.0);
//   &cv @WIRE(mode="straight") {#IS3:CV %p_IS3_CV};
//   %p_IS3_CV @TEXT("cv", size=0.8, halign="end", dy=0);
//   %p_IS3_CVB=(30,-99.0);
//   &cvb @WIRE(mode="straight") {#IS3:CVB %p_IS3_CVB};
//   %p_IS3_CVB @TEXT("cvb", size=0.8, halign="end", dy=0);
//   %p_IS3_RESET=(30,-101.0);
//   &reset @WIRE(mode="straight") {#IS3:RESET %p_IS3_RESET};
//   %p_IS3_RESET @TEXT("reset", size=0.8, halign="end", dy=0);
//   %p_IS3_P=(30,-103.0);
//   &pi @WIRE(mode="straight") {#IS3:P %p_IS3_P};
//   %p_IS3_P @TEXT("pi", size=0.8, halign="end", dy=0);
//   %p_IS3_N=(30,-105.0);
//   &ni @WIRE(mode="straight") {#IS3:N %p_IS3_N};
//   %p_IS3_N @TEXT("ni", size=0.8, halign="end", dy=0);
//   %p_IS3_FORCE=(30,-107.0);
//   &force @WIRE(mode="straight") {#IS3:FORCE %p_IS3_FORCE};
//   %p_IS3_FORCE @TEXT("force", size=0.8, halign="end", dy=0);
//   %p_IS3_CK=(54,-95.0);
//   &CLKC @WIRE(mode="straight") {#IS3:CK %p_IS3_CK};
//   %p_IS3_CK @TEXT("CLKC", size=0.8, halign="start", dy=0);
//   %p_IS3_REQ=(54,-97.0);
//   &req3 @WIRE(mode="straight") {#IS3:REQ %p_IS3_REQ};
//   %p_IS3_REQ @TEXT("req3", size=0.8, halign="start", dy=0);
//   %p_IS3_NEXT=(54,-99.0);
//   &next3 @WIRE(mode="straight") {#IS3:NEXT %p_IS3_NEXT};
//   %p_IS3_NEXT @TEXT("next3", size=0.8, halign="start", dy=0);
//   %p_IS3_BIT=(54,-101.0);
//   &raw11 @WIRE(mode="straight") {#IS3:BIT %p_IS3_BIT};
//   %p_IS3_BIT @TEXT("raw11", size=0.8, halign="start", dy=0);
//   %p_IS3_UP=(54,-103.0);
//   &UP10 @WIRE(mode="straight") {#IS3:UP %p_IS3_UP};
//   %p_IS3_UP @TEXT("UP10", size=0.8, halign="start", dy=0);
//   %p_IS3_DN=(54,-105.0);
//   &DN10 @WIRE(mode="straight") {#IS3:DN %p_IS3_DN};
//   %p_IS3_DN @TEXT("DN10", size=0.8, halign="start", dy=0);
//   %p_IS3_DONE=(54,-107.0);
//   &done3 @WIRE(mode="straight") {#IS3:DONE %p_IS3_DONE};
//   %p_IS3_DONE @TEXT("done3", size=0.8, halign="start", dy=0);
//   %p_IS3_VDD=(42,-89.0);
//   &DVDD @WIRE(mode="straight") {#IS3:VDD %p_IS3_VDD};
//   %p_IS3_VDD @TEXT("DVDD", size=0.8, halign="start", dy=0.5);
//   %p_IS3_VSS=(42,-113.0);
//   &VSS @WIRE(mode="straight") {#IS3:VSS %p_IS3_VSS};
//   %p_IS3_VSS @TEXT("VSS", size=0.8, halign="start", dy=0.5);
//   #IS4 @TEXT("cw=wait_fast+extra456", key="sizing", dy=-14.0, size=0.7);
//   #IS4 @PLACE(84,-101.0) => @ORIENT("R0");
//   %p_IS4_PREV=(72,-95.0);
//   &next3 @WIRE(mode="straight") {#IS4:PREV %p_IS4_PREV};
//   %p_IS4_PREV @TEXT("next3", size=0.8, halign="end", dy=0);
//   %p_IS4_CV=(72,-97.0);
//   &cv @WIRE(mode="straight") {#IS4:CV %p_IS4_CV};
//   %p_IS4_CV @TEXT("cv", size=0.8, halign="end", dy=0);
//   %p_IS4_CVB=(72,-99.0);
//   &cvb @WIRE(mode="straight") {#IS4:CVB %p_IS4_CVB};
//   %p_IS4_CVB @TEXT("cvb", size=0.8, halign="end", dy=0);
//   %p_IS4_RESET=(72,-101.0);
//   &reset @WIRE(mode="straight") {#IS4:RESET %p_IS4_RESET};
//   %p_IS4_RESET @TEXT("reset", size=0.8, halign="end", dy=0);
//   %p_IS4_P=(72,-103.0);
//   &pi @WIRE(mode="straight") {#IS4:P %p_IS4_P};
//   %p_IS4_P @TEXT("pi", size=0.8, halign="end", dy=0);
//   %p_IS4_N=(72,-105.0);
//   &ni @WIRE(mode="straight") {#IS4:N %p_IS4_N};
//   %p_IS4_N @TEXT("ni", size=0.8, halign="end", dy=0);
//   %p_IS4_FORCE=(72,-107.0);
//   &force @WIRE(mode="straight") {#IS4:FORCE %p_IS4_FORCE};
//   %p_IS4_FORCE @TEXT("force", size=0.8, halign="end", dy=0);
//   %p_IS4_CK=(96,-95.0);
//   &CLKC @WIRE(mode="straight") {#IS4:CK %p_IS4_CK};
//   %p_IS4_CK @TEXT("CLKC", size=0.8, halign="start", dy=0);
//   %p_IS4_REQ=(96,-97.0);
//   &req4 @WIRE(mode="straight") {#IS4:REQ %p_IS4_REQ};
//   %p_IS4_REQ @TEXT("req4", size=0.8, halign="start", dy=0);
//   %p_IS4_NEXT=(96,-99.0);
//   &next4 @WIRE(mode="straight") {#IS4:NEXT %p_IS4_NEXT};
//   %p_IS4_NEXT @TEXT("next4", size=0.8, halign="start", dy=0);
//   %p_IS4_BIT=(96,-101.0);
//   &raw10 @WIRE(mode="straight") {#IS4:BIT %p_IS4_BIT};
//   %p_IS4_BIT @TEXT("raw10", size=0.8, halign="start", dy=0);
//   %p_IS4_UP=(96,-103.0);
//   &UP9 @WIRE(mode="straight") {#IS4:UP %p_IS4_UP};
//   %p_IS4_UP @TEXT("UP9", size=0.8, halign="start", dy=0);
//   %p_IS4_DN=(96,-105.0);
//   &DN9 @WIRE(mode="straight") {#IS4:DN %p_IS4_DN};
//   %p_IS4_DN @TEXT("DN9", size=0.8, halign="start", dy=0);
//   %p_IS4_DONE=(96,-107.0);
//   &done4 @WIRE(mode="straight") {#IS4:DONE %p_IS4_DONE};
//   %p_IS4_DONE @TEXT("done4", size=0.8, halign="start", dy=0);
//   %p_IS4_VDD=(84,-89.0);
//   &DVDD @WIRE(mode="straight") {#IS4:VDD %p_IS4_VDD};
//   %p_IS4_VDD @TEXT("DVDD", size=0.8, halign="start", dy=0.5);
//   %p_IS4_VSS=(84,-113.0);
//   &VSS @WIRE(mode="straight") {#IS4:VSS %p_IS4_VSS};
//   %p_IS4_VSS @TEXT("VSS", size=0.8, halign="start", dy=0.5);
//   #IS5 @TEXT("cw=wait_fast+extra456", key="sizing", dy=-14.0, size=0.7);
//   #IS5 @PLACE(126,-101.0) => @ORIENT("R0");
//   %p_IS5_PREV=(114,-95.0);
//   &next4 @WIRE(mode="straight") {#IS5:PREV %p_IS5_PREV};
//   %p_IS5_PREV @TEXT("next4", size=0.8, halign="end", dy=0);
//   %p_IS5_CV=(114,-97.0);
//   &cv @WIRE(mode="straight") {#IS5:CV %p_IS5_CV};
//   %p_IS5_CV @TEXT("cv", size=0.8, halign="end", dy=0);
//   %p_IS5_CVB=(114,-99.0);
//   &cvb @WIRE(mode="straight") {#IS5:CVB %p_IS5_CVB};
//   %p_IS5_CVB @TEXT("cvb", size=0.8, halign="end", dy=0);
//   %p_IS5_RESET=(114,-101.0);
//   &reset @WIRE(mode="straight") {#IS5:RESET %p_IS5_RESET};
//   %p_IS5_RESET @TEXT("reset", size=0.8, halign="end", dy=0);
//   %p_IS5_P=(114,-103.0);
//   &pi @WIRE(mode="straight") {#IS5:P %p_IS5_P};
//   %p_IS5_P @TEXT("pi", size=0.8, halign="end", dy=0);
//   %p_IS5_N=(114,-105.0);
//   &ni @WIRE(mode="straight") {#IS5:N %p_IS5_N};
//   %p_IS5_N @TEXT("ni", size=0.8, halign="end", dy=0);
//   %p_IS5_FORCE=(114,-107.0);
//   &force @WIRE(mode="straight") {#IS5:FORCE %p_IS5_FORCE};
//   %p_IS5_FORCE @TEXT("force", size=0.8, halign="end", dy=0);
//   %p_IS5_CK=(138,-95.0);
//   &CLKC @WIRE(mode="straight") {#IS5:CK %p_IS5_CK};
//   %p_IS5_CK @TEXT("CLKC", size=0.8, halign="start", dy=0);
//   %p_IS5_REQ=(138,-97.0);
//   &req5 @WIRE(mode="straight") {#IS5:REQ %p_IS5_REQ};
//   %p_IS5_REQ @TEXT("req5", size=0.8, halign="start", dy=0);
//   %p_IS5_NEXT=(138,-99.0);
//   &next5 @WIRE(mode="straight") {#IS5:NEXT %p_IS5_NEXT};
//   %p_IS5_NEXT @TEXT("next5", size=0.8, halign="start", dy=0);
//   %p_IS5_BIT=(138,-101.0);
//   &raw9 @WIRE(mode="straight") {#IS5:BIT %p_IS5_BIT};
//   %p_IS5_BIT @TEXT("raw9", size=0.8, halign="start", dy=0);
//   %p_IS5_UP=(138,-103.0);
//   &UP8 @WIRE(mode="straight") {#IS5:UP %p_IS5_UP};
//   %p_IS5_UP @TEXT("UP8", size=0.8, halign="start", dy=0);
//   %p_IS5_DN=(138,-105.0);
//   &DN8 @WIRE(mode="straight") {#IS5:DN %p_IS5_DN};
//   %p_IS5_DN @TEXT("DN8", size=0.8, halign="start", dy=0);
//   %p_IS5_DONE=(138,-107.0);
//   &done5 @WIRE(mode="straight") {#IS5:DONE %p_IS5_DONE};
//   %p_IS5_DONE @TEXT("done5", size=0.8, halign="start", dy=0);
//   %p_IS5_VDD=(126,-89.0);
//   &DVDD @WIRE(mode="straight") {#IS5:VDD %p_IS5_VDD};
//   %p_IS5_VDD @TEXT("DVDD", size=0.8, halign="start", dy=0.5);
//   %p_IS5_VSS=(126,-113.0);
//   &VSS @WIRE(mode="straight") {#IS5:VSS %p_IS5_VSS};
//   %p_IS5_VSS @TEXT("VSS", size=0.8, halign="start", dy=0.5);
//   #IS6 @TEXT("cw=wait_fast+extra456", key="sizing", dy=-14.0, size=0.7);
//   #IS6 @PLACE(168,-101.0) => @ORIENT("R0");
//   %p_IS6_PREV=(156,-95.0);
//   &next5 @WIRE(mode="straight") {#IS6:PREV %p_IS6_PREV};
//   %p_IS6_PREV @TEXT("next5", size=0.8, halign="end", dy=0);
//   %p_IS6_CV=(156,-97.0);
//   &cv @WIRE(mode="straight") {#IS6:CV %p_IS6_CV};
//   %p_IS6_CV @TEXT("cv", size=0.8, halign="end", dy=0);
//   %p_IS6_CVB=(156,-99.0);
//   &cvb @WIRE(mode="straight") {#IS6:CVB %p_IS6_CVB};
//   %p_IS6_CVB @TEXT("cvb", size=0.8, halign="end", dy=0);
//   %p_IS6_RESET=(156,-101.0);
//   &reset @WIRE(mode="straight") {#IS6:RESET %p_IS6_RESET};
//   %p_IS6_RESET @TEXT("reset", size=0.8, halign="end", dy=0);
//   %p_IS6_P=(156,-103.0);
//   &pi @WIRE(mode="straight") {#IS6:P %p_IS6_P};
//   %p_IS6_P @TEXT("pi", size=0.8, halign="end", dy=0);
//   %p_IS6_N=(156,-105.0);
//   &ni @WIRE(mode="straight") {#IS6:N %p_IS6_N};
//   %p_IS6_N @TEXT("ni", size=0.8, halign="end", dy=0);
//   %p_IS6_FORCE=(156,-107.0);
//   &force @WIRE(mode="straight") {#IS6:FORCE %p_IS6_FORCE};
//   %p_IS6_FORCE @TEXT("force", size=0.8, halign="end", dy=0);
//   %p_IS6_CK=(180,-95.0);
//   &CLKC @WIRE(mode="straight") {#IS6:CK %p_IS6_CK};
//   %p_IS6_CK @TEXT("CLKC", size=0.8, halign="start", dy=0);
//   %p_IS6_REQ=(180,-97.0);
//   &req6 @WIRE(mode="straight") {#IS6:REQ %p_IS6_REQ};
//   %p_IS6_REQ @TEXT("req6", size=0.8, halign="start", dy=0);
//   %p_IS6_NEXT=(180,-99.0);
//   &next6 @WIRE(mode="straight") {#IS6:NEXT %p_IS6_NEXT};
//   %p_IS6_NEXT @TEXT("next6", size=0.8, halign="start", dy=0);
//   %p_IS6_BIT=(180,-101.0);
//   &raw8 @WIRE(mode="straight") {#IS6:BIT %p_IS6_BIT};
//   %p_IS6_BIT @TEXT("raw8", size=0.8, halign="start", dy=0);
//   %p_IS6_UP=(180,-103.0);
//   &UP7 @WIRE(mode="straight") {#IS6:UP %p_IS6_UP};
//   %p_IS6_UP @TEXT("UP7", size=0.8, halign="start", dy=0);
//   %p_IS6_DN=(180,-105.0);
//   &DN7 @WIRE(mode="straight") {#IS6:DN %p_IS6_DN};
//   %p_IS6_DN @TEXT("DN7", size=0.8, halign="start", dy=0);
//   %p_IS6_DONE=(180,-107.0);
//   &done6 @WIRE(mode="straight") {#IS6:DONE %p_IS6_DONE};
//   %p_IS6_DONE @TEXT("done6", size=0.8, halign="start", dy=0);
//   %p_IS6_VDD=(168,-89.0);
//   &DVDD @WIRE(mode="straight") {#IS6:VDD %p_IS6_VDD};
//   %p_IS6_VDD @TEXT("DVDD", size=0.8, halign="start", dy=0.5);
//   %p_IS6_VSS=(168,-113.0);
//   &VSS @WIRE(mode="straight") {#IS6:VSS %p_IS6_VSS};
//   %p_IS6_VSS @TEXT("VSS", size=0.8, halign="start", dy=0.5);
//   #IS7 @TEXT("cw=wait_slow", key="sizing", dy=-14.0, size=0.7);
//   #IS7 @PLACE(0,-133.0) => @ORIENT("R0");
//   %p_IS7_PREV=(-12,-127.0);
//   &next6 @WIRE(mode="straight") {#IS7:PREV %p_IS7_PREV};
//   %p_IS7_PREV @TEXT("next6", size=0.8, halign="end", dy=0);
//   %p_IS7_CV=(-12,-129.0);
//   &cv @WIRE(mode="straight") {#IS7:CV %p_IS7_CV};
//   %p_IS7_CV @TEXT("cv", size=0.8, halign="end", dy=0);
//   %p_IS7_CVB=(-12,-131.0);
//   &cvb @WIRE(mode="straight") {#IS7:CVB %p_IS7_CVB};
//   %p_IS7_CVB @TEXT("cvb", size=0.8, halign="end", dy=0);
//   %p_IS7_RESET=(-12,-133.0);
//   &reset @WIRE(mode="straight") {#IS7:RESET %p_IS7_RESET};
//   %p_IS7_RESET @TEXT("reset", size=0.8, halign="end", dy=0);
//   %p_IS7_P=(-12,-135.0);
//   &pi @WIRE(mode="straight") {#IS7:P %p_IS7_P};
//   %p_IS7_P @TEXT("pi", size=0.8, halign="end", dy=0);
//   %p_IS7_N=(-12,-137.0);
//   &ni @WIRE(mode="straight") {#IS7:N %p_IS7_N};
//   %p_IS7_N @TEXT("ni", size=0.8, halign="end", dy=0);
//   %p_IS7_FORCE=(-12,-139.0);
//   &force @WIRE(mode="straight") {#IS7:FORCE %p_IS7_FORCE};
//   %p_IS7_FORCE @TEXT("force", size=0.8, halign="end", dy=0);
//   %p_IS7_CK=(12,-127.0);
//   &CLKC @WIRE(mode="straight") {#IS7:CK %p_IS7_CK};
//   %p_IS7_CK @TEXT("CLKC", size=0.8, halign="start", dy=0);
//   %p_IS7_REQ=(12,-129.0);
//   &req7 @WIRE(mode="straight") {#IS7:REQ %p_IS7_REQ};
//   %p_IS7_REQ @TEXT("req7", size=0.8, halign="start", dy=0);
//   %p_IS7_NEXT=(12,-131.0);
//   &next7 @WIRE(mode="straight") {#IS7:NEXT %p_IS7_NEXT};
//   %p_IS7_NEXT @TEXT("next7", size=0.8, halign="start", dy=0);
//   %p_IS7_BIT=(12,-133.0);
//   &raw7 @WIRE(mode="straight") {#IS7:BIT %p_IS7_BIT};
//   %p_IS7_BIT @TEXT("raw7", size=0.8, halign="start", dy=0);
//   %p_IS7_UP=(12,-135.0);
//   &UP6 @WIRE(mode="straight") {#IS7:UP %p_IS7_UP};
//   %p_IS7_UP @TEXT("UP6", size=0.8, halign="start", dy=0);
//   %p_IS7_DN=(12,-137.0);
//   &DN6 @WIRE(mode="straight") {#IS7:DN %p_IS7_DN};
//   %p_IS7_DN @TEXT("DN6", size=0.8, halign="start", dy=0);
//   %p_IS7_DONE=(12,-139.0);
//   &done7 @WIRE(mode="straight") {#IS7:DONE %p_IS7_DONE};
//   %p_IS7_DONE @TEXT("done7", size=0.8, halign="start", dy=0);
//   %p_IS7_VDD=(0,-121.0);
//   &DVDD @WIRE(mode="straight") {#IS7:VDD %p_IS7_VDD};
//   %p_IS7_VDD @TEXT("DVDD", size=0.8, halign="start", dy=0.5);
//   %p_IS7_VSS=(0,-145.0);
//   &VSS @WIRE(mode="straight") {#IS7:VSS %p_IS7_VSS};
//   %p_IS7_VSS @TEXT("VSS", size=0.8, halign="start", dy=0.5);
//   #IS8 @TEXT("cw=wait_slow", key="sizing", dy=-14.0, size=0.7);
//   #IS8 @PLACE(42,-133.0) => @ORIENT("R0");
//   %p_IS8_PREV=(30,-127.0);
//   &next7 @WIRE(mode="straight") {#IS8:PREV %p_IS8_PREV};
//   %p_IS8_PREV @TEXT("next7", size=0.8, halign="end", dy=0);
//   %p_IS8_CV=(30,-129.0);
//   &cv @WIRE(mode="straight") {#IS8:CV %p_IS8_CV};
//   %p_IS8_CV @TEXT("cv", size=0.8, halign="end", dy=0);
//   %p_IS8_CVB=(30,-131.0);
//   &cvb @WIRE(mode="straight") {#IS8:CVB %p_IS8_CVB};
//   %p_IS8_CVB @TEXT("cvb", size=0.8, halign="end", dy=0);
//   %p_IS8_RESET=(30,-133.0);
//   &reset @WIRE(mode="straight") {#IS8:RESET %p_IS8_RESET};
//   %p_IS8_RESET @TEXT("reset", size=0.8, halign="end", dy=0);
//   %p_IS8_P=(30,-135.0);
//   &pi @WIRE(mode="straight") {#IS8:P %p_IS8_P};
//   %p_IS8_P @TEXT("pi", size=0.8, halign="end", dy=0);
//   %p_IS8_N=(30,-137.0);
//   &ni @WIRE(mode="straight") {#IS8:N %p_IS8_N};
//   %p_IS8_N @TEXT("ni", size=0.8, halign="end", dy=0);
//   %p_IS8_FORCE=(30,-139.0);
//   &force @WIRE(mode="straight") {#IS8:FORCE %p_IS8_FORCE};
//   %p_IS8_FORCE @TEXT("force", size=0.8, halign="end", dy=0);
//   %p_IS8_CK=(54,-127.0);
//   &CLKC @WIRE(mode="straight") {#IS8:CK %p_IS8_CK};
//   %p_IS8_CK @TEXT("CLKC", size=0.8, halign="start", dy=0);
//   %p_IS8_REQ=(54,-129.0);
//   &req8 @WIRE(mode="straight") {#IS8:REQ %p_IS8_REQ};
//   %p_IS8_REQ @TEXT("req8", size=0.8, halign="start", dy=0);
//   %p_IS8_NEXT=(54,-131.0);
//   &next8 @WIRE(mode="straight") {#IS8:NEXT %p_IS8_NEXT};
//   %p_IS8_NEXT @TEXT("next8", size=0.8, halign="start", dy=0);
//   %p_IS8_BIT=(54,-133.0);
//   &raw6 @WIRE(mode="straight") {#IS8:BIT %p_IS8_BIT};
//   %p_IS8_BIT @TEXT("raw6", size=0.8, halign="start", dy=0);
//   %p_IS8_UP=(54,-135.0);
//   &UP5 @WIRE(mode="straight") {#IS8:UP %p_IS8_UP};
//   %p_IS8_UP @TEXT("UP5", size=0.8, halign="start", dy=0);
//   %p_IS8_DN=(54,-137.0);
//   &DN5 @WIRE(mode="straight") {#IS8:DN %p_IS8_DN};
//   %p_IS8_DN @TEXT("DN5", size=0.8, halign="start", dy=0);
//   %p_IS8_DONE=(54,-139.0);
//   &done8 @WIRE(mode="straight") {#IS8:DONE %p_IS8_DONE};
//   %p_IS8_DONE @TEXT("done8", size=0.8, halign="start", dy=0);
//   %p_IS8_VDD=(42,-121.0);
//   &DVDD @WIRE(mode="straight") {#IS8:VDD %p_IS8_VDD};
//   %p_IS8_VDD @TEXT("DVDD", size=0.8, halign="start", dy=0.5);
//   %p_IS8_VSS=(42,-145.0);
//   &VSS @WIRE(mode="straight") {#IS8:VSS %p_IS8_VSS};
//   %p_IS8_VSS @TEXT("VSS", size=0.8, halign="start", dy=0.5);
//   #IS9 @TEXT("cw=wait_slow+extra9", key="sizing", dy=-14.0, size=0.7);
//   #IS9 @PLACE(84,-133.0) => @ORIENT("R0");
//   %p_IS9_PREV=(72,-127.0);
//   &next8 @WIRE(mode="straight") {#IS9:PREV %p_IS9_PREV};
//   %p_IS9_PREV @TEXT("next8", size=0.8, halign="end", dy=0);
//   %p_IS9_CV=(72,-129.0);
//   &cv @WIRE(mode="straight") {#IS9:CV %p_IS9_CV};
//   %p_IS9_CV @TEXT("cv", size=0.8, halign="end", dy=0);
//   %p_IS9_CVB=(72,-131.0);
//   &cvb @WIRE(mode="straight") {#IS9:CVB %p_IS9_CVB};
//   %p_IS9_CVB @TEXT("cvb", size=0.8, halign="end", dy=0);
//   %p_IS9_RESET=(72,-133.0);
//   &reset @WIRE(mode="straight") {#IS9:RESET %p_IS9_RESET};
//   %p_IS9_RESET @TEXT("reset", size=0.8, halign="end", dy=0);
//   %p_IS9_P=(72,-135.0);
//   &pi @WIRE(mode="straight") {#IS9:P %p_IS9_P};
//   %p_IS9_P @TEXT("pi", size=0.8, halign="end", dy=0);
//   %p_IS9_N=(72,-137.0);
//   &ni @WIRE(mode="straight") {#IS9:N %p_IS9_N};
//   %p_IS9_N @TEXT("ni", size=0.8, halign="end", dy=0);
//   %p_IS9_FORCE=(72,-139.0);
//   &force @WIRE(mode="straight") {#IS9:FORCE %p_IS9_FORCE};
//   %p_IS9_FORCE @TEXT("force", size=0.8, halign="end", dy=0);
//   %p_IS9_CK=(96,-127.0);
//   &CLKC @WIRE(mode="straight") {#IS9:CK %p_IS9_CK};
//   %p_IS9_CK @TEXT("CLKC", size=0.8, halign="start", dy=0);
//   %p_IS9_REQ=(96,-129.0);
//   &req9 @WIRE(mode="straight") {#IS9:REQ %p_IS9_REQ};
//   %p_IS9_REQ @TEXT("req9", size=0.8, halign="start", dy=0);
//   %p_IS9_NEXT=(96,-131.0);
//   &next9 @WIRE(mode="straight") {#IS9:NEXT %p_IS9_NEXT};
//   %p_IS9_NEXT @TEXT("next9", size=0.8, halign="start", dy=0);
//   %p_IS9_BIT=(96,-133.0);
//   &raw5 @WIRE(mode="straight") {#IS9:BIT %p_IS9_BIT};
//   %p_IS9_BIT @TEXT("raw5", size=0.8, halign="start", dy=0);
//   %p_IS9_UP=(96,-135.0);
//   &UP4 @WIRE(mode="straight") {#IS9:UP %p_IS9_UP};
//   %p_IS9_UP @TEXT("UP4", size=0.8, halign="start", dy=0);
//   %p_IS9_DN=(96,-137.0);
//   &DN4 @WIRE(mode="straight") {#IS9:DN %p_IS9_DN};
//   %p_IS9_DN @TEXT("DN4", size=0.8, halign="start", dy=0);
//   %p_IS9_DONE=(96,-139.0);
//   &done9 @WIRE(mode="straight") {#IS9:DONE %p_IS9_DONE};
//   %p_IS9_DONE @TEXT("done9", size=0.8, halign="start", dy=0);
//   %p_IS9_VDD=(84,-121.0);
//   &DVDD @WIRE(mode="straight") {#IS9:VDD %p_IS9_VDD};
//   %p_IS9_VDD @TEXT("DVDD", size=0.8, halign="start", dy=0.5);
//   %p_IS9_VSS=(84,-145.0);
//   &VSS @WIRE(mode="straight") {#IS9:VSS %p_IS9_VSS};
//   %p_IS9_VSS @TEXT("VSS", size=0.8, halign="start", dy=0.5);
//   #IS10 @TEXT("cw=wait_slow", key="sizing", dy=-14.0, size=0.7);
//   #IS10 @PLACE(126,-133.0) => @ORIENT("R0");
//   %p_IS10_PREV=(114,-127.0);
//   &next9 @WIRE(mode="straight") {#IS10:PREV %p_IS10_PREV};
//   %p_IS10_PREV @TEXT("next9", size=0.8, halign="end", dy=0);
//   %p_IS10_CV=(114,-129.0);
//   &cv @WIRE(mode="straight") {#IS10:CV %p_IS10_CV};
//   %p_IS10_CV @TEXT("cv", size=0.8, halign="end", dy=0);
//   %p_IS10_CVB=(114,-131.0);
//   &cvb @WIRE(mode="straight") {#IS10:CVB %p_IS10_CVB};
//   %p_IS10_CVB @TEXT("cvb", size=0.8, halign="end", dy=0);
//   %p_IS10_RESET=(114,-133.0);
//   &reset @WIRE(mode="straight") {#IS10:RESET %p_IS10_RESET};
//   %p_IS10_RESET @TEXT("reset", size=0.8, halign="end", dy=0);
//   %p_IS10_P=(114,-135.0);
//   &pi @WIRE(mode="straight") {#IS10:P %p_IS10_P};
//   %p_IS10_P @TEXT("pi", size=0.8, halign="end", dy=0);
//   %p_IS10_N=(114,-137.0);
//   &ni @WIRE(mode="straight") {#IS10:N %p_IS10_N};
//   %p_IS10_N @TEXT("ni", size=0.8, halign="end", dy=0);
//   %p_IS10_FORCE=(114,-139.0);
//   &force @WIRE(mode="straight") {#IS10:FORCE %p_IS10_FORCE};
//   %p_IS10_FORCE @TEXT("force", size=0.8, halign="end", dy=0);
//   %p_IS10_CK=(138,-127.0);
//   &CLKC @WIRE(mode="straight") {#IS10:CK %p_IS10_CK};
//   %p_IS10_CK @TEXT("CLKC", size=0.8, halign="start", dy=0);
//   %p_IS10_REQ=(138,-129.0);
//   &req10 @WIRE(mode="straight") {#IS10:REQ %p_IS10_REQ};
//   %p_IS10_REQ @TEXT("req10", size=0.8, halign="start", dy=0);
//   %p_IS10_NEXT=(138,-131.0);
//   &next10 @WIRE(mode="straight") {#IS10:NEXT %p_IS10_NEXT};
//   %p_IS10_NEXT @TEXT("next10", size=0.8, halign="start", dy=0);
//   %p_IS10_BIT=(138,-133.0);
//   &raw4 @WIRE(mode="straight") {#IS10:BIT %p_IS10_BIT};
//   %p_IS10_BIT @TEXT("raw4", size=0.8, halign="start", dy=0);
//   %p_IS10_UP=(138,-135.0);
//   &UP3 @WIRE(mode="straight") {#IS10:UP %p_IS10_UP};
//   %p_IS10_UP @TEXT("UP3", size=0.8, halign="start", dy=0);
//   %p_IS10_DN=(138,-137.0);
//   &DN3 @WIRE(mode="straight") {#IS10:DN %p_IS10_DN};
//   %p_IS10_DN @TEXT("DN3", size=0.8, halign="start", dy=0);
//   %p_IS10_DONE=(138,-139.0);
//   &done10 @WIRE(mode="straight") {#IS10:DONE %p_IS10_DONE};
//   %p_IS10_DONE @TEXT("done10", size=0.8, halign="start", dy=0);
//   %p_IS10_VDD=(126,-121.0);
//   &DVDD @WIRE(mode="straight") {#IS10:VDD %p_IS10_VDD};
//   %p_IS10_VDD @TEXT("DVDD", size=0.8, halign="start", dy=0.5);
//   %p_IS10_VSS=(126,-145.0);
//   &VSS @WIRE(mode="straight") {#IS10:VSS %p_IS10_VSS};
//   %p_IS10_VSS @TEXT("VSS", size=0.8, halign="start", dy=0.5);
//   #IS11 @TEXT("cw=wait_slow", key="sizing", dy=-14.0, size=0.7);
//   #IS11 @PLACE(168,-133.0) => @ORIENT("R0");
//   %p_IS11_PREV=(156,-127.0);
//   &next10 @WIRE(mode="straight") {#IS11:PREV %p_IS11_PREV};
//   %p_IS11_PREV @TEXT("next10", size=0.8, halign="end", dy=0);
//   %p_IS11_CV=(156,-129.0);
//   &cv @WIRE(mode="straight") {#IS11:CV %p_IS11_CV};
//   %p_IS11_CV @TEXT("cv", size=0.8, halign="end", dy=0);
//   %p_IS11_CVB=(156,-131.0);
//   &cvb @WIRE(mode="straight") {#IS11:CVB %p_IS11_CVB};
//   %p_IS11_CVB @TEXT("cvb", size=0.8, halign="end", dy=0);
//   %p_IS11_RESET=(156,-133.0);
//   &reset @WIRE(mode="straight") {#IS11:RESET %p_IS11_RESET};
//   %p_IS11_RESET @TEXT("reset", size=0.8, halign="end", dy=0);
//   %p_IS11_P=(156,-135.0);
//   &pi @WIRE(mode="straight") {#IS11:P %p_IS11_P};
//   %p_IS11_P @TEXT("pi", size=0.8, halign="end", dy=0);
//   %p_IS11_N=(156,-137.0);
//   &ni @WIRE(mode="straight") {#IS11:N %p_IS11_N};
//   %p_IS11_N @TEXT("ni", size=0.8, halign="end", dy=0);
//   %p_IS11_FORCE=(156,-139.0);
//   &force @WIRE(mode="straight") {#IS11:FORCE %p_IS11_FORCE};
//   %p_IS11_FORCE @TEXT("force", size=0.8, halign="end", dy=0);
//   %p_IS11_CK=(180,-127.0);
//   &CLKC @WIRE(mode="straight") {#IS11:CK %p_IS11_CK};
//   %p_IS11_CK @TEXT("CLKC", size=0.8, halign="start", dy=0);
//   %p_IS11_REQ=(180,-129.0);
//   &req11 @WIRE(mode="straight") {#IS11:REQ %p_IS11_REQ};
//   %p_IS11_REQ @TEXT("req11", size=0.8, halign="start", dy=0);
//   %p_IS11_NEXT=(180,-131.0);
//   &next11 @WIRE(mode="straight") {#IS11:NEXT %p_IS11_NEXT};
//   %p_IS11_NEXT @TEXT("next11", size=0.8, halign="start", dy=0);
//   %p_IS11_BIT=(180,-133.0);
//   &raw3 @WIRE(mode="straight") {#IS11:BIT %p_IS11_BIT};
//   %p_IS11_BIT @TEXT("raw3", size=0.8, halign="start", dy=0);
//   %p_IS11_UP=(180,-135.0);
//   &UP2 @WIRE(mode="straight") {#IS11:UP %p_IS11_UP};
//   %p_IS11_UP @TEXT("UP2", size=0.8, halign="start", dy=0);
//   %p_IS11_DN=(180,-137.0);
//   &DN2 @WIRE(mode="straight") {#IS11:DN %p_IS11_DN};
//   %p_IS11_DN @TEXT("DN2", size=0.8, halign="start", dy=0);
//   %p_IS11_DONE=(180,-139.0);
//   &done11 @WIRE(mode="straight") {#IS11:DONE %p_IS11_DONE};
//   %p_IS11_DONE @TEXT("done11", size=0.8, halign="start", dy=0);
//   %p_IS11_VDD=(168,-121.0);
//   &DVDD @WIRE(mode="straight") {#IS11:VDD %p_IS11_VDD};
//   %p_IS11_VDD @TEXT("DVDD", size=0.8, halign="start", dy=0.5);
//   %p_IS11_VSS=(168,-145.0);
//   &VSS @WIRE(mode="straight") {#IS11:VSS %p_IS11_VSS};
//   %p_IS11_VSS @TEXT("VSS", size=0.8, halign="start", dy=0.5);
//   #IS12 @TEXT("cw=wait_slow", key="sizing", dy=-14.0, size=0.7);
//   #IS12 @PLACE(0,-165.0) => @ORIENT("R0");
//   %p_IS12_PREV=(-12,-159.0);
//   &next11 @WIRE(mode="straight") {#IS12:PREV %p_IS12_PREV};
//   %p_IS12_PREV @TEXT("next11", size=0.8, halign="end", dy=0);
//   %p_IS12_CV=(-12,-161.0);
//   &cv @WIRE(mode="straight") {#IS12:CV %p_IS12_CV};
//   %p_IS12_CV @TEXT("cv", size=0.8, halign="end", dy=0);
//   %p_IS12_CVB=(-12,-163.0);
//   &cvb @WIRE(mode="straight") {#IS12:CVB %p_IS12_CVB};
//   %p_IS12_CVB @TEXT("cvb", size=0.8, halign="end", dy=0);
//   %p_IS12_RESET=(-12,-165.0);
//   &reset @WIRE(mode="straight") {#IS12:RESET %p_IS12_RESET};
//   %p_IS12_RESET @TEXT("reset", size=0.8, halign="end", dy=0);
//   %p_IS12_P=(-12,-167.0);
//   &pi @WIRE(mode="straight") {#IS12:P %p_IS12_P};
//   %p_IS12_P @TEXT("pi", size=0.8, halign="end", dy=0);
//   %p_IS12_N=(-12,-169.0);
//   &ni @WIRE(mode="straight") {#IS12:N %p_IS12_N};
//   %p_IS12_N @TEXT("ni", size=0.8, halign="end", dy=0);
//   %p_IS12_FORCE=(-12,-171.0);
//   &force @WIRE(mode="straight") {#IS12:FORCE %p_IS12_FORCE};
//   %p_IS12_FORCE @TEXT("force", size=0.8, halign="end", dy=0);
//   %p_IS12_CK=(12,-159.0);
//   &CLKC @WIRE(mode="straight") {#IS12:CK %p_IS12_CK};
//   %p_IS12_CK @TEXT("CLKC", size=0.8, halign="start", dy=0);
//   %p_IS12_REQ=(12,-161.0);
//   &req12 @WIRE(mode="straight") {#IS12:REQ %p_IS12_REQ};
//   %p_IS12_REQ @TEXT("req12", size=0.8, halign="start", dy=0);
//   %p_IS12_NEXT=(12,-163.0);
//   &next12 @WIRE(mode="straight") {#IS12:NEXT %p_IS12_NEXT};
//   %p_IS12_NEXT @TEXT("next12", size=0.8, halign="start", dy=0);
//   %p_IS12_BIT=(12,-165.0);
//   &raw2 @WIRE(mode="straight") {#IS12:BIT %p_IS12_BIT};
//   %p_IS12_BIT @TEXT("raw2", size=0.8, halign="start", dy=0);
//   %p_IS12_UP=(12,-167.0);
//   &UP1 @WIRE(mode="straight") {#IS12:UP %p_IS12_UP};
//   %p_IS12_UP @TEXT("UP1", size=0.8, halign="start", dy=0);
//   %p_IS12_DN=(12,-169.0);
//   &DN1 @WIRE(mode="straight") {#IS12:DN %p_IS12_DN};
//   %p_IS12_DN @TEXT("DN1", size=0.8, halign="start", dy=0);
//   %p_IS12_DONE=(12,-171.0);
//   &done12 @WIRE(mode="straight") {#IS12:DONE %p_IS12_DONE};
//   %p_IS12_DONE @TEXT("done12", size=0.8, halign="start", dy=0);
//   %p_IS12_VDD=(0,-153.0);
//   &DVDD @WIRE(mode="straight") {#IS12:VDD %p_IS12_VDD};
//   %p_IS12_VDD @TEXT("DVDD", size=0.8, halign="start", dy=0.5);
//   %p_IS12_VSS=(0,-177.0);
//   &VSS @WIRE(mode="straight") {#IS12:VSS %p_IS12_VSS};
//   %p_IS12_VSS @TEXT("VSS", size=0.8, halign="start", dy=0.5);
//   #IS13 @TEXT("cw=wait_slow", key="sizing", dy=-14.0, size=0.7);
//   #IS13 @PLACE(42,-165.0) => @ORIENT("R0");
//   %p_IS13_PREV=(30,-159.0);
//   &next12 @WIRE(mode="straight") {#IS13:PREV %p_IS13_PREV};
//   %p_IS13_PREV @TEXT("next12", size=0.8, halign="end", dy=0);
//   %p_IS13_CV=(30,-161.0);
//   &cv @WIRE(mode="straight") {#IS13:CV %p_IS13_CV};
//   %p_IS13_CV @TEXT("cv", size=0.8, halign="end", dy=0);
//   %p_IS13_CVB=(30,-163.0);
//   &cvb @WIRE(mode="straight") {#IS13:CVB %p_IS13_CVB};
//   %p_IS13_CVB @TEXT("cvb", size=0.8, halign="end", dy=0);
//   %p_IS13_RESET=(30,-165.0);
//   &reset @WIRE(mode="straight") {#IS13:RESET %p_IS13_RESET};
//   %p_IS13_RESET @TEXT("reset", size=0.8, halign="end", dy=0);
//   %p_IS13_P=(30,-167.0);
//   &pi @WIRE(mode="straight") {#IS13:P %p_IS13_P};
//   %p_IS13_P @TEXT("pi", size=0.8, halign="end", dy=0);
//   %p_IS13_N=(30,-169.0);
//   &ni @WIRE(mode="straight") {#IS13:N %p_IS13_N};
//   %p_IS13_N @TEXT("ni", size=0.8, halign="end", dy=0);
//   %p_IS13_FORCE=(30,-171.0);
//   &force @WIRE(mode="straight") {#IS13:FORCE %p_IS13_FORCE};
//   %p_IS13_FORCE @TEXT("force", size=0.8, halign="end", dy=0);
//   %p_IS13_CK=(54,-159.0);
//   &CLKC @WIRE(mode="straight") {#IS13:CK %p_IS13_CK};
//   %p_IS13_CK @TEXT("CLKC", size=0.8, halign="start", dy=0);
//   %p_IS13_REQ=(54,-161.0);
//   &req13 @WIRE(mode="straight") {#IS13:REQ %p_IS13_REQ};
//   %p_IS13_REQ @TEXT("req13", size=0.8, halign="start", dy=0);
//   %p_IS13_NEXT=(54,-163.0);
//   &next13 @WIRE(mode="straight") {#IS13:NEXT %p_IS13_NEXT};
//   %p_IS13_NEXT @TEXT("next13", size=0.8, halign="start", dy=0);
//   %p_IS13_BIT=(54,-165.0);
//   &raw1 @WIRE(mode="straight") {#IS13:BIT %p_IS13_BIT};
//   %p_IS13_BIT @TEXT("raw1", size=0.8, halign="start", dy=0);
//   %p_IS13_UP=(54,-167.0);
//   &UP0 @WIRE(mode="straight") {#IS13:UP %p_IS13_UP};
//   %p_IS13_UP @TEXT("UP0", size=0.8, halign="start", dy=0);
//   %p_IS13_DN=(54,-169.0);
//   &DN0 @WIRE(mode="straight") {#IS13:DN %p_IS13_DN};
//   %p_IS13_DN @TEXT("DN0", size=0.8, halign="start", dy=0);
//   %p_IS13_DONE=(54,-171.0);
//   &done13 @WIRE(mode="straight") {#IS13:DONE %p_IS13_DONE};
//   %p_IS13_DONE @TEXT("done13", size=0.8, halign="start", dy=0);
//   %p_IS13_VDD=(42,-153.0);
//   &DVDD @WIRE(mode="straight") {#IS13:VDD %p_IS13_VDD};
//   %p_IS13_VDD @TEXT("DVDD", size=0.8, halign="start", dy=0.5);
//   %p_IS13_VSS=(42,-177.0);
//   &VSS @WIRE(mode="straight") {#IS13:VSS %p_IS13_VSS};
//   %p_IS13_VSS @TEXT("VSS", size=0.8, halign="start", dy=0.5);
//   #IS14 @TEXT("cw=wait_slow", key="sizing", dy=-14.0, size=0.7);
//   #IS14 @PLACE(84,-165.0) => @ORIENT("R0");
//   %p_IS14_PREV=(72,-159.0);
//   &next13 @WIRE(mode="straight") {#IS14:PREV %p_IS14_PREV};
//   %p_IS14_PREV @TEXT("next13", size=0.8, halign="end", dy=0);
//   %p_IS14_CV=(72,-161.0);
//   &cv @WIRE(mode="straight") {#IS14:CV %p_IS14_CV};
//   %p_IS14_CV @TEXT("cv", size=0.8, halign="end", dy=0);
//   %p_IS14_CVB=(72,-163.0);
//   &cvb @WIRE(mode="straight") {#IS14:CVB %p_IS14_CVB};
//   %p_IS14_CVB @TEXT("cvb", size=0.8, halign="end", dy=0);
//   %p_IS14_RESET=(72,-165.0);
//   &reset @WIRE(mode="straight") {#IS14:RESET %p_IS14_RESET};
//   %p_IS14_RESET @TEXT("reset", size=0.8, halign="end", dy=0);
//   %p_IS14_P=(72,-167.0);
//   &pi @WIRE(mode="straight") {#IS14:P %p_IS14_P};
//   %p_IS14_P @TEXT("pi", size=0.8, halign="end", dy=0);
//   %p_IS14_N=(72,-169.0);
//   &ni @WIRE(mode="straight") {#IS14:N %p_IS14_N};
//   %p_IS14_N @TEXT("ni", size=0.8, halign="end", dy=0);
//   %p_IS14_FORCE=(72,-171.0);
//   &force @WIRE(mode="straight") {#IS14:FORCE %p_IS14_FORCE};
//   %p_IS14_FORCE @TEXT("force", size=0.8, halign="end", dy=0);
//   %p_IS14_CK=(96,-159.0);
//   &CLKC @WIRE(mode="straight") {#IS14:CK %p_IS14_CK};
//   %p_IS14_CK @TEXT("CLKC", size=0.8, halign="start", dy=0);
//   %p_IS14_REQ=(96,-161.0);
//   &req14 @WIRE(mode="straight") {#IS14:REQ %p_IS14_REQ};
//   %p_IS14_REQ @TEXT("req14", size=0.8, halign="start", dy=0);
//   %p_IS14_NEXT=(96,-163.0);
//   &next14 @WIRE(mode="straight") {#IS14:NEXT %p_IS14_NEXT};
//   %p_IS14_NEXT @TEXT("next14", size=0.8, halign="start", dy=0);
//   %p_IS14_BIT=(96,-165.0);
//   &raw0 @WIRE(mode="straight") {#IS14:BIT %p_IS14_BIT};
//   %p_IS14_BIT @TEXT("raw0", size=0.8, halign="start", dy=0);
//   %p_IS14_UP=(96,-167.0);
//   &lastup @WIRE(mode="straight") {#IS14:UP %p_IS14_UP};
//   %p_IS14_UP @TEXT("lastup", size=0.8, halign="start", dy=0);
//   %p_IS14_DN=(96,-169.0);
//   &lastdn @WIRE(mode="straight") {#IS14:DN %p_IS14_DN};
//   %p_IS14_DN @TEXT("lastdn", size=0.8, halign="start", dy=0);
//   %p_IS14_DONE=(96,-171.0);
//   &done14 @WIRE(mode="straight") {#IS14:DONE %p_IS14_DONE};
//   %p_IS14_DONE @TEXT("done14", size=0.8, halign="start", dy=0);
//   %p_IS14_VDD=(84,-153.0);
//   &DVDD @WIRE(mode="straight") {#IS14:VDD %p_IS14_VDD};
//   %p_IS14_VDD @TEXT("DVDD", size=0.8, halign="start", dy=0.5);
//   %p_IS14_VSS=(84,-177.0);
//   &VSS @WIRE(mode="straight") {#IS14:VSS %p_IS14_VSS};
//   %p_IS14_VSS @TEXT("VSS", size=0.8, halign="start", dy=0.5);
//   #IR0 @TEXT("wn=800n wp=2400n", key="sizing", dy=-9.0, size=0.7);
//   #IR0 @PLACE(126,-165.0) => @ORIENT("R0");
//   %p_IR0_A=(114,-164.0);
//   &req1 @WIRE(mode="straight") {#IR0:A %p_IR0_A};
//   %p_IR0_A @TEXT("req1", size=0.8, halign="end", dy=0);
//   %p_IR0_B=(114,-166.0);
//   &req2 @WIRE(mode="straight") {#IR0:B %p_IR0_B};
//   %p_IR0_B @TEXT("req2", size=0.8, halign="end", dy=0);
//   %p_IR0_Y=(138,-165.0);
//   &rq0 @WIRE(mode="straight") {#IR0:Y %p_IR0_Y};
//   %p_IR0_Y @TEXT("rq0", size=0.8, halign="start", dy=0);
//   %p_IR0_VDD=(126,-158.0);
//   &DVDD @WIRE(mode="straight") {#IR0:VDD %p_IR0_VDD};
//   %p_IR0_VDD @TEXT("DVDD", size=0.8, halign="start", dy=0.5);
//   %p_IR0_VSS=(126,-172.0);
//   &VSS @WIRE(mode="straight") {#IR0:VSS %p_IR0_VSS};
//   %p_IR0_VSS @TEXT("VSS", size=0.8, halign="start", dy=0.5);
//   #IR1 @TEXT("wn=800n wp=2400n", key="sizing", dy=-9.0, size=0.7);
//   #IR1 @PLACE(168,-165.0) => @ORIENT("R0");
//   %p_IR1_A=(156,-164.0);
//   &req3 @WIRE(mode="straight") {#IR1:A %p_IR1_A};
//   %p_IR1_A @TEXT("req3", size=0.8, halign="end", dy=0);
//   %p_IR1_B=(156,-166.0);
//   &req4 @WIRE(mode="straight") {#IR1:B %p_IR1_B};
//   %p_IR1_B @TEXT("req4", size=0.8, halign="end", dy=0);
//   %p_IR1_Y=(180,-165.0);
//   &rq1 @WIRE(mode="straight") {#IR1:Y %p_IR1_Y};
//   %p_IR1_Y @TEXT("rq1", size=0.8, halign="start", dy=0);
//   %p_IR1_VDD=(168,-158.0);
//   &DVDD @WIRE(mode="straight") {#IR1:VDD %p_IR1_VDD};
//   %p_IR1_VDD @TEXT("DVDD", size=0.8, halign="start", dy=0.5);
//   %p_IR1_VSS=(168,-172.0);
//   &VSS @WIRE(mode="straight") {#IR1:VSS %p_IR1_VSS};
//   %p_IR1_VSS @TEXT("VSS", size=0.8, halign="start", dy=0.5);
//   #IR2 @TEXT("wn=800n wp=2400n", key="sizing", dy=-9.0, size=0.7);
//   #IR2 @PLACE(0,-192.0) => @ORIENT("R0");
//   %p_IR2_A=(-12,-191.0);
//   &req5 @WIRE(mode="straight") {#IR2:A %p_IR2_A};
//   %p_IR2_A @TEXT("req5", size=0.8, halign="end", dy=0);
//   %p_IR2_B=(-12,-193.0);
//   &req6 @WIRE(mode="straight") {#IR2:B %p_IR2_B};
//   %p_IR2_B @TEXT("req6", size=0.8, halign="end", dy=0);
//   %p_IR2_Y=(12,-192.0);
//   &rq2 @WIRE(mode="straight") {#IR2:Y %p_IR2_Y};
//   %p_IR2_Y @TEXT("rq2", size=0.8, halign="start", dy=0);
//   %p_IR2_VDD=(0,-185.0);
//   &DVDD @WIRE(mode="straight") {#IR2:VDD %p_IR2_VDD};
//   %p_IR2_VDD @TEXT("DVDD", size=0.8, halign="start", dy=0.5);
//   %p_IR2_VSS=(0,-199.0);
//   &VSS @WIRE(mode="straight") {#IR2:VSS %p_IR2_VSS};
//   %p_IR2_VSS @TEXT("VSS", size=0.8, halign="start", dy=0.5);
//   #IR3 @TEXT("wn=800n wp=2400n", key="sizing", dy=-9.0, size=0.7);
//   #IR3 @PLACE(42,-192.0) => @ORIENT("R0");
//   %p_IR3_A=(30,-191.0);
//   &req7 @WIRE(mode="straight") {#IR3:A %p_IR3_A};
//   %p_IR3_A @TEXT("req7", size=0.8, halign="end", dy=0);
//   %p_IR3_B=(30,-193.0);
//   &req8 @WIRE(mode="straight") {#IR3:B %p_IR3_B};
//   %p_IR3_B @TEXT("req8", size=0.8, halign="end", dy=0);
//   %p_IR3_Y=(54,-192.0);
//   &rq3 @WIRE(mode="straight") {#IR3:Y %p_IR3_Y};
//   %p_IR3_Y @TEXT("rq3", size=0.8, halign="start", dy=0);
//   %p_IR3_VDD=(42,-185.0);
//   &DVDD @WIRE(mode="straight") {#IR3:VDD %p_IR3_VDD};
//   %p_IR3_VDD @TEXT("DVDD", size=0.8, halign="start", dy=0.5);
//   %p_IR3_VSS=(42,-199.0);
//   &VSS @WIRE(mode="straight") {#IR3:VSS %p_IR3_VSS};
//   %p_IR3_VSS @TEXT("VSS", size=0.8, halign="start", dy=0.5);
//   #IR4 @TEXT("wn=800n wp=2400n", key="sizing", dy=-9.0, size=0.7);
//   #IR4 @PLACE(84,-192.0) => @ORIENT("R0");
//   %p_IR4_A=(72,-191.0);
//   &req9 @WIRE(mode="straight") {#IR4:A %p_IR4_A};
//   %p_IR4_A @TEXT("req9", size=0.8, halign="end", dy=0);
//   %p_IR4_B=(72,-193.0);
//   &req10 @WIRE(mode="straight") {#IR4:B %p_IR4_B};
//   %p_IR4_B @TEXT("req10", size=0.8, halign="end", dy=0);
//   %p_IR4_Y=(96,-192.0);
//   &rq4 @WIRE(mode="straight") {#IR4:Y %p_IR4_Y};
//   %p_IR4_Y @TEXT("rq4", size=0.8, halign="start", dy=0);
//   %p_IR4_VDD=(84,-185.0);
//   &DVDD @WIRE(mode="straight") {#IR4:VDD %p_IR4_VDD};
//   %p_IR4_VDD @TEXT("DVDD", size=0.8, halign="start", dy=0.5);
//   %p_IR4_VSS=(84,-199.0);
//   &VSS @WIRE(mode="straight") {#IR4:VSS %p_IR4_VSS};
//   %p_IR4_VSS @TEXT("VSS", size=0.8, halign="start", dy=0.5);
//   #IR5 @TEXT("wn=800n wp=2400n", key="sizing", dy=-9.0, size=0.7);
//   #IR5 @PLACE(126,-192.0) => @ORIENT("R0");
//   %p_IR5_A=(114,-191.0);
//   &req11 @WIRE(mode="straight") {#IR5:A %p_IR5_A};
//   %p_IR5_A @TEXT("req11", size=0.8, halign="end", dy=0);
//   %p_IR5_B=(114,-193.0);
//   &req12 @WIRE(mode="straight") {#IR5:B %p_IR5_B};
//   %p_IR5_B @TEXT("req12", size=0.8, halign="end", dy=0);
//   %p_IR5_Y=(138,-192.0);
//   &rq5 @WIRE(mode="straight") {#IR5:Y %p_IR5_Y};
//   %p_IR5_Y @TEXT("rq5", size=0.8, halign="start", dy=0);
//   %p_IR5_VDD=(126,-185.0);
//   &DVDD @WIRE(mode="straight") {#IR5:VDD %p_IR5_VDD};
//   %p_IR5_VDD @TEXT("DVDD", size=0.8, halign="start", dy=0.5);
//   %p_IR5_VSS=(126,-199.0);
//   &VSS @WIRE(mode="straight") {#IR5:VSS %p_IR5_VSS};
//   %p_IR5_VSS @TEXT("VSS", size=0.8, halign="start", dy=0.5);
//   #IR6 @TEXT("wn=800n wp=2400n", key="sizing", dy=-9.0, size=0.7);
//   #IR6 @PLACE(168,-192.0) => @ORIENT("R0");
//   %p_IR6_A=(156,-191.0);
//   &req13 @WIRE(mode="straight") {#IR6:A %p_IR6_A};
//   %p_IR6_A @TEXT("req13", size=0.8, halign="end", dy=0);
//   %p_IR6_B=(156,-193.0);
//   &req14 @WIRE(mode="straight") {#IR6:B %p_IR6_B};
//   %p_IR6_B @TEXT("req14", size=0.8, halign="end", dy=0);
//   %p_IR6_Y=(180,-192.0);
//   &rq6 @WIRE(mode="straight") {#IR6:Y %p_IR6_Y};
//   %p_IR6_Y @TEXT("rq6", size=0.8, halign="start", dy=0);
//   %p_IR6_VDD=(168,-185.0);
//   &DVDD @WIRE(mode="straight") {#IR6:VDD %p_IR6_VDD};
//   %p_IR6_VDD @TEXT("DVDD", size=0.8, halign="start", dy=0.5);
//   %p_IR6_VSS=(168,-199.0);
//   &VSS @WIRE(mode="straight") {#IR6:VSS %p_IR6_VSS};
//   %p_IR6_VSS @TEXT("VSS", size=0.8, halign="start", dy=0.5);
//   #IRA @TEXT("wn=2400n wp=900n", key="sizing", dy=-11.0, size=0.7);
//   #IRA @PLACE(0,-217.0) => @ORIENT("R0");
//   %p_IRA_A=(-12,-214.0);
//   &rq0 @WIRE(mode="straight") {#IRA:A %p_IRA_A};
//   %p_IRA_A @TEXT("rq0", size=0.8, halign="end", dy=0);
//   %p_IRA_B=(-12,-216.0);
//   &rq1 @WIRE(mode="straight") {#IRA:B %p_IRA_B};
//   %p_IRA_B @TEXT("rq1", size=0.8, halign="end", dy=0);
//   %p_IRA_C=(-12,-218.0);
//   &rq2 @WIRE(mode="straight") {#IRA:C %p_IRA_C};
//   %p_IRA_C @TEXT("rq2", size=0.8, halign="end", dy=0);
//   %p_IRA_D=(-12,-220.0);
//   &rq3 @WIRE(mode="straight") {#IRA:D %p_IRA_D};
//   %p_IRA_D @TEXT("rq3", size=0.8, halign="end", dy=0);
//   %p_IRA_Y=(12,-217.0);
//   &ra @WIRE(mode="straight") {#IRA:Y %p_IRA_Y};
//   %p_IRA_Y @TEXT("ra", size=0.8, halign="start", dy=0);
//   %p_IRA_VDD=(0,-208.0);
//   &DVDD @WIRE(mode="straight") {#IRA:VDD %p_IRA_VDD};
//   %p_IRA_VDD @TEXT("DVDD", size=0.8, halign="start", dy=0.5);
//   %p_IRA_VSS=(0,-226.0);
//   &VSS @WIRE(mode="straight") {#IRA:VSS %p_IRA_VSS};
//   %p_IRA_VSS @TEXT("VSS", size=0.8, halign="start", dy=0.5);
//   #IRZ @TEXT("wn=1800n wp=900n", key="sizing", dy=-10.0, size=0.7);
//   #IRZ @PLACE(42,-217.0) => @ORIENT("R0");
//   %p_IRZ_A=(30,-215.0);
//   &rq4 @WIRE(mode="straight") {#IRZ:A %p_IRZ_A};
//   %p_IRZ_A @TEXT("rq4", size=0.8, halign="end", dy=0);
//   %p_IRZ_B=(30,-217.0);
//   &rq5 @WIRE(mode="straight") {#IRZ:B %p_IRZ_B};
//   %p_IRZ_B @TEXT("rq5", size=0.8, halign="end", dy=0);
//   %p_IRZ_C=(30,-219.0);
//   &rq6 @WIRE(mode="straight") {#IRZ:C %p_IRZ_C};
//   %p_IRZ_C @TEXT("rq6", size=0.8, halign="end", dy=0);
//   %p_IRZ_Y=(54,-217.0);
//   &rz @WIRE(mode="straight") {#IRZ:Y %p_IRZ_Y};
//   %p_IRZ_Y @TEXT("rz", size=0.8, halign="start", dy=0);
//   %p_IRZ_VDD=(42,-209.0);
//   &DVDD @WIRE(mode="straight") {#IRZ:VDD %p_IRZ_VDD};
//   %p_IRZ_VDD @TEXT("DVDD", size=0.8, halign="start", dy=0.5);
//   %p_IRZ_VSS=(42,-225.0);
//   &VSS @WIRE(mode="straight") {#IRZ:VSS %p_IRZ_VSS};
//   %p_IRZ_VSS @TEXT("VSS", size=0.8, halign="start", dy=0.5);
//   #IROR @TEXT("wn=1200n wp=3600n drive=2", key="sizing", dy=-9.0, size=0.7);
//   #IROR @PLACE(84,-217.0) => @ORIENT("R0");
//   %p_IROR_A=(72,-216.0);
//   &ra @WIRE(mode="straight") {#IROR:A %p_IROR_A};
//   %p_IROR_A @TEXT("ra", size=0.8, halign="end", dy=0);
//   %p_IROR_B=(72,-218.0);
//   &rz @WIRE(mode="straight") {#IROR:B %p_IROR_B};
//   %p_IROR_B @TEXT("rz", size=0.8, halign="end", dy=0);
//   %p_IROR_Y=(96,-217.0);
//   &rqbar @WIRE(mode="straight") {#IROR:Y %p_IROR_Y};
//   %p_IROR_Y @TEXT("rqbar", size=0.8, halign="start", dy=0);
//   %p_IROR_VDD=(84,-210.0);
//   &DVDD @WIRE(mode="straight") {#IROR:VDD %p_IROR_VDD};
//   %p_IROR_VDD @TEXT("DVDD", size=0.8, halign="start", dy=0.5);
//   %p_IROR_VSS=(84,-224.0);
//   &VSS @WIRE(mode="straight") {#IROR:VSS %p_IROR_VSS};
//   %p_IROR_VSS @TEXT("VSS", size=0.8, halign="start", dy=0.5);
//   #IFB @TEXT("wn=1200n wp=1800n", key="sizing", dy=-8.0, size=0.7);
//   #IFB @PLACE(126,-217.0) => @ORIENT("R0");
//   %p_IFB_A=(114,-217.0);
//   &force @WIRE(mode="straight") {#IFB:A %p_IFB_A};
//   %p_IFB_A @TEXT("force", size=0.8, halign="end", dy=0);
//   %p_IFB_Y=(138,-217.0);
//   &forceb @WIRE(mode="straight") {#IFB:Y %p_IFB_Y};
//   %p_IFB_Y @TEXT("forceb", size=0.8, halign="start", dy=0);
//   %p_IFB_VDD=(126,-211.0);
//   &DVDD @WIRE(mode="straight") {#IFB:VDD %p_IFB_VDD};
//   %p_IFB_VDD @TEXT("DVDD", size=0.8, halign="start", dy=0.5);
//   %p_IFB_VSS=(126,-223.0);
//   &VSS @WIRE(mode="straight") {#IFB:VSS %p_IFB_VSS};
//   %p_IFB_VSS @TEXT("VSS", size=0.8, halign="start", dy=0.5);
//   #ICKH @PLACE(168,-217.0) => @ORIENT("R0");
//   %p_ICKH_SETB=(156,-213.0);
//   &rqbar @WIRE(mode="straight") {#ICKH:SETB %p_ICKH_SETB};
//   %p_ICKH_SETB @TEXT("rqbar", size=0.8, halign="end", dy=0);
//   %p_ICKH_CV=(156,-215.0);
//   &cv @WIRE(mode="straight") {#ICKH:CV %p_ICKH_CV};
//   %p_ICKH_CV @TEXT("cv", size=0.8, halign="end", dy=0);
//   %p_ICKH_PB=(156,-217.0);
//   &pib @WIRE(mode="straight") {#ICKH:PB %p_ICKH_PB};
//   %p_ICKH_PB @TEXT("pib", size=0.8, halign="end", dy=0);
//   %p_ICKH_NB=(156,-219.0);
//   &nib @WIRE(mode="straight") {#ICKH:NB %p_ICKH_NB};
//   %p_ICKH_NB @TEXT("nib", size=0.8, halign="end", dy=0);
//   %p_ICKH_FB=(156,-221.0);
//   &forceb @WIRE(mode="straight") {#ICKH:FB %p_ICKH_FB};
//   %p_ICKH_FB @TEXT("forceb", size=0.8, halign="end", dy=0);
//   %p_ICKH_CK=(180,-217.0);
//   &CLKC @WIRE(mode="straight") {#ICKH:CK %p_ICKH_CK};
//   %p_ICKH_CK @TEXT("CLKC", size=0.8, halign="start", dy=0);
//   %p_ICKH_VDD=(168,-207.0);
//   &DVDD @WIRE(mode="straight") {#ICKH:VDD %p_ICKH_VDD};
//   %p_ICKH_VDD @TEXT("DVDD", size=0.8, halign="start", dy=0.5);
//   %p_ICKH_VSS=(168,-227.0);
//   &VSS @WIRE(mode="straight") {#ICKH:VSS %p_ICKH_VSS};
//   %p_ICKH_VSS @TEXT("VSS", size=0.8, halign="start", dy=0.5);
//   #IT0 @TEXT("cw=timer_load", key="sizing", dy=-9.0, size=0.7);
//   #IT0 @PLACE(0,-242.0) => @ORIENT("R0");
//   %p_IT0_A=(-12,-241.0);
//   &CLKC @WIRE(mode="straight") {#IT0:A %p_IT0_A};
//   %p_IT0_A @TEXT("CLKC", size=0.8, halign="end", dy=0);
//   %p_IT0_EN=(-12,-243.0);
//   &CLKC @WIRE(mode="straight") {#IT0:EN %p_IT0_EN};
//   %p_IT0_EN @TEXT("CLKC", size=0.8, halign="end", dy=0);
//   %p_IT0_Y=(12,-242.0);
//   &to0 @WIRE(mode="straight") {#IT0:Y %p_IT0_Y};
//   %p_IT0_Y @TEXT("to0", size=0.8, halign="start", dy=0);
//   %p_IT0_VDD=(0,-235.0);
//   &DVDD @WIRE(mode="straight") {#IT0:VDD %p_IT0_VDD};
//   %p_IT0_VDD @TEXT("DVDD", size=0.8, halign="start", dy=0.5);
//   %p_IT0_VSS=(0,-249.0);
//   &VSS @WIRE(mode="straight") {#IT0:VSS %p_IT0_VSS};
//   %p_IT0_VSS @TEXT("VSS", size=0.8, halign="start", dy=0.5);
//   #IT1 @TEXT("cw=timer_load", key="sizing", dy=-9.0, size=0.7);
//   #IT1 @PLACE(42,-242.0) => @ORIENT("R0");
//   %p_IT1_A=(30,-241.0);
//   &to0 @WIRE(mode="straight") {#IT1:A %p_IT1_A};
//   %p_IT1_A @TEXT("to0", size=0.8, halign="end", dy=0);
//   %p_IT1_EN=(30,-243.0);
//   &CLKC @WIRE(mode="straight") {#IT1:EN %p_IT1_EN};
//   %p_IT1_EN @TEXT("CLKC", size=0.8, halign="end", dy=0);
//   %p_IT1_Y=(54,-242.0);
//   &to1 @WIRE(mode="straight") {#IT1:Y %p_IT1_Y};
//   %p_IT1_Y @TEXT("to1", size=0.8, halign="start", dy=0);
//   %p_IT1_VDD=(42,-235.0);
//   &DVDD @WIRE(mode="straight") {#IT1:VDD %p_IT1_VDD};
//   %p_IT1_VDD @TEXT("DVDD", size=0.8, halign="start", dy=0.5);
//   %p_IT1_VSS=(42,-249.0);
//   &VSS @WIRE(mode="straight") {#IT1:VSS %p_IT1_VSS};
//   %p_IT1_VSS @TEXT("VSS", size=0.8, halign="start", dy=0.5);
//   #IT2 @TEXT("cw=timer_load", key="sizing", dy=-9.0, size=0.7);
//   #IT2 @PLACE(84,-242.0) => @ORIENT("R0");
//   %p_IT2_A=(72,-241.0);
//   &to1 @WIRE(mode="straight") {#IT2:A %p_IT2_A};
//   %p_IT2_A @TEXT("to1", size=0.8, halign="end", dy=0);
//   %p_IT2_EN=(72,-243.0);
//   &CLKC @WIRE(mode="straight") {#IT2:EN %p_IT2_EN};
//   %p_IT2_EN @TEXT("CLKC", size=0.8, halign="end", dy=0);
//   %p_IT2_Y=(96,-242.0);
//   &to2 @WIRE(mode="straight") {#IT2:Y %p_IT2_Y};
//   %p_IT2_Y @TEXT("to2", size=0.8, halign="start", dy=0);
//   %p_IT2_VDD=(84,-235.0);
//   &DVDD @WIRE(mode="straight") {#IT2:VDD %p_IT2_VDD};
//   %p_IT2_VDD @TEXT("DVDD", size=0.8, halign="start", dy=0.5);
//   %p_IT2_VSS=(84,-249.0);
//   &VSS @WIRE(mode="straight") {#IT2:VSS %p_IT2_VSS};
//   %p_IT2_VSS @TEXT("VSS", size=0.8, halign="start", dy=0.5);
//   #IT3 @TEXT("cw=timer_load", key="sizing", dy=-9.0, size=0.7);
//   #IT3 @PLACE(126,-242.0) => @ORIENT("R0");
//   %p_IT3_A=(114,-241.0);
//   &to2 @WIRE(mode="straight") {#IT3:A %p_IT3_A};
//   %p_IT3_A @TEXT("to2", size=0.8, halign="end", dy=0);
//   %p_IT3_EN=(114,-243.0);
//   &CLKC @WIRE(mode="straight") {#IT3:EN %p_IT3_EN};
//   %p_IT3_EN @TEXT("CLKC", size=0.8, halign="end", dy=0);
//   %p_IT3_Y=(138,-242.0);
//   &to3 @WIRE(mode="straight") {#IT3:Y %p_IT3_Y};
//   %p_IT3_Y @TEXT("to3", size=0.8, halign="start", dy=0);
//   %p_IT3_VDD=(126,-235.0);
//   &DVDD @WIRE(mode="straight") {#IT3:VDD %p_IT3_VDD};
//   %p_IT3_VDD @TEXT("DVDD", size=0.8, halign="start", dy=0.5);
//   %p_IT3_VSS=(126,-249.0);
//   &VSS @WIRE(mode="straight") {#IT3:VSS %p_IT3_VSS};
//   %p_IT3_VSS @TEXT("VSS", size=0.8, halign="start", dy=0.5);
//   #IT4 @TEXT("cw=timer_load", key="sizing", dy=-9.0, size=0.7);
//   #IT4 @PLACE(168,-242.0) => @ORIENT("R0");
//   %p_IT4_A=(156,-241.0);
//   &to3 @WIRE(mode="straight") {#IT4:A %p_IT4_A};
//   %p_IT4_A @TEXT("to3", size=0.8, halign="end", dy=0);
//   %p_IT4_EN=(156,-243.0);
//   &CLKC @WIRE(mode="straight") {#IT4:EN %p_IT4_EN};
//   %p_IT4_EN @TEXT("CLKC", size=0.8, halign="end", dy=0);
//   %p_IT4_Y=(180,-242.0);
//   &to4 @WIRE(mode="straight") {#IT4:Y %p_IT4_Y};
//   %p_IT4_Y @TEXT("to4", size=0.8, halign="start", dy=0);
//   %p_IT4_VDD=(168,-235.0);
//   &DVDD @WIRE(mode="straight") {#IT4:VDD %p_IT4_VDD};
//   %p_IT4_VDD @TEXT("DVDD", size=0.8, halign="start", dy=0.5);
//   %p_IT4_VSS=(168,-249.0);
//   &VSS @WIRE(mode="straight") {#IT4:VSS %p_IT4_VSS};
//   %p_IT4_VSS @TEXT("VSS", size=0.8, halign="start", dy=0.5);
//   #IT5 @TEXT("cw=timer_load", key="sizing", dy=-9.0, size=0.7);
//   #IT5 @PLACE(0,-264.0) => @ORIENT("R0");
//   %p_IT5_A=(-12,-263.0);
//   &to4 @WIRE(mode="straight") {#IT5:A %p_IT5_A};
//   %p_IT5_A @TEXT("to4", size=0.8, halign="end", dy=0);
//   %p_IT5_EN=(-12,-265.0);
//   &CLKC @WIRE(mode="straight") {#IT5:EN %p_IT5_EN};
//   %p_IT5_EN @TEXT("CLKC", size=0.8, halign="end", dy=0);
//   %p_IT5_Y=(12,-264.0);
//   &to5 @WIRE(mode="straight") {#IT5:Y %p_IT5_Y};
//   %p_IT5_Y @TEXT("to5", size=0.8, halign="start", dy=0);
//   %p_IT5_VDD=(0,-257.0);
//   &DVDD @WIRE(mode="straight") {#IT5:VDD %p_IT5_VDD};
//   %p_IT5_VDD @TEXT("DVDD", size=0.8, halign="start", dy=0.5);
//   %p_IT5_VSS=(0,-271.0);
//   &VSS @WIRE(mode="straight") {#IT5:VSS %p_IT5_VSS};
//   %p_IT5_VSS @TEXT("VSS", size=0.8, halign="start", dy=0.5);
//   #IT6 @TEXT("cw=timer_load", key="sizing", dy=-9.0, size=0.7);
//   #IT6 @PLACE(42,-264.0) => @ORIENT("R0");
//   %p_IT6_A=(30,-263.0);
//   &to5 @WIRE(mode="straight") {#IT6:A %p_IT6_A};
//   %p_IT6_A @TEXT("to5", size=0.8, halign="end", dy=0);
//   %p_IT6_EN=(30,-265.0);
//   &CLKC @WIRE(mode="straight") {#IT6:EN %p_IT6_EN};
//   %p_IT6_EN @TEXT("CLKC", size=0.8, halign="end", dy=0);
//   %p_IT6_Y=(54,-264.0);
//   &to6 @WIRE(mode="straight") {#IT6:Y %p_IT6_Y};
//   %p_IT6_Y @TEXT("to6", size=0.8, halign="start", dy=0);
//   %p_IT6_VDD=(42,-257.0);
//   &DVDD @WIRE(mode="straight") {#IT6:VDD %p_IT6_VDD};
//   %p_IT6_VDD @TEXT("DVDD", size=0.8, halign="start", dy=0.5);
//   %p_IT6_VSS=(42,-271.0);
//   &VSS @WIRE(mode="straight") {#IT6:VSS %p_IT6_VSS};
//   %p_IT6_VSS @TEXT("VSS", size=0.8, halign="start", dy=0.5);
//   #IT7 @TEXT("cw=timer_load", key="sizing", dy=-9.0, size=0.7);
//   #IT7 @PLACE(84,-264.0) => @ORIENT("R0");
//   %p_IT7_A=(72,-263.0);
//   &to6 @WIRE(mode="straight") {#IT7:A %p_IT7_A};
//   %p_IT7_A @TEXT("to6", size=0.8, halign="end", dy=0);
//   %p_IT7_EN=(72,-265.0);
//   &CLKC @WIRE(mode="straight") {#IT7:EN %p_IT7_EN};
//   %p_IT7_EN @TEXT("CLKC", size=0.8, halign="end", dy=0);
//   %p_IT7_Y=(96,-264.0);
//   &to7 @WIRE(mode="straight") {#IT7:Y %p_IT7_Y};
//   %p_IT7_Y @TEXT("to7", size=0.8, halign="start", dy=0);
//   %p_IT7_VDD=(84,-257.0);
//   &DVDD @WIRE(mode="straight") {#IT7:VDD %p_IT7_VDD};
//   %p_IT7_VDD @TEXT("DVDD", size=0.8, halign="start", dy=0.5);
//   %p_IT7_VSS=(84,-271.0);
//   &VSS @WIRE(mode="straight") {#IT7:VSS %p_IT7_VSS};
//   %p_IT7_VSS @TEXT("VSS", size=0.8, halign="start", dy=0.5);
//   #IT8 @TEXT("cw=timer_load", key="sizing", dy=-9.0, size=0.7);
//   #IT8 @PLACE(126,-264.0) => @ORIENT("R0");
//   %p_IT8_A=(114,-263.0);
//   &to7 @WIRE(mode="straight") {#IT8:A %p_IT8_A};
//   %p_IT8_A @TEXT("to7", size=0.8, halign="end", dy=0);
//   %p_IT8_EN=(114,-265.0);
//   &CLKC @WIRE(mode="straight") {#IT8:EN %p_IT8_EN};
//   %p_IT8_EN @TEXT("CLKC", size=0.8, halign="end", dy=0);
//   %p_IT8_Y=(138,-264.0);
//   &to8 @WIRE(mode="straight") {#IT8:Y %p_IT8_Y};
//   %p_IT8_Y @TEXT("to8", size=0.8, halign="start", dy=0);
//   %p_IT8_VDD=(126,-257.0);
//   &DVDD @WIRE(mode="straight") {#IT8:VDD %p_IT8_VDD};
//   %p_IT8_VDD @TEXT("DVDD", size=0.8, halign="start", dy=0.5);
//   %p_IT8_VSS=(126,-271.0);
//   &VSS @WIRE(mode="straight") {#IT8:VSS %p_IT8_VSS};
//   %p_IT8_VSS @TEXT("VSS", size=0.8, halign="start", dy=0.5);
//   #IT9 @TEXT("cw=timer_load", key="sizing", dy=-9.0, size=0.7);
//   #IT9 @PLACE(168,-264.0) => @ORIENT("R0");
//   %p_IT9_A=(156,-263.0);
//   &to8 @WIRE(mode="straight") {#IT9:A %p_IT9_A};
//   %p_IT9_A @TEXT("to8", size=0.8, halign="end", dy=0);
//   %p_IT9_EN=(156,-265.0);
//   &CLKC @WIRE(mode="straight") {#IT9:EN %p_IT9_EN};
//   %p_IT9_EN @TEXT("CLKC", size=0.8, halign="end", dy=0);
//   %p_IT9_Y=(180,-264.0);
//   &to9 @WIRE(mode="straight") {#IT9:Y %p_IT9_Y};
//   %p_IT9_Y @TEXT("to9", size=0.8, halign="start", dy=0);
//   %p_IT9_VDD=(168,-257.0);
//   &DVDD @WIRE(mode="straight") {#IT9:VDD %p_IT9_VDD};
//   %p_IT9_VDD @TEXT("DVDD", size=0.8, halign="start", dy=0.5);
//   %p_IT9_VSS=(168,-271.0);
//   &VSS @WIRE(mode="straight") {#IT9:VSS %p_IT9_VSS};
//   %p_IT9_VSS @TEXT("VSS", size=0.8, halign="start", dy=0.5);
//   #IT10 @TEXT("cw=timer_load", key="sizing", dy=-9.0, size=0.7);
//   #IT10 @PLACE(0,-286.0) => @ORIENT("R0");
//   %p_IT10_A=(-12,-285.0);
//   &to9 @WIRE(mode="straight") {#IT10:A %p_IT10_A};
//   %p_IT10_A @TEXT("to9", size=0.8, halign="end", dy=0);
//   %p_IT10_EN=(-12,-287.0);
//   &CLKC @WIRE(mode="straight") {#IT10:EN %p_IT10_EN};
//   %p_IT10_EN @TEXT("CLKC", size=0.8, halign="end", dy=0);
//   %p_IT10_Y=(12,-286.0);
//   &to10 @WIRE(mode="straight") {#IT10:Y %p_IT10_Y};
//   %p_IT10_Y @TEXT("to10", size=0.8, halign="start", dy=0);
//   %p_IT10_VDD=(0,-279.0);
//   &DVDD @WIRE(mode="straight") {#IT10:VDD %p_IT10_VDD};
//   %p_IT10_VDD @TEXT("DVDD", size=0.8, halign="start", dy=0.5);
//   %p_IT10_VSS=(0,-293.0);
//   &VSS @WIRE(mode="straight") {#IT10:VSS %p_IT10_VSS};
//   %p_IT10_VSS @TEXT("VSS", size=0.8, halign="start", dy=0.5);
//   #IT11 @TEXT("cw=timer_load", key="sizing", dy=-9.0, size=0.7);
//   #IT11 @PLACE(42,-286.0) => @ORIENT("R0");
//   %p_IT11_A=(30,-285.0);
//   &to10 @WIRE(mode="straight") {#IT11:A %p_IT11_A};
//   %p_IT11_A @TEXT("to10", size=0.8, halign="end", dy=0);
//   %p_IT11_EN=(30,-287.0);
//   &CLKC @WIRE(mode="straight") {#IT11:EN %p_IT11_EN};
//   %p_IT11_EN @TEXT("CLKC", size=0.8, halign="end", dy=0);
//   %p_IT11_Y=(54,-286.0);
//   &to11 @WIRE(mode="straight") {#IT11:Y %p_IT11_Y};
//   %p_IT11_Y @TEXT("to11", size=0.8, halign="start", dy=0);
//   %p_IT11_VDD=(42,-279.0);
//   &DVDD @WIRE(mode="straight") {#IT11:VDD %p_IT11_VDD};
//   %p_IT11_VDD @TEXT("DVDD", size=0.8, halign="start", dy=0.5);
//   %p_IT11_VSS=(42,-293.0);
//   &VSS @WIRE(mode="straight") {#IT11:VSS %p_IT11_VSS};
//   %p_IT11_VSS @TEXT("VSS", size=0.8, halign="start", dy=0.5);
//   #IT12 @TEXT("cw=timer_load", key="sizing", dy=-9.0, size=0.7);
//   #IT12 @PLACE(84,-286.0) => @ORIENT("R0");
//   %p_IT12_A=(72,-285.0);
//   &to11 @WIRE(mode="straight") {#IT12:A %p_IT12_A};
//   %p_IT12_A @TEXT("to11", size=0.8, halign="end", dy=0);
//   %p_IT12_EN=(72,-287.0);
//   &CLKC @WIRE(mode="straight") {#IT12:EN %p_IT12_EN};
//   %p_IT12_EN @TEXT("CLKC", size=0.8, halign="end", dy=0);
//   %p_IT12_Y=(96,-286.0);
//   &to12 @WIRE(mode="straight") {#IT12:Y %p_IT12_Y};
//   %p_IT12_Y @TEXT("to12", size=0.8, halign="start", dy=0);
//   %p_IT12_VDD=(84,-279.0);
//   &DVDD @WIRE(mode="straight") {#IT12:VDD %p_IT12_VDD};
//   %p_IT12_VDD @TEXT("DVDD", size=0.8, halign="start", dy=0.5);
//   %p_IT12_VSS=(84,-293.0);
//   &VSS @WIRE(mode="straight") {#IT12:VSS %p_IT12_VSS};
//   %p_IT12_VSS @TEXT("VSS", size=0.8, halign="start", dy=0.5);
//   #IT13 @TEXT("cw=timer_load", key="sizing", dy=-9.0, size=0.7);
//   #IT13 @PLACE(126,-286.0) => @ORIENT("R0");
//   %p_IT13_A=(114,-285.0);
//   &to12 @WIRE(mode="straight") {#IT13:A %p_IT13_A};
//   %p_IT13_A @TEXT("to12", size=0.8, halign="end", dy=0);
//   %p_IT13_EN=(114,-287.0);
//   &CLKC @WIRE(mode="straight") {#IT13:EN %p_IT13_EN};
//   %p_IT13_EN @TEXT("CLKC", size=0.8, halign="end", dy=0);
//   %p_IT13_Y=(138,-286.0);
//   &to13 @WIRE(mode="straight") {#IT13:Y %p_IT13_Y};
//   %p_IT13_Y @TEXT("to13", size=0.8, halign="start", dy=0);
//   %p_IT13_VDD=(126,-279.0);
//   &DVDD @WIRE(mode="straight") {#IT13:VDD %p_IT13_VDD};
//   %p_IT13_VDD @TEXT("DVDD", size=0.8, halign="start", dy=0.5);
//   %p_IT13_VSS=(126,-293.0);
//   &VSS @WIRE(mode="straight") {#IT13:VSS %p_IT13_VSS};
//   %p_IT13_VSS @TEXT("VSS", size=0.8, halign="start", dy=0.5);
//   #IT14 @TEXT("cw=timer_load", key="sizing", dy=-9.0, size=0.7);
//   #IT14 @PLACE(168,-286.0) => @ORIENT("R0");
//   %p_IT14_A=(156,-285.0);
//   &to13 @WIRE(mode="straight") {#IT14:A %p_IT14_A};
//   %p_IT14_A @TEXT("to13", size=0.8, halign="end", dy=0);
//   %p_IT14_EN=(156,-287.0);
//   &CLKC @WIRE(mode="straight") {#IT14:EN %p_IT14_EN};
//   %p_IT14_EN @TEXT("CLKC", size=0.8, halign="end", dy=0);
//   %p_IT14_Y=(180,-286.0);
//   &to14 @WIRE(mode="straight") {#IT14:Y %p_IT14_Y};
//   %p_IT14_Y @TEXT("to14", size=0.8, halign="start", dy=0);
//   %p_IT14_VDD=(168,-279.0);
//   &DVDD @WIRE(mode="straight") {#IT14:VDD %p_IT14_VDD};
//   %p_IT14_VDD @TEXT("DVDD", size=0.8, halign="start", dy=0.5);
//   %p_IT14_VSS=(168,-293.0);
//   &VSS @WIRE(mode="straight") {#IT14:VSS %p_IT14_VSS};
//   %p_IT14_VSS @TEXT("VSS", size=0.8, halign="start", dy=0.5);
//   #IT15 @TEXT("cw=timer_load", key="sizing", dy=-9.0, size=0.7);
//   #IT15 @PLACE(0,-308.0) => @ORIENT("R0");
//   %p_IT15_A=(-12,-307.0);
//   &to14 @WIRE(mode="straight") {#IT15:A %p_IT15_A};
//   %p_IT15_A @TEXT("to14", size=0.8, halign="end", dy=0);
//   %p_IT15_EN=(-12,-309.0);
//   &CLKC @WIRE(mode="straight") {#IT15:EN %p_IT15_EN};
//   %p_IT15_EN @TEXT("CLKC", size=0.8, halign="end", dy=0);
//   %p_IT15_Y=(12,-308.0);
//   &to15 @WIRE(mode="straight") {#IT15:Y %p_IT15_Y};
//   %p_IT15_Y @TEXT("to15", size=0.8, halign="start", dy=0);
//   %p_IT15_VDD=(0,-301.0);
//   &DVDD @WIRE(mode="straight") {#IT15:VDD %p_IT15_VDD};
//   %p_IT15_VDD @TEXT("DVDD", size=0.8, halign="start", dy=0.5);
//   %p_IT15_VSS=(0,-315.0);
//   &VSS @WIRE(mode="straight") {#IT15:VSS %p_IT15_VSS};
//   %p_IT15_VSS @TEXT("VSS", size=0.8, halign="start", dy=0.5);
//   #ITO @PLACE(42,-308.0) => @ORIENT("R0");
//   %p_ITO_A=(30,-307.0);
//   &to15 @WIRE(mode="straight") {#ITO:A %p_ITO_A};
//   %p_ITO_A @TEXT("to15", size=0.8, halign="end", dy=0);
//   %p_ITO_B=(30,-309.0);
//   &CLKC @WIRE(mode="straight") {#ITO:B %p_ITO_B};
//   %p_ITO_B @TEXT("CLKC", size=0.8, halign="end", dy=0);
//   %p_ITO_Y=(54,-308.0);
//   &force @WIRE(mode="straight") {#ITO:Y %p_ITO_Y};
//   %p_ITO_Y @TEXT("force", size=0.8, halign="start", dy=0);
//   %p_ITO_VDD=(42,-301.0);
//   &DVDD @WIRE(mode="straight") {#ITO:VDD %p_ITO_VDD};
//   %p_ITO_VDD @TEXT("DVDD", size=0.8, halign="start", dy=0.5);
//   %p_ITO_VSS=(42,-315.0);
//   &VSS @WIRE(mode="straight") {#ITO:VSS %p_ITO_VSS};
//   %p_ITO_VSS @TEXT("VSS", size=0.8, halign="start", dy=0.5);
//   #IEOC @PLACE(84,-308.0) => @ORIENT("R0");
//   %p_IEOC_A=(72,-307.0);
//   &done14 @WIRE(mode="straight") {#IEOC:A %p_IEOC_A};
//   %p_IEOC_A @TEXT("done14", size=0.8, halign="end", dy=0);
//   %p_IEOC_B=(72,-309.0);
//   &cv @WIRE(mode="straight") {#IEOC:B %p_IEOC_B};
//   %p_IEOC_B @TEXT("cv", size=0.8, halign="end", dy=0);
//   %p_IEOC_Y=(96,-308.0);
//   &eoc @WIRE(mode="straight") {#IEOC:Y %p_IEOC_Y};
//   %p_IEOC_Y @TEXT("eoc", size=0.8, halign="start", dy=0);
//   %p_IEOC_VDD=(84,-301.0);
//   &DVDD @WIRE(mode="straight") {#IEOC:VDD %p_IEOC_VDD};
//   %p_IEOC_VDD @TEXT("DVDD", size=0.8, halign="start", dy=0.5);
//   %p_IEOC_VSS=(84,-315.0);
//   &VSS @WIRE(mode="straight") {#IEOC:VSS %p_IEOC_VSS};
//   %p_IEOC_VSS @TEXT("VSS", size=0.8, halign="start", dy=0.5);
//   #IENREG @PLACE(126,-308.0) => @ORIENT("R0");
//   %p_IENREG_A=(114,-307.0);
//   &eoc @WIRE(mode="straight") {#IENREG:A %p_IENREG_A};
//   %p_IENREG_A @TEXT("eoc", size=0.8, halign="end", dy=0);
//   %p_IENREG_B=(114,-309.0);
//   &abort @WIRE(mode="straight") {#IENREG:B %p_IENREG_B};
//   %p_IENREG_B @TEXT("abort", size=0.8, halign="end", dy=0);
//   %p_IENREG_Y=(138,-308.0);
//   &load @WIRE(mode="straight") {#IENREG:Y %p_IENREG_Y};
//   %p_IENREG_Y @TEXT("load", size=0.8, halign="start", dy=0);
//   %p_IENREG_VDD=(126,-301.0);
//   &DVDD @WIRE(mode="straight") {#IENREG:VDD %p_IENREG_VDD};
//   %p_IENREG_VDD @TEXT("DVDD", size=0.8, halign="start", dy=0.5);
//   %p_IENREG_VSS=(126,-315.0);
//   &VSS @WIRE(mode="straight") {#IENREG:VSS %p_IENREG_VSS};
//   %p_IENREG_VSS @TEXT("VSS", size=0.8, halign="start", dy=0.5);
//   #ILBUF @TEXT("drive=6", key="sizing", dy=-8.0, size=0.7);
//   #ILBUF @PLACE(168,-308.0) => @ORIENT("R0");
//   %p_ILBUF_A=(156,-308.0);
//   &load @WIRE(mode="straight") {#ILBUF:A %p_ILBUF_A};
//   %p_ILBUF_A @TEXT("load", size=0.8, halign="end", dy=0);
//   %p_ILBUF_Y=(180,-308.0);
//   &loadp @WIRE(mode="straight") {#ILBUF:Y %p_ILBUF_Y};
//   %p_ILBUF_Y @TEXT("loadp", size=0.8, halign="start", dy=0);
//   %p_ILBUF_VDD=(168,-302.0);
//   &DVDD @WIRE(mode="straight") {#ILBUF:VDD %p_ILBUF_VDD};
//   %p_ILBUF_VDD @TEXT("DVDD", size=0.8, halign="start", dy=0.5);
//   %p_ILBUF_VSS=(168,-314.0);
//   &VSS @WIRE(mode="straight") {#ILBUF:VSS %p_ILBUF_VSS};
//   %p_ILBUF_VSS @TEXT("VSS", size=0.8, halign="start", dy=0.5);
//   #ILBAR @TEXT("wn=4u wp=6u", key="sizing", dy=-8.0, size=0.7);
//   #ILBAR @PLACE(0,-331.0) => @ORIENT("R0");
//   %p_ILBAR_A=(-12,-331.0);
//   &loadp @WIRE(mode="straight") {#ILBAR:A %p_ILBAR_A};
//   %p_ILBAR_A @TEXT("loadp", size=0.8, halign="end", dy=0);
//   %p_ILBAR_Y=(12,-331.0);
//   &loadb @WIRE(mode="straight") {#ILBAR:Y %p_ILBAR_Y};
//   %p_ILBAR_Y @TEXT("loadb", size=0.8, halign="start", dy=0);
//   %p_ILBAR_VDD=(0,-325.0);
//   &DVDD @WIRE(mode="straight") {#ILBAR:VDD %p_ILBAR_VDD};
//   %p_ILBAR_VDD @TEXT("DVDD", size=0.8, halign="start", dy=0.5);
//   %p_ILBAR_VSS=(0,-337.0);
//   &VSS @WIRE(mode="straight") {#ILBAR:VSS %p_ILBAR_VSS};
//   %p_ILBAR_VSS @TEXT("VSS", size=0.8, halign="start", dy=0.5);
//   #ID13 @PLACE(42,-331.0) => @ORIENT("R0");
//   %p_ID13_A=(30,-329.0);
//   &raw13 @WIRE(mode="straight") {#ID13:A %p_ID13_A};
//   %p_ID13_A @TEXT("raw13", size=0.8, halign="end", dy=0);
//   %p_ID13_EN=(30,-331.0);
//   &loadp @WIRE(mode="straight") {#ID13:EN %p_ID13_EN};
//   %p_ID13_EN @TEXT("loadp", size=0.8, halign="end", dy=0);
//   %p_ID13_ENB=(30,-333.0);
//   &loadb @WIRE(mode="straight") {#ID13:ENB %p_ID13_ENB};
//   %p_ID13_ENB @TEXT("loadb", size=0.8, halign="end", dy=0);
//   %p_ID13_Q=(54,-331.0);
//   &D13 @WIRE(mode="straight") {#ID13:Q %p_ID13_Q};
//   %p_ID13_Q @TEXT("D13", size=0.8, halign="start", dy=0);
//   %p_ID13_VDD=(42,-323.0);
//   &DVDD @WIRE(mode="straight") {#ID13:VDD %p_ID13_VDD};
//   %p_ID13_VDD @TEXT("DVDD", size=0.8, halign="start", dy=0.5);
//   %p_ID13_VSS=(42,-339.0);
//   &VSS @WIRE(mode="straight") {#ID13:VSS %p_ID13_VSS};
//   %p_ID13_VSS @TEXT("VSS", size=0.8, halign="start", dy=0.5);
//   #ID12 @PLACE(84,-331.0) => @ORIENT("R0");
//   %p_ID12_A=(72,-329.0);
//   &raw12 @WIRE(mode="straight") {#ID12:A %p_ID12_A};
//   %p_ID12_A @TEXT("raw12", size=0.8, halign="end", dy=0);
//   %p_ID12_EN=(72,-331.0);
//   &loadp @WIRE(mode="straight") {#ID12:EN %p_ID12_EN};
//   %p_ID12_EN @TEXT("loadp", size=0.8, halign="end", dy=0);
//   %p_ID12_ENB=(72,-333.0);
//   &loadb @WIRE(mode="straight") {#ID12:ENB %p_ID12_ENB};
//   %p_ID12_ENB @TEXT("loadb", size=0.8, halign="end", dy=0);
//   %p_ID12_Q=(96,-331.0);
//   &D12 @WIRE(mode="straight") {#ID12:Q %p_ID12_Q};
//   %p_ID12_Q @TEXT("D12", size=0.8, halign="start", dy=0);
//   %p_ID12_VDD=(84,-323.0);
//   &DVDD @WIRE(mode="straight") {#ID12:VDD %p_ID12_VDD};
//   %p_ID12_VDD @TEXT("DVDD", size=0.8, halign="start", dy=0.5);
//   %p_ID12_VSS=(84,-339.0);
//   &VSS @WIRE(mode="straight") {#ID12:VSS %p_ID12_VSS};
//   %p_ID12_VSS @TEXT("VSS", size=0.8, halign="start", dy=0.5);
//   #ID11 @PLACE(126,-331.0) => @ORIENT("R0");
//   %p_ID11_A=(114,-329.0);
//   &raw11 @WIRE(mode="straight") {#ID11:A %p_ID11_A};
//   %p_ID11_A @TEXT("raw11", size=0.8, halign="end", dy=0);
//   %p_ID11_EN=(114,-331.0);
//   &loadp @WIRE(mode="straight") {#ID11:EN %p_ID11_EN};
//   %p_ID11_EN @TEXT("loadp", size=0.8, halign="end", dy=0);
//   %p_ID11_ENB=(114,-333.0);
//   &loadb @WIRE(mode="straight") {#ID11:ENB %p_ID11_ENB};
//   %p_ID11_ENB @TEXT("loadb", size=0.8, halign="end", dy=0);
//   %p_ID11_Q=(138,-331.0);
//   &D11 @WIRE(mode="straight") {#ID11:Q %p_ID11_Q};
//   %p_ID11_Q @TEXT("D11", size=0.8, halign="start", dy=0);
//   %p_ID11_VDD=(126,-323.0);
//   &DVDD @WIRE(mode="straight") {#ID11:VDD %p_ID11_VDD};
//   %p_ID11_VDD @TEXT("DVDD", size=0.8, halign="start", dy=0.5);
//   %p_ID11_VSS=(126,-339.0);
//   &VSS @WIRE(mode="straight") {#ID11:VSS %p_ID11_VSS};
//   %p_ID11_VSS @TEXT("VSS", size=0.8, halign="start", dy=0.5);
//   #ID10 @PLACE(168,-331.0) => @ORIENT("R0");
//   %p_ID10_A=(156,-329.0);
//   &raw10 @WIRE(mode="straight") {#ID10:A %p_ID10_A};
//   %p_ID10_A @TEXT("raw10", size=0.8, halign="end", dy=0);
//   %p_ID10_EN=(156,-331.0);
//   &loadp @WIRE(mode="straight") {#ID10:EN %p_ID10_EN};
//   %p_ID10_EN @TEXT("loadp", size=0.8, halign="end", dy=0);
//   %p_ID10_ENB=(156,-333.0);
//   &loadb @WIRE(mode="straight") {#ID10:ENB %p_ID10_ENB};
//   %p_ID10_ENB @TEXT("loadb", size=0.8, halign="end", dy=0);
//   %p_ID10_Q=(180,-331.0);
//   &D10 @WIRE(mode="straight") {#ID10:Q %p_ID10_Q};
//   %p_ID10_Q @TEXT("D10", size=0.8, halign="start", dy=0);
//   %p_ID10_VDD=(168,-323.0);
//   &DVDD @WIRE(mode="straight") {#ID10:VDD %p_ID10_VDD};
//   %p_ID10_VDD @TEXT("DVDD", size=0.8, halign="start", dy=0.5);
//   %p_ID10_VSS=(168,-339.0);
//   &VSS @WIRE(mode="straight") {#ID10:VSS %p_ID10_VSS};
//   %p_ID10_VSS @TEXT("VSS", size=0.8, halign="start", dy=0.5);
//   #ID9 @PLACE(0,-355.0) => @ORIENT("R0");
//   %p_ID9_A=(-12,-353.0);
//   &raw9 @WIRE(mode="straight") {#ID9:A %p_ID9_A};
//   %p_ID9_A @TEXT("raw9", size=0.8, halign="end", dy=0);
//   %p_ID9_EN=(-12,-355.0);
//   &loadp @WIRE(mode="straight") {#ID9:EN %p_ID9_EN};
//   %p_ID9_EN @TEXT("loadp", size=0.8, halign="end", dy=0);
//   %p_ID9_ENB=(-12,-357.0);
//   &loadb @WIRE(mode="straight") {#ID9:ENB %p_ID9_ENB};
//   %p_ID9_ENB @TEXT("loadb", size=0.8, halign="end", dy=0);
//   %p_ID9_Q=(12,-355.0);
//   &D9 @WIRE(mode="straight") {#ID9:Q %p_ID9_Q};
//   %p_ID9_Q @TEXT("D9", size=0.8, halign="start", dy=0);
//   %p_ID9_VDD=(0,-347.0);
//   &DVDD @WIRE(mode="straight") {#ID9:VDD %p_ID9_VDD};
//   %p_ID9_VDD @TEXT("DVDD", size=0.8, halign="start", dy=0.5);
//   %p_ID9_VSS=(0,-363.0);
//   &VSS @WIRE(mode="straight") {#ID9:VSS %p_ID9_VSS};
//   %p_ID9_VSS @TEXT("VSS", size=0.8, halign="start", dy=0.5);
//   #ID8 @PLACE(42,-355.0) => @ORIENT("R0");
//   %p_ID8_A=(30,-353.0);
//   &raw8 @WIRE(mode="straight") {#ID8:A %p_ID8_A};
//   %p_ID8_A @TEXT("raw8", size=0.8, halign="end", dy=0);
//   %p_ID8_EN=(30,-355.0);
//   &loadp @WIRE(mode="straight") {#ID8:EN %p_ID8_EN};
//   %p_ID8_EN @TEXT("loadp", size=0.8, halign="end", dy=0);
//   %p_ID8_ENB=(30,-357.0);
//   &loadb @WIRE(mode="straight") {#ID8:ENB %p_ID8_ENB};
//   %p_ID8_ENB @TEXT("loadb", size=0.8, halign="end", dy=0);
//   %p_ID8_Q=(54,-355.0);
//   &D8 @WIRE(mode="straight") {#ID8:Q %p_ID8_Q};
//   %p_ID8_Q @TEXT("D8", size=0.8, halign="start", dy=0);
//   %p_ID8_VDD=(42,-347.0);
//   &DVDD @WIRE(mode="straight") {#ID8:VDD %p_ID8_VDD};
//   %p_ID8_VDD @TEXT("DVDD", size=0.8, halign="start", dy=0.5);
//   %p_ID8_VSS=(42,-363.0);
//   &VSS @WIRE(mode="straight") {#ID8:VSS %p_ID8_VSS};
//   %p_ID8_VSS @TEXT("VSS", size=0.8, halign="start", dy=0.5);
//   #ID7 @PLACE(84,-355.0) => @ORIENT("R0");
//   %p_ID7_A=(72,-353.0);
//   &raw7 @WIRE(mode="straight") {#ID7:A %p_ID7_A};
//   %p_ID7_A @TEXT("raw7", size=0.8, halign="end", dy=0);
//   %p_ID7_EN=(72,-355.0);
//   &loadp @WIRE(mode="straight") {#ID7:EN %p_ID7_EN};
//   %p_ID7_EN @TEXT("loadp", size=0.8, halign="end", dy=0);
//   %p_ID7_ENB=(72,-357.0);
//   &loadb @WIRE(mode="straight") {#ID7:ENB %p_ID7_ENB};
//   %p_ID7_ENB @TEXT("loadb", size=0.8, halign="end", dy=0);
//   %p_ID7_Q=(96,-355.0);
//   &D7 @WIRE(mode="straight") {#ID7:Q %p_ID7_Q};
//   %p_ID7_Q @TEXT("D7", size=0.8, halign="start", dy=0);
//   %p_ID7_VDD=(84,-347.0);
//   &DVDD @WIRE(mode="straight") {#ID7:VDD %p_ID7_VDD};
//   %p_ID7_VDD @TEXT("DVDD", size=0.8, halign="start", dy=0.5);
//   %p_ID7_VSS=(84,-363.0);
//   &VSS @WIRE(mode="straight") {#ID7:VSS %p_ID7_VSS};
//   %p_ID7_VSS @TEXT("VSS", size=0.8, halign="start", dy=0.5);
//   #ID6 @PLACE(126,-355.0) => @ORIENT("R0");
//   %p_ID6_A=(114,-353.0);
//   &raw6 @WIRE(mode="straight") {#ID6:A %p_ID6_A};
//   %p_ID6_A @TEXT("raw6", size=0.8, halign="end", dy=0);
//   %p_ID6_EN=(114,-355.0);
//   &loadp @WIRE(mode="straight") {#ID6:EN %p_ID6_EN};
//   %p_ID6_EN @TEXT("loadp", size=0.8, halign="end", dy=0);
//   %p_ID6_ENB=(114,-357.0);
//   &loadb @WIRE(mode="straight") {#ID6:ENB %p_ID6_ENB};
//   %p_ID6_ENB @TEXT("loadb", size=0.8, halign="end", dy=0);
//   %p_ID6_Q=(138,-355.0);
//   &D6 @WIRE(mode="straight") {#ID6:Q %p_ID6_Q};
//   %p_ID6_Q @TEXT("D6", size=0.8, halign="start", dy=0);
//   %p_ID6_VDD=(126,-347.0);
//   &DVDD @WIRE(mode="straight") {#ID6:VDD %p_ID6_VDD};
//   %p_ID6_VDD @TEXT("DVDD", size=0.8, halign="start", dy=0.5);
//   %p_ID6_VSS=(126,-363.0);
//   &VSS @WIRE(mode="straight") {#ID6:VSS %p_ID6_VSS};
//   %p_ID6_VSS @TEXT("VSS", size=0.8, halign="start", dy=0.5);
//   #ID5 @PLACE(168,-355.0) => @ORIENT("R0");
//   %p_ID5_A=(156,-353.0);
//   &raw5 @WIRE(mode="straight") {#ID5:A %p_ID5_A};
//   %p_ID5_A @TEXT("raw5", size=0.8, halign="end", dy=0);
//   %p_ID5_EN=(156,-355.0);
//   &loadp @WIRE(mode="straight") {#ID5:EN %p_ID5_EN};
//   %p_ID5_EN @TEXT("loadp", size=0.8, halign="end", dy=0);
//   %p_ID5_ENB=(156,-357.0);
//   &loadb @WIRE(mode="straight") {#ID5:ENB %p_ID5_ENB};
//   %p_ID5_ENB @TEXT("loadb", size=0.8, halign="end", dy=0);
//   %p_ID5_Q=(180,-355.0);
//   &D5 @WIRE(mode="straight") {#ID5:Q %p_ID5_Q};
//   %p_ID5_Q @TEXT("D5", size=0.8, halign="start", dy=0);
//   %p_ID5_VDD=(168,-347.0);
//   &DVDD @WIRE(mode="straight") {#ID5:VDD %p_ID5_VDD};
//   %p_ID5_VDD @TEXT("DVDD", size=0.8, halign="start", dy=0.5);
//   %p_ID5_VSS=(168,-363.0);
//   &VSS @WIRE(mode="straight") {#ID5:VSS %p_ID5_VSS};
//   %p_ID5_VSS @TEXT("VSS", size=0.8, halign="start", dy=0.5);
//   #ID4 @PLACE(0,-379.0) => @ORIENT("R0");
//   %p_ID4_A=(-12,-377.0);
//   &raw4 @WIRE(mode="straight") {#ID4:A %p_ID4_A};
//   %p_ID4_A @TEXT("raw4", size=0.8, halign="end", dy=0);
//   %p_ID4_EN=(-12,-379.0);
//   &loadp @WIRE(mode="straight") {#ID4:EN %p_ID4_EN};
//   %p_ID4_EN @TEXT("loadp", size=0.8, halign="end", dy=0);
//   %p_ID4_ENB=(-12,-381.0);
//   &loadb @WIRE(mode="straight") {#ID4:ENB %p_ID4_ENB};
//   %p_ID4_ENB @TEXT("loadb", size=0.8, halign="end", dy=0);
//   %p_ID4_Q=(12,-379.0);
//   &D4 @WIRE(mode="straight") {#ID4:Q %p_ID4_Q};
//   %p_ID4_Q @TEXT("D4", size=0.8, halign="start", dy=0);
//   %p_ID4_VDD=(0,-371.0);
//   &DVDD @WIRE(mode="straight") {#ID4:VDD %p_ID4_VDD};
//   %p_ID4_VDD @TEXT("DVDD", size=0.8, halign="start", dy=0.5);
//   %p_ID4_VSS=(0,-387.0);
//   &VSS @WIRE(mode="straight") {#ID4:VSS %p_ID4_VSS};
//   %p_ID4_VSS @TEXT("VSS", size=0.8, halign="start", dy=0.5);
//   #ID3 @PLACE(42,-379.0) => @ORIENT("R0");
//   %p_ID3_A=(30,-377.0);
//   &raw3 @WIRE(mode="straight") {#ID3:A %p_ID3_A};
//   %p_ID3_A @TEXT("raw3", size=0.8, halign="end", dy=0);
//   %p_ID3_EN=(30,-379.0);
//   &loadp @WIRE(mode="straight") {#ID3:EN %p_ID3_EN};
//   %p_ID3_EN @TEXT("loadp", size=0.8, halign="end", dy=0);
//   %p_ID3_ENB=(30,-381.0);
//   &loadb @WIRE(mode="straight") {#ID3:ENB %p_ID3_ENB};
//   %p_ID3_ENB @TEXT("loadb", size=0.8, halign="end", dy=0);
//   %p_ID3_Q=(54,-379.0);
//   &D3 @WIRE(mode="straight") {#ID3:Q %p_ID3_Q};
//   %p_ID3_Q @TEXT("D3", size=0.8, halign="start", dy=0);
//   %p_ID3_VDD=(42,-371.0);
//   &DVDD @WIRE(mode="straight") {#ID3:VDD %p_ID3_VDD};
//   %p_ID3_VDD @TEXT("DVDD", size=0.8, halign="start", dy=0.5);
//   %p_ID3_VSS=(42,-387.0);
//   &VSS @WIRE(mode="straight") {#ID3:VSS %p_ID3_VSS};
//   %p_ID3_VSS @TEXT("VSS", size=0.8, halign="start", dy=0.5);
//   #ID2 @PLACE(84,-379.0) => @ORIENT("R0");
//   %p_ID2_A=(72,-377.0);
//   &raw2 @WIRE(mode="straight") {#ID2:A %p_ID2_A};
//   %p_ID2_A @TEXT("raw2", size=0.8, halign="end", dy=0);
//   %p_ID2_EN=(72,-379.0);
//   &loadp @WIRE(mode="straight") {#ID2:EN %p_ID2_EN};
//   %p_ID2_EN @TEXT("loadp", size=0.8, halign="end", dy=0);
//   %p_ID2_ENB=(72,-381.0);
//   &loadb @WIRE(mode="straight") {#ID2:ENB %p_ID2_ENB};
//   %p_ID2_ENB @TEXT("loadb", size=0.8, halign="end", dy=0);
//   %p_ID2_Q=(96,-379.0);
//   &D2 @WIRE(mode="straight") {#ID2:Q %p_ID2_Q};
//   %p_ID2_Q @TEXT("D2", size=0.8, halign="start", dy=0);
//   %p_ID2_VDD=(84,-371.0);
//   &DVDD @WIRE(mode="straight") {#ID2:VDD %p_ID2_VDD};
//   %p_ID2_VDD @TEXT("DVDD", size=0.8, halign="start", dy=0.5);
//   %p_ID2_VSS=(84,-387.0);
//   &VSS @WIRE(mode="straight") {#ID2:VSS %p_ID2_VSS};
//   %p_ID2_VSS @TEXT("VSS", size=0.8, halign="start", dy=0.5);
//   #ID1 @PLACE(126,-379.0) => @ORIENT("R0");
//   %p_ID1_A=(114,-377.0);
//   &raw1 @WIRE(mode="straight") {#ID1:A %p_ID1_A};
//   %p_ID1_A @TEXT("raw1", size=0.8, halign="end", dy=0);
//   %p_ID1_EN=(114,-379.0);
//   &loadp @WIRE(mode="straight") {#ID1:EN %p_ID1_EN};
//   %p_ID1_EN @TEXT("loadp", size=0.8, halign="end", dy=0);
//   %p_ID1_ENB=(114,-381.0);
//   &loadb @WIRE(mode="straight") {#ID1:ENB %p_ID1_ENB};
//   %p_ID1_ENB @TEXT("loadb", size=0.8, halign="end", dy=0);
//   %p_ID1_Q=(138,-379.0);
//   &D1 @WIRE(mode="straight") {#ID1:Q %p_ID1_Q};
//   %p_ID1_Q @TEXT("D1", size=0.8, halign="start", dy=0);
//   %p_ID1_VDD=(126,-371.0);
//   &DVDD @WIRE(mode="straight") {#ID1:VDD %p_ID1_VDD};
//   %p_ID1_VDD @TEXT("DVDD", size=0.8, halign="start", dy=0.5);
//   %p_ID1_VSS=(126,-387.0);
//   &VSS @WIRE(mode="straight") {#ID1:VSS %p_ID1_VSS};
//   %p_ID1_VSS @TEXT("VSS", size=0.8, halign="start", dy=0.5);
//   #ID0 @PLACE(168,-379.0) => @ORIENT("R0");
//   %p_ID0_A=(156,-377.0);
//   &raw0 @WIRE(mode="straight") {#ID0:A %p_ID0_A};
//   %p_ID0_A @TEXT("raw0", size=0.8, halign="end", dy=0);
//   %p_ID0_EN=(156,-379.0);
//   &loadp @WIRE(mode="straight") {#ID0:EN %p_ID0_EN};
//   %p_ID0_EN @TEXT("loadp", size=0.8, halign="end", dy=0);
//   %p_ID0_ENB=(156,-381.0);
//   &loadb @WIRE(mode="straight") {#ID0:ENB %p_ID0_ENB};
//   %p_ID0_ENB @TEXT("loadb", size=0.8, halign="end", dy=0);
//   %p_ID0_Q=(180,-379.0);
//   &D0 @WIRE(mode="straight") {#ID0:Q %p_ID0_Q};
//   %p_ID0_Q @TEXT("D0", size=0.8, halign="start", dy=0);
//   %p_ID0_VDD=(168,-371.0);
//   &DVDD @WIRE(mode="straight") {#ID0:VDD %p_ID0_VDD};
//   %p_ID0_VDD @TEXT("DVDD", size=0.8, halign="start", dy=0.5);
//   %p_ID0_VSS=(168,-387.0);
//   &VSS @WIRE(mode="straight") {#ID0:VSS %p_ID0_VSS};
//   %p_ID0_VSS @TEXT("VSS", size=0.8, halign="start", dy=0.5);
//   #IRWB @PLACE(0,-402.0) => @ORIENT("R0");
//   %p_IRWB_A=(-12,-402.0);
//   &cv_resetwait @WIRE(mode="straight") {#IRWB:A %p_IRWB_A};
//   %p_IRWB_A @TEXT("cv_resetwait", size=0.8, halign="end", dy=0);
//   %p_IRWB_Y=(12,-402.0);
//   &cv_resetwaitb @WIRE(mode="straight") {#IRWB:Y %p_IRWB_Y};
//   %p_IRWB_Y @TEXT("cv_resetwaitb", size=0.8, halign="start", dy=0);
//   %p_IRWB_VDD=(0,-396.0);
//   &DVDD @WIRE(mode="straight") {#IRWB:VDD %p_IRWB_VDD};
//   %p_IRWB_VDD @TEXT("DVDD", size=0.8, halign="start", dy=0.5);
//   %p_IRWB_VSS=(0,-408.0);
//   &VSS @WIRE(mode="straight") {#IRWB:VSS %p_IRWB_VSS};
//   %p_IRWB_VSS @TEXT("VSS", size=0.8, halign="start", dy=0.5);
//   #IRSTP @PLACE(42,-402.0) => @ORIENT("R0");
//   %p_IRSTP_A=(30,-401.0);
//   &cv @WIRE(mode="straight") {#IRSTP:A %p_IRSTP_A};
//   %p_IRSTP_A @TEXT("cv", size=0.8, halign="end", dy=0);
//   %p_IRSTP_B=(30,-403.0);
//   &cv_resetwaitb @WIRE(mode="straight") {#IRSTP:B %p_IRSTP_B};
//   %p_IRSTP_B @TEXT("cv_resetwaitb", size=0.8, halign="end", dy=0);
//   %p_IRSTP_Y=(54,-402.0);
//   &beginpulse @WIRE(mode="straight") {#IRSTP:Y %p_IRSTP_Y};
//   %p_IRSTP_Y @TEXT("beginpulse", size=0.8, halign="start", dy=0);
//   %p_IRSTP_VDD=(42,-395.0);
//   &DVDD @WIRE(mode="straight") {#IRSTP:VDD %p_IRSTP_VDD};
//   %p_IRSTP_VDD @TEXT("DVDD", size=0.8, halign="start", dy=0.5);
//   %p_IRSTP_VSS=(42,-409.0);
//   &VSS @WIRE(mode="straight") {#IRSTP:VSS %p_IRSTP_VSS};
//   %p_IRSTP_VSS @TEXT("VSS", size=0.8, halign="start", dy=0.5);
//   #IDONE @PLACE(84,-402.0) => @ORIENT("R0");
//   %p_IDONE_A=(72,-401.0);
//   &eoc @WIRE(mode="straight") {#IDONE:A %p_IDONE_A};
//   %p_IDONE_A @TEXT("eoc", size=0.8, halign="end", dy=0);
//   %p_IDONE_B=(72,-403.0);
//   &abort @WIRE(mode="straight") {#IDONE:B %p_IDONE_B};
//   %p_IDONE_B @TEXT("abort", size=0.8, halign="end", dy=0);
//   %p_IDONE_Y=(96,-402.0);
//   &committed @WIRE(mode="straight") {#IDONE:Y %p_IDONE_Y};
//   %p_IDONE_Y @TEXT("committed", size=0.8, halign="start", dy=0);
//   %p_IDONE_VDD=(84,-395.0);
//   &DVDD @WIRE(mode="straight") {#IDONE:VDD %p_IDONE_VDD};
//   %p_IDONE_VDD @TEXT("DVDD", size=0.8, halign="start", dy=0.5);
//   %p_IDONE_VSS=(84,-409.0);
//   &VSS @WIRE(mode="straight") {#IDONE:VSS %p_IDONE_VSS};
//   %p_IDONE_VSS @TEXT("VSS", size=0.8, halign="start", dy=0.5);
//   #ICOMMIT @PLACE(126,-402.0) => @ORIENT("R0");
//   %p_ICOMMIT_S=(114,-401.0);
//   &committed @WIRE(mode="straight") {#ICOMMIT:S %p_ICOMMIT_S};
//   %p_ICOMMIT_S @TEXT("committed", size=0.8, halign="end", dy=0);
//   %p_ICOMMIT_R=(114,-403.0);
//   &beginpulse @WIRE(mode="straight") {#ICOMMIT:R %p_ICOMMIT_R};
//   %p_ICOMMIT_R @TEXT("beginpulse", size=0.8, halign="end", dy=0);
//   %p_ICOMMIT_Q=(138,-401.0);
//   &complete @WIRE(mode="straight") {#ICOMMIT:Q %p_ICOMMIT_Q};
//   %p_ICOMMIT_Q @TEXT("complete", size=0.8, halign="start", dy=0);
//   %p_ICOMMIT_QB=(138,-403.0);
//   &completeb @WIRE(mode="straight") {#ICOMMIT:QB %p_ICOMMIT_QB};
//   %p_ICOMMIT_QB @TEXT("completeb", size=0.8, halign="start", dy=0);
//   %p_ICOMMIT_VDD=(126,-395.0);
//   &DVDD @WIRE(mode="straight") {#ICOMMIT:VDD %p_ICOMMIT_VDD};
//   %p_ICOMMIT_VDD @TEXT("DVDD", size=0.8, halign="start", dy=0.5);
//   %p_ICOMMIT_VSS=(126,-409.0);
//   &VSS @WIRE(mode="straight") {#ICOMMIT:VSS %p_ICOMMIT_VSS};
//   %p_ICOMMIT_VSS @TEXT("VSS", size=0.8, halign="start", dy=0.5);
//   #IRD0 @TEXT("cw=ready_load", key="sizing", dy=-8.0, size=0.7);
//   #IRD0 @PLACE(168,-402.0) => @ORIENT("R0");
//   %p_IRD0_A=(156,-402.0);
//   &complete @WIRE(mode="straight") {#IRD0:A %p_IRD0_A};
//   %p_IRD0_A @TEXT("complete", size=0.8, halign="end", dy=0);
//   %p_IRD0_Y=(180,-402.0);
//   &rdywait0 @WIRE(mode="straight") {#IRD0:Y %p_IRD0_Y};
//   %p_IRD0_Y @TEXT("rdywait0", size=0.8, halign="start", dy=0);
//   %p_IRD0_VDD=(168,-396.0);
//   &DVDD @WIRE(mode="straight") {#IRD0:VDD %p_IRD0_VDD};
//   %p_IRD0_VDD @TEXT("DVDD", size=0.8, halign="start", dy=0.5);
//   %p_IRD0_VSS=(168,-408.0);
//   &VSS @WIRE(mode="straight") {#IRD0:VSS %p_IRD0_VSS};
//   %p_IRD0_VSS @TEXT("VSS", size=0.8, halign="start", dy=0.5);
//   #IRD1 @TEXT("cw=ready_load", key="sizing", dy=-8.0, size=0.7);
//   #IRD1 @PLACE(0,-424.0) => @ORIENT("R0");
//   %p_IRD1_A=(-12,-424.0);
//   &rdywait0 @WIRE(mode="straight") {#IRD1:A %p_IRD1_A};
//   %p_IRD1_A @TEXT("rdywait0", size=0.8, halign="end", dy=0);
//   %p_IRD1_Y=(12,-424.0);
//   &rdywait1 @WIRE(mode="straight") {#IRD1:Y %p_IRD1_Y};
//   %p_IRD1_Y @TEXT("rdywait1", size=0.8, halign="start", dy=0);
//   %p_IRD1_VDD=(0,-418.0);
//   &DVDD @WIRE(mode="straight") {#IRD1:VDD %p_IRD1_VDD};
//   %p_IRD1_VDD @TEXT("DVDD", size=0.8, halign="start", dy=0.5);
//   %p_IRD1_VSS=(0,-430.0);
//   &VSS @WIRE(mode="straight") {#IRD1:VSS %p_IRD1_VSS};
//   %p_IRD1_VSS @TEXT("VSS", size=0.8, halign="start", dy=0.5);
//   #IRD2 @TEXT("cw=ready_load", key="sizing", dy=-8.0, size=0.7);
//   #IRD2 @PLACE(42,-424.0) => @ORIENT("R0");
//   %p_IRD2_A=(30,-424.0);
//   &rdywait1 @WIRE(mode="straight") {#IRD2:A %p_IRD2_A};
//   %p_IRD2_A @TEXT("rdywait1", size=0.8, halign="end", dy=0);
//   %p_IRD2_Y=(54,-424.0);
//   &rdywait2 @WIRE(mode="straight") {#IRD2:Y %p_IRD2_Y};
//   %p_IRD2_Y @TEXT("rdywait2", size=0.8, halign="start", dy=0);
//   %p_IRD2_VDD=(42,-418.0);
//   &DVDD @WIRE(mode="straight") {#IRD2:VDD %p_IRD2_VDD};
//   %p_IRD2_VDD @TEXT("DVDD", size=0.8, halign="start", dy=0.5);
//   %p_IRD2_VSS=(42,-430.0);
//   &VSS @WIRE(mode="straight") {#IRD2:VSS %p_IRD2_VSS};
//   %p_IRD2_VSS @TEXT("VSS", size=0.8, halign="start", dy=0.5);
//   #IRD3 @TEXT("cw=ready_load", key="sizing", dy=-8.0, size=0.7);
//   #IRD3 @PLACE(84,-424.0) => @ORIENT("R0");
//   %p_IRD3_A=(72,-424.0);
//   &rdywait2 @WIRE(mode="straight") {#IRD3:A %p_IRD3_A};
//   %p_IRD3_A @TEXT("rdywait2", size=0.8, halign="end", dy=0);
//   %p_IRD3_Y=(96,-424.0);
//   &rdywait3 @WIRE(mode="straight") {#IRD3:Y %p_IRD3_Y};
//   %p_IRD3_Y @TEXT("rdywait3", size=0.8, halign="start", dy=0);
//   %p_IRD3_VDD=(84,-418.0);
//   &DVDD @WIRE(mode="straight") {#IRD3:VDD %p_IRD3_VDD};
//   %p_IRD3_VDD @TEXT("DVDD", size=0.8, halign="start", dy=0.5);
//   %p_IRD3_VSS=(84,-430.0);
//   &VSS @WIRE(mode="straight") {#IRD3:VSS %p_IRD3_VSS};
//   %p_IRD3_VSS @TEXT("VSS", size=0.8, halign="start", dy=0.5);
//   #IRD4 @TEXT("cw=ready_load", key="sizing", dy=-8.0, size=0.7);
//   #IRD4 @PLACE(126,-424.0) => @ORIENT("R0");
//   %p_IRD4_A=(114,-424.0);
//   &rdywait3 @WIRE(mode="straight") {#IRD4:A %p_IRD4_A};
//   %p_IRD4_A @TEXT("rdywait3", size=0.8, halign="end", dy=0);
//   %p_IRD4_Y=(138,-424.0);
//   &rdywait4 @WIRE(mode="straight") {#IRD4:Y %p_IRD4_Y};
//   %p_IRD4_Y @TEXT("rdywait4", size=0.8, halign="start", dy=0);
//   %p_IRD4_VDD=(126,-418.0);
//   &DVDD @WIRE(mode="straight") {#IRD4:VDD %p_IRD4_VDD};
//   %p_IRD4_VDD @TEXT("DVDD", size=0.8, halign="start", dy=0.5);
//   %p_IRD4_VSS=(126,-430.0);
//   &VSS @WIRE(mode="straight") {#IRD4:VSS %p_IRD4_VSS};
//   %p_IRD4_VSS @TEXT("VSS", size=0.8, halign="start", dy=0.5);
//   #IRDS @PLACE(168,-424.0) => @ORIENT("R0");
//   %p_IRDS_A=(156,-423.0);
//   &rdywait4 @WIRE(mode="straight") {#IRDS:A %p_IRDS_A};
//   %p_IRDS_A @TEXT("rdywait4", size=0.8, halign="end", dy=0);
//   %p_IRDS_B=(156,-425.0);
//   &complete @WIRE(mode="straight") {#IRDS:B %p_IRDS_B};
//   %p_IRDS_B @TEXT("complete", size=0.8, halign="end", dy=0);
//   %p_IRDS_Y=(180,-424.0);
//   &setready @WIRE(mode="straight") {#IRDS:Y %p_IRDS_Y};
//   %p_IRDS_Y @TEXT("setready", size=0.8, halign="start", dy=0);
//   %p_IRDS_VDD=(168,-417.0);
//   &DVDD @WIRE(mode="straight") {#IRDS:VDD %p_IRDS_VDD};
//   %p_IRDS_VDD @TEXT("DVDD", size=0.8, halign="start", dy=0.5);
//   %p_IRDS_VSS=(168,-431.0);
//   &VSS @WIRE(mode="straight") {#IRDS:VSS %p_IRDS_VSS};
//   %p_IRDS_VSS @TEXT("VSS", size=0.8, halign="start", dy=0.5);
//   #IRDY @PLACE(0,-446.0) => @ORIENT("R0");
//   %p_IRDY_S=(-12,-445.0);
//   &setready @WIRE(mode="straight") {#IRDY:S %p_IRDY_S};
//   %p_IRDY_S @TEXT("setready", size=0.8, halign="end", dy=0);
//   %p_IRDY_R=(-12,-447.0);
//   &beginpulse @WIRE(mode="straight") {#IRDY:R %p_IRDY_R};
//   %p_IRDY_R @TEXT("beginpulse", size=0.8, halign="end", dy=0);
//   %p_IRDY_Q=(12,-445.0);
//   &ready @WIRE(mode="straight") {#IRDY:Q %p_IRDY_Q};
//   %p_IRDY_Q @TEXT("ready", size=0.8, halign="start", dy=0);
//   %p_IRDY_QB=(12,-447.0);
//   &readyb @WIRE(mode="straight") {#IRDY:QB %p_IRDY_QB};
//   %p_IRDY_QB @TEXT("readyb", size=0.8, halign="start", dy=0);
//   %p_IRDY_VDD=(0,-439.0);
//   &DVDD @WIRE(mode="straight") {#IRDY:VDD %p_IRDY_VDD};
//   %p_IRDY_VDD @TEXT("DVDD", size=0.8, halign="start", dy=0.5);
//   %p_IRDY_VSS=(0,-453.0);
//   &VSS @WIRE(mode="straight") {#IRDY:VSS %p_IRDY_VSS};
//   %p_IRDY_VSS @TEXT("VSS", size=0.8, halign="start", dy=0.5);
//   #IRDB @TEXT("drive=4", key="sizing", dy=-8.0, size=0.7);
//   #IRDB @PLACE(42,-446.0) => @ORIENT("R0");
//   %p_IRDB_A=(30,-446.0);
//   &ready @WIRE(mode="straight") {#IRDB:A %p_IRDB_A};
//   %p_IRDB_A @TEXT("ready", size=0.8, halign="end", dy=0);
//   %p_IRDB_Y=(54,-446.0);
//   &RDY @WIRE(mode="straight") {#IRDB:Y %p_IRDB_Y};
//   %p_IRDB_Y @TEXT("RDY", size=0.8, halign="start", dy=0);
//   %p_IRDB_VDD=(42,-440.0);
//   &DVDD @WIRE(mode="straight") {#IRDB:VDD %p_IRDB_VDD};
//   %p_IRDB_VDD @TEXT("DVDD", size=0.8, halign="start", dy=0.5);
//   %p_IRDB_VSS=(42,-452.0);
//   &VSS @WIRE(mode="straight") {#IRDB:VSS %p_IRDB_VSS};
//   %p_IRDB_VSS @TEXT("VSS", size=0.8, halign="start", dy=0.5);
//   {#ICV #ICB #IP #IN #IAB0 #IAB1 #IAB2 #IAB3 #IACB #IAP #IRC0 #IRC1 #IRC2 #IRC3 #IRC4 #IRC5 #IRB #IST0 #IST1 #IS1 #IS2 #IS3 #IS4 #IS5 #IS6 #IS7 #IS8 #IS9 #IS10 #IS11 #IS12 #IS13 #IS14 #IR0 #IR1 #IR2 #IR3 #IR4 #IR5 #IR6 #IRA #IRZ #IROR #IFB #ICKH #IT0 #IT1 #IT2 #IT3 #IT4 #IT5 #IT6 #IT7 #IT8 #IT9 #IT10 #IT11 #IT12 #IT13 #IT14 #IT15 #ITO #IEOC #IENREG #ILBUF #ILBAR #ID13 #ID12 #ID11 #ID10 #ID9 #ID8 #ID7 #ID6 #ID5 #ID4 #ID3 #ID2 #ID1 #ID0 #IRWB #IRSTP #IDONE #ICOMMIT #IRD0 #IRD1 #IRD2 #IRD3 #IRD4 #IRDS #IRDY #IRDB} @GROUP;
//   {&CONV &OUTP &OUTN &CLKC &UP12 &UP11 &UP10 &UP9 &UP8 &UP7 &UP6 &UP5 &UP4 &UP3 &UP2 &UP1 &UP0 &DN12 &DN11 &DN10 &DN9 &DN8 &DN7 &DN6 &DN5 &DN4 &DN3 &DN2 &DN1 &DN0 &D13 &D12 &D11 &D10 &D9 &D8 &D7 &D6 &D5 &D4 &D3 &D2 &D1 &D0 &RDY &DVDD &VSS} @REMOVE-FROM $PORT_FILL_SET;
//   %port0=$IO_PORT @ATTACH &CONV => @PLACE(-28,0) => @ORIENT("R0");
//   %port1=$IO_PORT @ATTACH &OUTP => @PLACE(-28,-3) => @ORIENT("R0");
//   %port2=$IO_PORT @ATTACH &OUTN => @PLACE(-28,-6) => @ORIENT("R0");
//   %port3=$IO_PORT @ATTACH &CLKC => @PLACE(-28,-9) => @ORIENT("R0");
//   %port4=$IO_PORT @ATTACH &UP12 => @PLACE(-28,-12) => @ORIENT("R0");
//   %port5=$IO_PORT @ATTACH &UP11 => @PLACE(-28,-15) => @ORIENT("R0");
//   %port6=$IO_PORT @ATTACH &UP10 => @PLACE(-28,-18) => @ORIENT("R0");
//   %port7=$IO_PORT @ATTACH &UP9 => @PLACE(-28,-21) => @ORIENT("R0");
//   %port8=$IO_PORT @ATTACH &UP8 => @PLACE(-28,-24) => @ORIENT("R0");
//   %port9=$IO_PORT @ATTACH &UP7 => @PLACE(-28,-27) => @ORIENT("R0");
//   %port10=$IO_PORT @ATTACH &UP6 => @PLACE(-28,-30) => @ORIENT("R0");
//   %port11=$IO_PORT @ATTACH &UP5 => @PLACE(-28,-33) => @ORIENT("R0");
//   %port12=$IO_PORT @ATTACH &UP4 => @PLACE(-28,-36) => @ORIENT("R0");
//   %port13=$IO_PORT @ATTACH &UP3 => @PLACE(-28,-39) => @ORIENT("R0");
//   %port14=$IO_PORT @ATTACH &UP2 => @PLACE(-28,-42) => @ORIENT("R0");
//   %port15=$IO_PORT @ATTACH &UP1 => @PLACE(-28,-45) => @ORIENT("R0");
//   %port16=$IO_PORT @ATTACH &UP0 => @PLACE(-28,-48) => @ORIENT("R0");
//   %port17=$IO_PORT @ATTACH &DN12 => @PLACE(-28,-51) => @ORIENT("R0");
//   %port18=$IO_PORT @ATTACH &DN11 => @PLACE(-28,-54) => @ORIENT("R0");
//   %port19=$IO_PORT @ATTACH &DN10 => @PLACE(-28,-57) => @ORIENT("R0");
//   %port20=$IO_PORT @ATTACH &DN9 => @PLACE(-28,-60) => @ORIENT("R0");
//   %port21=$IO_PORT @ATTACH &DN8 => @PLACE(-28,-63) => @ORIENT("R0");
//   %port22=$IO_PORT @ATTACH &DN7 => @PLACE(-28,-66) => @ORIENT("R0");
//   %port23=$IO_PORT @ATTACH &DN6 => @PLACE(-28,-69) => @ORIENT("R0");
//   %port24=$IO_PORT @ATTACH &DN5 => @PLACE(-28,-72) => @ORIENT("R0");
//   %port25=$IO_PORT @ATTACH &DN4 => @PLACE(-28,-75) => @ORIENT("R0");
//   %port26=$IO_PORT @ATTACH &DN3 => @PLACE(-28,-78) => @ORIENT("R0");
//   %port27=$IO_PORT @ATTACH &DN2 => @PLACE(-28,-81) => @ORIENT("R0");
//   %port28=$IO_PORT @ATTACH &DN1 => @PLACE(-28,-84) => @ORIENT("R0");
//   %port29=$IO_PORT @ATTACH &DN0 => @PLACE(-28,-87) => @ORIENT("R0");
//   %port30=$IO_PORT @ATTACH &D13 => @PLACE(-28,-90) => @ORIENT("R0");
//   %port31=$IO_PORT @ATTACH &D12 => @PLACE(-28,-93) => @ORIENT("R0");
//   %port32=$IO_PORT @ATTACH &D11 => @PLACE(-28,-96) => @ORIENT("R0");
//   %port33=$IO_PORT @ATTACH &D10 => @PLACE(-28,-99) => @ORIENT("R0");
//   %port34=$IO_PORT @ATTACH &D9 => @PLACE(-28,-102) => @ORIENT("R0");
//   %port35=$IO_PORT @ATTACH &D8 => @PLACE(-28,-105) => @ORIENT("R0");
//   %port36=$IO_PORT @ATTACH &D7 => @PLACE(-28,-108) => @ORIENT("R0");
//   %port37=$IO_PORT @ATTACH &D6 => @PLACE(-28,-111) => @ORIENT("R0");
//   %port38=$IO_PORT @ATTACH &D5 => @PLACE(-28,-114) => @ORIENT("R0");
//   %port39=$IO_PORT @ATTACH &D4 => @PLACE(-28,-117) => @ORIENT("R0");
//   %port40=$IO_PORT @ATTACH &D3 => @PLACE(-28,-120) => @ORIENT("R0");
//   %port41=$IO_PORT @ATTACH &D2 => @PLACE(-28,-123) => @ORIENT("R0");
//   %port42=$IO_PORT @ATTACH &D1 => @PLACE(-28,-126) => @ORIENT("R0");
//   %port43=$IO_PORT @ATTACH &D0 => @PLACE(-28,-129) => @ORIENT("R0");
//   %port44=$IO_PORT @ATTACH &RDY => @PLACE(-28,-132) => @ORIENT("R0");
//   %port45=$IO_PORT @ATTACH &DVDD => @PLACE(-28,-135) => @ORIENT("R0");
//   %port46=$IO_PORT @ATTACH &VSS => @PLACE(-28,-138) => @ORIENT("R0");
//   (-28,24) @TEXT("adc_sarlogic", size=1.2, bold=true);
//   (-28,20) @TEXT("14-decision asynchronous SAR, 13 split-CDAC updates, parallel output storage and persistent RDY.", size=0.7);
//   (-28,16) @TEXT("Defaults: wait_fast=400n wait_slow=9400n extra3=1800n extra456=6u extra9=8u timer_load=1400n reset_load=3u start_load=3600n ready_load=5u", size=0.8);
// }
ends adc_sarlogic
