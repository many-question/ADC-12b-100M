// adc_clkgen transistor view: static CMOS, loaded-output interlocks.
// @RNL(type="header") {
//   @VERSION("0.3");
//   @USE-PACKAGE(name="adc28", version="0.1", path="../../../rnl/adc28.rnl");
// }
simulator lang=spectre

// Sizes are total channel widths; each device's finger count is explicit.
// Primitive-cell schematics and top-level routing below are manually authored.
subckt adc_clkgen_inv (A Y VDD VSS)
parameters wn=400n wp=600n ln=30n lp=30n nn=2 np=2
MN (Y A VSS VSS) nch_ulvt_mac w=wn l=ln nf=nn
MP (Y A VDD VDD) pch_ulvt_mac w=wp l=lp nf=np
// @RNL {
//   &VDD @ADD-TO $SUPPLY_NET_SET;
//   &VSS @ADD-TO $GROUND_NET_SET;
//   {#MN #MP} @GROUP;
//   #MP @PLACE(0,4) => @ORIENT("R0");
//   #MN @PLACE(0,-4) => @ORIENT("R0");
//   %ga=(-6,0); %out=(0,0); %vp=(0,10); %vn=(0,-10);
//   $JUNCTION @ATTACH %ga; $JUNCTION @ATTACH %out;
//   %a=$IO_PORT @ATTACH &A => @PLACE(-12,0) => @ORIENT("R0");
//   %y=$IO_PORT @ATTACH &Y => @PLACE(9,0) => @ORIENT("MY");
//   %v=$SUPPLY @ATTACH &VDD => @PLACE(0,12);
//   %g=$GROUND @ATTACH &VSS => @PLACE(0,-12);
//   &A @WIRE {%a:p %ga};
//   &A @WIRE {#MP:g (-6,4) %ga (-6,-4) #MN:g};
//   &Y @WIRE {#MP:d %out #MN:d};
//   &Y @WIRE {%out %y:p};
//   &VDD @WIRE {#MP:s %vp %v:p};
//   &VDD @WIRE {#MP:b (4,4) (4,10) %vp};
//   &VSS @WIRE {#MN:s %vn %g:p};
//   &VSS @WIRE {#MN:b (4,-4) (4,-10) %vn};
//   {#MN #MP} @TEXT("W=${w}, L=${l}, nf=${nf}", key="size", dx=6, dy=1, size=0.55);
//   (-12,16) @TEXT("Static CMOS inverter; explicit bulk ties", halign="start") => @SET-STYLE $title_style;
// }
// @RNL {
//   %symbol = @DEFINE-SYMBOL(box=[-5, -4, 5, 4]) {
//     @RECTANGLE {(-3.5,-2.5) (3.5,2.5)};
//     (-5,0) @PIN(terminal="A", direction="left");
//     @LINE {(-5,0) (-3.5,0)};
//     (5,0) @PIN(terminal="Y", direction="right");
//     @LINE {(3.5,0) (5,0)};
//     (0,4) @PIN(terminal="VDD", direction="up");
//     @LINE {(0,2.5) (0,4)};
//     (0,-4) @PIN(terminal="VSS", direction="down");
//     @LINE {(0,-2.5) (0,-4)};
//     (0,0.8) @TEXT("INV", size=0.65, halign="middle");
//     ? @TEXT("${wn}/${wp}", key="sizes", size=0.5, halign="middle") => @PLACE(0,-1.4);
//     ? @TEXT("${name}", key="name", size=0.6, halign="start") => @PLACE(-4,4.8);
//   };
//   # @SET-SYMBOL %symbol;
// }
ends adc_clkgen_inv

subckt adc_clkgen_nand2 (A B Y VDD VSS)
parameters wn=800n wp=600n nn=2 np=2
MNA (Y B nx VSS) nch_ulvt_mac w=wn l=30n nf=nn
MNB (nx A VSS VSS) nch_ulvt_mac w=wn l=30n nf=nn
MPA (Y A VDD VDD) pch_ulvt_mac w=wp l=30n nf=np
MPB (Y B VDD VDD) pch_ulvt_mac w=wp l=30n nf=np
// @RNL {
//   &VDD @ADD-TO $SUPPLY_NET_SET;
//   &VSS @ADD-TO $GROUND_NET_SET;
//   {#MNA #MNB} @AS $MATCHED;
//   {#MPA #MPB} @AS $MATCHED;
//   {#MNA #MNB #MPA #MPB} @GROUP;
//   #MPA @PLACE(-4,6) => @ORIENT("R0");
//   #MPB @PLACE(6,6) => @ORIENT("R0");
//   #MNA @PLACE(0,-2) => @ORIENT("R0");
//   #MNB @PLACE(0,-10) => @ORIENT("R0");
//   %a=$IO_PORT @ATTACH &A => @PLACE(-17,6) => @ORIENT("R0");
//   %b=$IO_PORT @ATTACH &B => @PLACE(-17,-2) => @ORIENT("R0");
//   %y=$IO_PORT @ATTACH &Y => @PLACE(16,4) => @ORIENT("MY");
//   %v=$SUPPLY @ATTACH &VDD => @PLACE(0,16);
//   %g=$GROUND @ATTACH &VSS => @PLACE(0,-18);
//   %a1=(-10,6); %b1=(-12,-2); %y1=(0,4); %v1=(-4,13); %v2=(6,13); %g1=(0,-16); %g2=(10,-10);
//   $JUNCTION @ATTACH %a1; $JUNCTION @ATTACH %b1; $JUNCTION @ATTACH %y1;
//   &A @WIRE {%a:p %a1 #MPA:g};
//   &A @WIRE {%a1 (-10,-10) #MNB:g};
//   &B @WIRE {%b:p %b1 #MNA:g};
//   &B @WIRE {%b1 (-12,11) (3,11) #MPB:g};
//   &Y @WIRE {#MPA:d %y1 #MPB:d %y:p};
//   &Y @WIRE {%y1 #MNA:d};
//   &nx @WIRE {#MNA:s #MNB:d};
//   &VDD @WIRE {#MPA:s %v1 (0,13) %v:p};
//   &VDD @WIRE {%v1 %v2 #MPB:s};
//   &VDD @WIRE {#MPA:b (-1,6) (-1,13) %v1};
//   &VDD @WIRE {#MPB:b (10,6) (10,13) %v2};
//   &VSS @WIRE {#MNB:s %g1 %g:p};
//   &VSS @WIRE {#MNA:b (10,-2) %g2 (10,-16) %g1};
//   &VSS @WIRE {#MNB:b %g2};
//   {#MNA #MNB #MPA #MPB} @TEXT("", key="model");
//   (-18,-22) @TEXT("MPA/MPB: pch_ulvt_mac, W=wp, L=30n, nf=np", halign="start", size=0.6);
//   (-18,-24) @TEXT("MNA/MNB: nch_ulvt_mac, W=wn, L=30n, nf=nn", halign="start", size=0.6);
//   (-18,20) @TEXT("NAND: immediate sample-off, conversion-off interlock", halign="start") => @SET-STYLE $title_style;
// }
// @RNL {
//   %symbol = @DEFINE-SYMBOL(box=[-5, -4, 5, 4]) {
//     @RECTANGLE {(-3.5,-2.5) (3.5,2.5)};
//     (-5,1) @PIN(terminal="A", direction="left");
//     @LINE {(-5,1) (-3.5,1)};
//     (-5,-1) @PIN(terminal="B", direction="left");
//     @LINE {(-5,-1) (-3.5,-1)};
//     (5,0) @PIN(terminal="Y", direction="right");
//     @LINE {(3.5,0) (5,0)};
//     (0,4) @PIN(terminal="VDD", direction="up");
//     @LINE {(0,2.5) (0,4)};
//     (0,-4) @PIN(terminal="VSS", direction="down");
//     @LINE {(0,-2.5) (0,-4)};
//     (0,0.8) @TEXT("NAND", size=0.65, halign="middle");
//     ? @TEXT("${wn}/${wp}", key="sizes", size=0.5, halign="middle") => @PLACE(0,-1.4);
//     ? @TEXT("${name}", key="name", size=0.6, halign="start") => @PLACE(-4,4.8);
//   };
//   # @SET-SYMBOL %symbol;
// }
ends adc_clkgen_nand2

subckt adc_clkgen_nor2 (A B Y VDD VSS)
parameters wn=1.2u wp=3.6u nn=2 np=4
MNA (Y A VSS VSS) nch_ulvt_mac w=wn l=30n nf=nn
MNB (Y B VSS VSS) nch_ulvt_mac w=wn l=30n nf=nn
MPA (px A VDD VDD) pch_ulvt_mac w=wp l=30n nf=np
MPB (Y B px VDD) pch_ulvt_mac w=wp l=30n nf=np
// @RNL {
//   &VDD @ADD-TO $SUPPLY_NET_SET;
//   &VSS @ADD-TO $GROUND_NET_SET;
//   {#MNA #MNB} @AS $MATCHED;
//   {#MPA #MPB} @AS $MATCHED;
//   {#MNA #MNB #MPA #MPB} @GROUP;
//   #MPA @PLACE(0,10) => @ORIENT("R0");
//   #MPB @PLACE(0,2) => @ORIENT("R0");
//   #MNA @PLACE(-5,-6) => @ORIENT("R0");
//   #MNB @PLACE(5,-6) => @ORIENT("MY");
//   %a=$IO_PORT @ATTACH &A => @PLACE(-18,10) => @ORIENT("R0");
//   %b=$IO_PORT @ATTACH &B => @PLACE(-18,2) => @ORIENT("R0");
//   %y=$IO_PORT @ATTACH &Y => @PLACE(12,-2) => @ORIENT("MY");
//   %v=$SUPPLY @ATTACH &VDD => @PLACE(0,18);
//   %g=$GROUND @ATTACH &VSS => @PLACE(0,-17);
//   %a1=(-12,10); %b1=(-6,2); %y1=(0,-2); %v1=(0,16); %pb=(8,10); %g1=(-5,-12); %g2=(5,-12); %ng=(0,-12);
//   $JUNCTION @ATTACH %a1; $JUNCTION @ATTACH %b1; $JUNCTION @ATTACH %y1;
//   &A @WIRE {%a:p %a1 #MPA:g};
//   &A @WIRE {%a1 (-12,-6) #MNA:g};
//   &B @WIRE {%b:p %b1 #MPB:g};
//   &B @WIRE {%b1 (-6,22) (16,22) (16,-6) #MNB:g};
//   &px @WIRE {#MPA:d #MPB:s};
//   &Y @WIRE {#MPB:d %y1 %y:p};
//   &Y @WIRE {#MNA:d (-5,-2) %y1 (5,-2) #MNB:d};
//   &VDD @WIRE {#MPA:s %v1 %v:p};
//   &VDD @WIRE {#MPB:b (8,2) %pb (8,16) %v1};
//   &VDD @WIRE {#MPA:b %pb};
//   &VSS @WIRE {#MNA:s %g1 %ng %g2 #MNB:s};
//   &VSS @WIRE {%ng %g:p};
//   &VSS @WIRE {#MNA:b (-2,-6) (-2,-12) %g1};
//   &VSS @WIRE {#MNB:b (2,-6) (2,-12) %g2};
//   {#MNA #MNB #MPA #MPB} @TEXT("", key="model");
//   (-18,-22) @TEXT("MPA/MPB: pch_ulvt_mac, W=wp, L=30n, nf=np", halign="start", size=0.6);
//   (-18,-24) @TEXT("MNA/MNB: nch_ulvt_mac, W=wn, L=30n, nf=nn", halign="start", size=0.6);
//   (-18,26) @TEXT("NOR: CLK or PHI_B high forces conversion off", halign="start") => @SET-STYLE $title_style;
// }
// @RNL {
//   %symbol = @DEFINE-SYMBOL(box=[-5, -4, 5, 4]) {
//     @RECTANGLE {(-3.5,-2.5) (3.5,2.5)};
//     (-5,1) @PIN(terminal="A", direction="left");
//     @LINE {(-5,1) (-3.5,1)};
//     (-5,-1) @PIN(terminal="B", direction="left");
//     @LINE {(-5,-1) (-3.5,-1)};
//     (5,0) @PIN(terminal="Y", direction="right");
//     @LINE {(3.5,0) (5,0)};
//     (0,4) @PIN(terminal="VDD", direction="up");
//     @LINE {(0,2.5) (0,4)};
//     (0,-4) @PIN(terminal="VSS", direction="down");
//     @LINE {(0,-2.5) (0,-4)};
//     (0,0.8) @TEXT("NOR", size=0.65, halign="middle");
//     ? @TEXT("${wn}/${wp}", key="sizes", size=0.5, halign="middle") => @PLACE(0,-1.4);
//     ? @TEXT("${name}", key="name", size=0.6, halign="start") => @PLACE(-4,4.8);
//   };
//   # @SET-SYMBOL %symbol;
// }
ends adc_clkgen_nor2

subckt adc_clkgen_gatecap (A VDD VSS)
parameters wn=2u wp=3u ln=90n lp=90n nn=4 np=4
MN (VSS A VSS VSS) nch_ulvt_mac w=wn l=ln nf=nn
MP (VDD A VDD VDD) pch_ulvt_mac w=wp l=lp nf=np
// @RNL {
//   &VDD @ADD-TO $SUPPLY_NET_SET;
//   &VSS @ADD-TO $GROUND_NET_SET;
//   {#MN #MP} @GROUP;
//   #MP @PLACE(0,6) => @ORIENT("R0");
//   #MN @PLACE(0,-6) => @ORIENT("R0");
//   %a=$IO_PORT @ATTACH &A => @PLACE(-12,0) => @ORIENT("R0");
//   %v=$SUPPLY @ATTACH &VDD => @PLACE(0,15);
//   %g=$GROUND @ATTACH &VSS => @PLACE(0,-15);
//   %ga=(-6,0); %vp=(0,12); %vn=(0,-12);
//   $JUNCTION @ATTACH %ga; $JUNCTION @ATTACH %vp; $JUNCTION @ATTACH %vn;
//   &A @WIRE {%a:p %ga};
//   &A @WIRE {#MP:g (-6,6) %ga (-6,-6) #MN:g};
//   &VDD @WIRE {#MP:s %vp %v:p};
//   &VDD @WIRE {#MP:d (5,4) (5,12) %vp};
//   &VDD @WIRE {#MP:b (5,6)};
//   &VSS @WIRE {#MN:s %vn %g:p};
//   &VSS @WIRE {#MN:d (5,-4) (5,-12) %vn};
//   &VSS @WIRE {#MN:b (5,-6)};
//   {#MN #MP} @TEXT("", key="model");
//   (-12,20) @TEXT("Complementary MOS gate load; source, drain and body tied to rails", halign="start") => @SET-STYLE $title_style;
//   (-12,-19) @TEXT("MP: pch_ulvt_mac, W=wp, L=lp, nf=np", halign="start", size=0.6);
//   (-12,-21) @TEXT("MN: nch_ulvt_mac, W=wn, L=ln, nf=nn", halign="start", size=0.6);
// }
// @RNL {
//   %symbol = @DEFINE-SYMBOL(box=[-5, -4, 5, 4]) {
//     @RECTANGLE {(-3.5,-2.5) (3.5,2.5)};
//     (-5,0) @PIN(terminal="A", direction="left");
//     @LINE {(-5,0) (-3.5,0)};
//     (0,4) @PIN(terminal="VDD", direction="up");
//     @LINE {(0,2.5) (0,4)};
//     (0,-4) @PIN(terminal="VSS", direction="down");
//     @LINE {(0,-2.5) (0,-4)};
//     (0,0.8) @TEXT("LOAD", size=0.65, halign="middle");
//     ? @TEXT("${wn}/${wp}", key="sizes", size=0.5, halign="middle") => @PLACE(0,-1.4);
//     ? @TEXT("${name}", key="name", size=0.6, halign="start") => @PLACE(-4,4.8);
//   };
//   # @SET-SYMBOL %symbol;
// }
ends adc_clkgen_gatecap

subckt adc_clkgen (CLK PHI_S PHI_SB PHI_B PHI_BB CONV AVDD VSS)
// Sampling is inhibited until the loaded CONV output is low.
// Conversion is inhibited until both CLK and the loaded PHI_B output are low.
// Four physical inverter stages delay PHI_B relative to the loaded PHI_S.
// MOS gate loads slow internal edges without long-channel series resistance.
// CLK controls the lower NAND pull-down device to keep its internal node bounded.
XOFF (CONV coff AVDD VSS) adc_clkgen_inv wn=1.2u wp=1.8u nn=2 np=2
XSG (CLK coff sbar AVDD VSS) adc_clkgen_nand2 wn=800n wp=600n nn=2 np=2
XS1 (sbar s1 AVDD VSS) adc_clkgen_inv wn=1.2u wp=1.8u nn=2 np=2
XS2 (s1 s2 AVDD VSS) adc_clkgen_inv wn=2u wp=3u nn=4 np=4
XS3 (s2 PHI_S AVDD VSS) adc_clkgen_inv wn=8u wp=12u nn=8 np=12
XSB1 (sbar sb1 AVDD VSS) adc_clkgen_inv wn=600n wp=900n nn=2 np=2
XSB2 (sb1 PHI_SB AVDD VSS) adc_clkgen_inv wn=8u wp=12u nn=8 np=12
XB1 (PHI_S b1 AVDD VSS) adc_clkgen_inv wn=400n wp=600n nn=2 np=2
XB2 (b1 b2 AVDD VSS) adc_clkgen_inv wn=400n wp=600n nn=2 np=2
XB3 (b2 b3 AVDD VSS) adc_clkgen_inv wn=400n wp=600n nn=2 np=2
XB4 (b3 PHI_B AVDD VSS) adc_clkgen_inv wn=8u wp=4.8u nn=8 np=4
XBB1 (b3 bb1 AVDD VSS) adc_clkgen_inv wn=800n wp=1.2u nn=2 np=2
XBB2 (bb1 PHI_BB AVDD VSS) adc_clkgen_inv wn=2.4u wp=3.6u nn=4 np=4
XCG (CLK PHI_B ce AVDD VSS) adc_clkgen_nor2 wn=600n wp=1.8u nn=2 np=2
XC1 (ce cb AVDD VSS) adc_clkgen_inv wn=1.2u wp=1.8u nn=2 np=2
XC2 (cb CONV AVDD VSS) adc_clkgen_inv wn=2.4u wp=3.6u nn=4 np=4
XCS1 (s1 AVDD VSS) adc_clkgen_gatecap wn=2u wp=3u nn=4 np=4
XCS2 (s1 AVDD VSS) adc_clkgen_gatecap wn=2u wp=3u nn=4 np=4
XCS3 (s1 AVDD VSS) adc_clkgen_gatecap wn=2u wp=3u nn=4 np=4
XCB1 (b1 AVDD VSS) adc_clkgen_gatecap wn=2u wp=3u nn=4 np=4
XCB2 (b2 AVDD VSS) adc_clkgen_gatecap wn=2u wp=3u nn=4 np=4
XCC1 (cb AVDD VSS) adc_clkgen_gatecap wn=2u wp=3u nn=4 np=4
XCC2 (cb AVDD VSS) adc_clkgen_gatecap wn=2u wp=3u nn=4 np=4
XCE1 (ce AVDD VSS) adc_clkgen_gatecap wn=2u wp=3u nn=4 np=4
XCS4 (s1 AVDD VSS) adc_clkgen_gatecap wn=400n wp=600n nn=2 np=2
XCO1 (coff AVDD VSS) adc_clkgen_gatecap wn=400n wp=600n nn=2 np=2
XCO2 (coff AVDD VSS) adc_clkgen_gatecap wn=400n wp=600n nn=2 np=2
XCE2 (ce AVDD VSS) adc_clkgen_gatecap wn=400n wp=600n nn=2 np=2
// @RNL {
//   &AVDD @ADD-TO $SUPPLY_NET_SET;
//   &VSS @ADD-TO $GROUND_NET_SET;
//   {#XS1 #XS2 #XS3 #XSB1 #XSB2} @GROUP;
//   {#XB1 #XB2 #XB3 #XB4 #XBB1 #XBB2} @GROUP;
//   {#XCG #XC1 #XC2 #XOFF #XSG} @GROUP;
//   {#XCB1 #XCB2 #XCS1 #XCS2 #XCS3 #XCC1 #XCC2 #XCE1 #XCS4 #XCO1 #XCO2 #XCE2} @GROUP;
//   {#XS3 #XSB2} @AS $MATCHED;
//   #XOFF @PLACE(0,40) => @ORIENT("R0");
//   %v0=$SUPPLY @ATTACH &AVDD => @PLACE(0,48);
//   &AVDD @WIRE {#XOFF:VDD %v0:p};
//   %g0=$GROUND @ATTACH &VSS => @PLACE(0,32);
//   &VSS @WIRE {#XOFF:VSS %g0:p};
//   #XSG @PLACE(0,15) => @ORIENT("R0");
//   %v1=$SUPPLY @ATTACH &AVDD => @PLACE(0,23);
//   &AVDD @WIRE {#XSG:VDD %v1:p};
//   %g1=$GROUND @ATTACH &VSS => @PLACE(0,7);
//   &VSS @WIRE {#XSG:VSS %g1:p};
//   #XS1 @PLACE(20,15) => @ORIENT("R0");
//   %v2=$SUPPLY @ATTACH &AVDD => @PLACE(20,23);
//   &AVDD @WIRE {#XS1:VDD %v2:p};
//   %g2=$GROUND @ATTACH &VSS => @PLACE(20,7);
//   &VSS @WIRE {#XS1:VSS %g2:p};
//   #XS2 @PLACE(40,15) => @ORIENT("R0");
//   %v3=$SUPPLY @ATTACH &AVDD => @PLACE(40,23);
//   &AVDD @WIRE {#XS2:VDD %v3:p};
//   %g3=$GROUND @ATTACH &VSS => @PLACE(40,7);
//   &VSS @WIRE {#XS2:VSS %g3:p};
//   #XS3 @PLACE(60,15) => @ORIENT("R0");
//   %v4=$SUPPLY @ATTACH &AVDD => @PLACE(60,23);
//   &AVDD @WIRE {#XS3:VDD %v4:p};
//   %g4=$GROUND @ATTACH &VSS => @PLACE(60,7);
//   &VSS @WIRE {#XS3:VSS %g4:p};
//   #XSB1 @PLACE(20,-15) => @ORIENT("R0");
//   %v5=$SUPPLY @ATTACH &AVDD => @PLACE(20,-7);
//   &AVDD @WIRE {#XSB1:VDD %v5:p};
//   %g5=$GROUND @ATTACH &VSS => @PLACE(20,-23);
//   &VSS @WIRE {#XSB1:VSS %g5:p};
//   #XSB2 @PLACE(60,-15) => @ORIENT("R0");
//   %v6=$SUPPLY @ATTACH &AVDD => @PLACE(60,-7);
//   &AVDD @WIRE {#XSB2:VDD %v6:p};
//   %g6=$GROUND @ATTACH &VSS => @PLACE(60,-23);
//   &VSS @WIRE {#XSB2:VSS %g6:p};
//   #XB1 @PLACE(90,15) => @ORIENT("R0");
//   %v7=$SUPPLY @ATTACH &AVDD => @PLACE(90,23);
//   &AVDD @WIRE {#XB1:VDD %v7:p};
//   %g7=$GROUND @ATTACH &VSS => @PLACE(90,7);
//   &VSS @WIRE {#XB1:VSS %g7:p};
//   #XB2 @PLACE(110,15) => @ORIENT("R0");
//   %v8=$SUPPLY @ATTACH &AVDD => @PLACE(110,23);
//   &AVDD @WIRE {#XB2:VDD %v8:p};
//   %g8=$GROUND @ATTACH &VSS => @PLACE(110,7);
//   &VSS @WIRE {#XB2:VSS %g8:p};
//   #XB3 @PLACE(130,15) => @ORIENT("R0");
//   %v9=$SUPPLY @ATTACH &AVDD => @PLACE(130,23);
//   &AVDD @WIRE {#XB3:VDD %v9:p};
//   %g9=$GROUND @ATTACH &VSS => @PLACE(130,7);
//   &VSS @WIRE {#XB3:VSS %g9:p};
//   #XB4 @PLACE(150,15) => @ORIENT("R0");
//   %v10=$SUPPLY @ATTACH &AVDD => @PLACE(150,23);
//   &AVDD @WIRE {#XB4:VDD %v10:p};
//   %g10=$GROUND @ATTACH &VSS => @PLACE(150,7);
//   &VSS @WIRE {#XB4:VSS %g10:p};
//   #XBB1 @PLACE(130,-15) => @ORIENT("R0");
//   %v11=$SUPPLY @ATTACH &AVDD => @PLACE(130,-7);
//   &AVDD @WIRE {#XBB1:VDD %v11:p};
//   %g11=$GROUND @ATTACH &VSS => @PLACE(130,-23);
//   &VSS @WIRE {#XBB1:VSS %g11:p};
//   #XBB2 @PLACE(150,-15) => @ORIENT("R0");
//   %v12=$SUPPLY @ATTACH &AVDD => @PLACE(150,-7);
//   &AVDD @WIRE {#XBB2:VDD %v12:p};
//   %g12=$GROUND @ATTACH &VSS => @PLACE(150,-23);
//   &VSS @WIRE {#XBB2:VSS %g12:p};
//   #XCG @PLACE(180,15) => @ORIENT("R0");
//   %v13=$SUPPLY @ATTACH &AVDD => @PLACE(180,23);
//   &AVDD @WIRE {#XCG:VDD %v13:p};
//   %g13=$GROUND @ATTACH &VSS => @PLACE(180,7);
//   &VSS @WIRE {#XCG:VSS %g13:p};
//   #XC1 @PLACE(200,15) => @ORIENT("R0");
//   %v14=$SUPPLY @ATTACH &AVDD => @PLACE(200,23);
//   &AVDD @WIRE {#XC1:VDD %v14:p};
//   %g14=$GROUND @ATTACH &VSS => @PLACE(200,7);
//   &VSS @WIRE {#XC1:VSS %g14:p};
//   #XC2 @PLACE(220,15) => @ORIENT("R0");
//   %v15=$SUPPLY @ATTACH &AVDD => @PLACE(220,23);
//   &AVDD @WIRE {#XC2:VDD %v15:p};
//   %g15=$GROUND @ATTACH &VSS => @PLACE(220,7);
//   &VSS @WIRE {#XC2:VSS %g15:p};
//   #XCS1 @PLACE(30,40) => @ORIENT("R0");
//   %v16=$SUPPLY @ATTACH &AVDD => @PLACE(30,48);
//   &AVDD @WIRE {#XCS1:VDD %v16:p};
//   %g16=$GROUND @ATTACH &VSS => @PLACE(30,32);
//   &VSS @WIRE {#XCS1:VSS %g16:p};
//   #XCB1 @PLACE(120,40) => @ORIENT("R0");
//   %v17=$SUPPLY @ATTACH &AVDD => @PLACE(120,48);
//   &AVDD @WIRE {#XCB1:VDD %v17:p};
//   %g17=$GROUND @ATTACH &VSS => @PLACE(120,32);
//   &VSS @WIRE {#XCB1:VSS %g17:p};
//   #XCB2 @PLACE(150,40) => @ORIENT("R0");
//   %v18=$SUPPLY @ATTACH &AVDD => @PLACE(150,48);
//   &AVDD @WIRE {#XCB2:VDD %v18:p};
//   %g18=$GROUND @ATTACH &VSS => @PLACE(150,32);
//   &VSS @WIRE {#XCB2:VSS %g18:p};
//   #XCC1 @PLACE(210,40) => @ORIENT("R0");
//   %v19=$SUPPLY @ATTACH &AVDD => @PLACE(210,48);
//   &AVDD @WIRE {#XCC1:VDD %v19:p};
//   %g19=$GROUND @ATTACH &VSS => @PLACE(210,32);
//   &VSS @WIRE {#XCC1:VSS %g19:p};
//   %pclk=$IO_PORT @ATTACH &CLK => @PLACE(-25,16) => @ORIENT("R0");
//   %ps=$IO_PORT @ATTACH &PHI_S => @PLACE(75,27) => @ORIENT("MY");
//   %psb=$IO_PORT @ATTACH &PHI_SB => @PLACE(75,-15) => @ORIENT("MY");
//   %pb=$IO_PORT @ATTACH &PHI_B => @PLACE(165,27) => @ORIENT("MY");
//   %pbb=$IO_PORT @ATTACH &PHI_BB => @PLACE(165,-15) => @ORIENT("MY");
//   %pc=$IO_PORT @ATTACH &CONV => @PLACE(240,15) => @ORIENT("MY");
//   %jclk=(-15,16); %jsb=(10,15); %js=(70,15); %jb3=(140,15); %jb=(160,15); %jc=(230,15);
//   $JUNCTION @ATTACH %jclk; $JUNCTION @ATTACH %jsb; $JUNCTION @ATTACH %js;
//   $JUNCTION @ATTACH %jb3; $JUNCTION @ATTACH %jb; $JUNCTION @ATTACH %jc;
//   &CLK @WIRE {%pclk:p %jclk #XSG:A};
//   &CLK @WIRE {%jclk (-15,68) (170,68) (170,16) #XCG:A};
//   &coff @WIRE {#XOFF:Y (10,40) (10,29) (-10,29) (-10,14) #XSG:B};
//   &sbar @WIRE {#XSG:Y %jsb #XS1:A};
//   &sbar @WIRE {%jsb (10,-15) #XSB1:A};
//   &s1 @WIRE {#XS1:Y #XS2:A};
//   %js1=(30,15); $JUNCTION @ATTACH %js1;
//   &s1 @WIRE {%js1 (30,28) (24,28) (24,40) #XCS1:A};
//   &s2 @WIRE {#XS2:Y #XS3:A};
//   &sb1 @WIRE {#XSB1:Y #XSB2:A};
//   &PHI_S @WIRE {#XS3:Y %js #XB1:A};
//   &PHI_S @WIRE {%js (70,27) %ps:p};
//   &PHI_SB @WIRE {#XSB2:Y %psb:p};
//   &b1 @WIRE {#XB1:Y #XB2:A};
//   %jb1=(100,15); $JUNCTION @ATTACH %jb1;
//   &b1 @WIRE {%jb1 (100,29) (114,29) (114,40) #XCB1:A};
//   &b2 @WIRE {#XB2:Y #XB3:A};
//   %jb2=(120,15); $JUNCTION @ATTACH %jb2;
//   &b2 @WIRE {%jb2 (120,25) (144,25) (144,40) #XCB2:A};
//   &b3 @WIRE {#XB3:Y %jb3 #XB4:A};
//   &b3 @WIRE {%jb3 (140,-1) (120,-1) (120,-15) #XBB1:A};
//   &bb1 @WIRE {#XBB1:Y #XBB2:A};
//   &PHI_B @WIRE {#XB4:Y %jb (170,15) (170,14) #XCG:B};
//   &PHI_B @WIRE {%jb (160,27) %pb:p};
//   &PHI_BB @WIRE {#XBB2:Y %pbb:p};
//   &ce @WIRE {#XCG:Y #XC1:A};
//   &cb @WIRE {#XC1:Y #XC2:A};
//   %jcb=(210,15); $JUNCTION @ATTACH %jcb;
//   &cb @WIRE {%jcb (210,28) (204,28) (204,40) #XCC1:A};
//   &CONV @WIRE {#XC2:Y %jc %pc:p};
//   &CONV @WIRE {%jc (230,55) (-10,55) (-10,40) #XOFF:A};
//   (-25,76) @TEXT("adc_clkgen: CMOS phases with feedback from loaded outputs", halign="start") => @SET-STYLE $title_style;
//   (18,-30) @TEXT("Sample drivers; Wn/Wp shown inside each cell", halign="start") => @SET-STYLE $note_style;
//   (88,52) @TEXT("Physical S-to-B delay with local MOS gate loads", halign="start") => @SET-STYLE $note_style;
//   (88,58) @TEXT("Inverters L=30n; MOS gate loads L=90n", halign="start", size=0.6);
//   (178,52) @TEXT("Conversion inhibit and 250 fF driver", halign="start") => @SET-STYLE $note_style;
//   (30,58) @TEXT("Loaded CONV feedback: sample turn-on waits for conversion turn-off", halign="start") => @SET-STYLE $note_style;
//   #XCS2 @PLACE(50,40) => @ORIENT("R0");
//   %v20=$SUPPLY @ATTACH &AVDD => @PLACE(50,48);
//   &AVDD @WIRE {#XCS2:VDD %v20:p};
//   %g20=$GROUND @ATTACH &VSS => @PLACE(50,32);
//   &VSS @WIRE {#XCS2:VSS %g20:p};
//   #XCS3 @PLACE(70,40) => @ORIENT("R0");
//   %v21=$SUPPLY @ATTACH &AVDD => @PLACE(70,48);
//   &AVDD @WIRE {#XCS3:VDD %v21:p};
//   %g21=$GROUND @ATTACH &VSS => @PLACE(70,32);
//   &VSS @WIRE {#XCS3:VSS %g21:p};
//   #XCE1 @PLACE(180,-15) => @ORIENT("R0");
//   %v22=$SUPPLY @ATTACH &AVDD => @PLACE(180,-7);
//   &AVDD @WIRE {#XCE1:VDD %v22:p};
//   %g22=$GROUND @ATTACH &VSS => @PLACE(180,-23);
//   &VSS @WIRE {#XCE1:VSS %g22:p};
//   #XCC2 @PLACE(240,-15) => @ORIENT("R0");
//   %v25=$SUPPLY @ATTACH &AVDD => @PLACE(240,-7);
//   &AVDD @WIRE {#XCC2:VDD %v25:p};
//   %g25=$GROUND @ATTACH &VSS => @PLACE(240,-23);
//   &VSS @WIRE {#XCC2:VSS %g25:p};
//   %jcs=(24,28); %jcs2=(44,28);
//   $JUNCTION @ATTACH %jcs; $JUNCTION @ATTACH %jcs2;
//   &s1 @WIRE {%jcs %jcs2 (44,40) #XCS2:A};
//   &s1 @WIRE {%jcs2 (64,28) (64,40) #XCS3:A};
//   %jce=(190,15); %jce2=(190,-1);
//   $JUNCTION @ATTACH %jce;
//   &ce @WIRE {%jce %jce2 (170,-1) (170,-15) #XCE1:A};
//   &cb @WIRE {%jcb (210,1) (230,1) (230,-15) #XCC2:A};
//   (178,-30) @TEXT("Local CE and CB edge-shaping gate loads", halign="start") => @SET-STYLE $note_style;
//   #XCS4 @PLACE(90,40) => @ORIENT("R0");
//   %v26=$SUPPLY @ATTACH &AVDD => @PLACE(90,48);
//   &AVDD @WIRE {#XCS4:VDD %v26:p};
//   %g26=$GROUND @ATTACH &VSS => @PLACE(90,32);
//   &VSS @WIRE {#XCS4:VSS %g26:p};
//   #XCO1 @PLACE(-20,40) => @ORIENT("R0");
//   %v27=$SUPPLY @ATTACH &AVDD => @PLACE(-20,48);
//   &AVDD @WIRE {#XCO1:VDD %v27:p};
//   %g27=$GROUND @ATTACH &VSS => @PLACE(-20,32);
//   &VSS @WIRE {#XCO1:VSS %g27:p};
//   %jcs3=(64,28); $JUNCTION @ATTACH %jcs3;
//   &s1 @WIRE {%jcs3 (84,28) (84,40) #XCS4:A};
//   %jcoff=(-10,29); $JUNCTION @ATTACH %jcoff;
//   &coff @WIRE {%jcoff (-30,29) (-30,40) #XCO1:A};
//   #XCO2 @PLACE(-40,40) => @ORIENT("R0");
//   %v28=$SUPPLY @ATTACH &AVDD => @PLACE(-40,48);
//   &AVDD @WIRE {#XCO2:VDD %v28:p};
//   %g28=$GROUND @ATTACH &VSS => @PLACE(-40,32);
//   &VSS @WIRE {#XCO2:VSS %g28:p};
//   #XCE2 @PLACE(210,-15) => @ORIENT("R0");
//   %v29=$SUPPLY @ATTACH &AVDD => @PLACE(210,-7);
//   &AVDD @WIRE {#XCE2:VDD %v29:p};
//   %g29=$GROUND @ATTACH &VSS => @PLACE(210,-23);
//   &VSS @WIRE {#XCE2:VSS %g29:p};
//   &coff @WIRE {%jcoff (-50,29) (-50,40) #XCO2:A};
//   $JUNCTION @ATTACH %jce2;
//   &ce @WIRE {%jce2 (200,-1) (200,-15) #XCE2:A};
// }
ends adc_clkgen
