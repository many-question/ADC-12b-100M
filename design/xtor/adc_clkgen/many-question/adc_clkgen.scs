// adc_clkgen transistor view: static CMOS, loaded-output interlocks.
// @RNL(type="header") {
//   @VERSION("0.3");
//   @USE-PACKAGE(name="adc28", version="0.1", path="../../../rnl/adc28.rnl");
// }
simulator lang=spectre

// Sizes are total channel widths; each device's finger count is explicit.
// Primitive-cell schematics and top-level routing below are manually authored.
subckt adc_clkgen_inv (A Y VDD VSS)
parameters wn=400n wp=600n ln=30n lp=30n nn=2 np=2
MN (Y A VSS VSS) nch_ulvt_mac w=wn l=ln nf=nn
MP (Y A VDD VDD) pch_ulvt_mac w=wp l=lp nf=np
// @RNL {
//   &VDD @ADD-TO $SUPPLY_NET_SET; &VSS @ADD-TO $GROUND_NET_SET;
//   # @SET-SYMBOL $INVERTER;
//   #MP @SET-SYMBOL $PMOS; #MN @SET-SYMBOL $NMOS;
//   {#MN #MP} @GROUP; {#MN #MP} @TEXT("", key="model");
//   #MP @PLACE(0,5) => @ORIENT("R0");
//   #MN @PLACE(0,-5) => @ORIENT("R0");
//   %ga=(-6,0);
//   %out=(0,0);
//   %vp=(0,10);
//   %vn=(0,-10);
//   %a=$IO_PORT @ATTACH &A => @PLACE(-10,0) => @ORIENT("R0");
//   %y=$IO_PORT @ATTACH &Y => @PLACE(8,0) => @ORIENT("MY");
//   %v=$SUPPLY @ATTACH &VDD => @PLACE(0,12) => @ORIENT("R0");
//   %g=$GROUND @ATTACH &VSS => @PLACE(0,-12) => @ORIENT("R0");
//   &A @WIRE(mode="straight") {%a:p %ga};
//   &A @WIRE(mode="straight") {#MP:g (-6,5) %ga (-6,-5) #MN:g};
//   &Y @WIRE(mode="straight") {#MP:d %out #MN:d};
//   &Y @WIRE(mode="straight") {%out %y:p};
//   &VDD @WIRE(mode="straight") {#MP:s %vp %v:p};
//   &VSS @WIRE(mode="straight") {#MN:s %vn %g:p};
//   (-10,20) @TEXT("adc_clkgen_inv", size=1.2, textcolor="#334155", bold=true, halign="start");
//   (-10,18) @TEXT("Y = NOT A; PMOS above, NMOS below", size=0.8, textcolor="#334155", bold=false, halign="start");
//   (-10,-21) @TEXT("Implicit bodies: MP to VDD; MN to VSS.", size=0.7, textcolor="#334155", bold=false, halign="start");
//   (-10,-17) @TEXT("MP: pch_ulvt_mac; W=wp, L=lp, nf=np", size=0.7, textcolor="#334155", bold=false, halign="start");
//   (-10,-19) @TEXT("MN: nch_ulvt_mac; W=wn, L=ln, nf=nn", size=0.7, textcolor="#334155", bold=false, halign="start");
//   $JUNCTION @ATTACH %ga;
//   $JUNCTION @ATTACH %out;
// }
ends adc_clkgen_inv

subckt adc_clkgen_nand2 (A B Y VDD VSS)
parameters wn=800n wp=600n nn=2 np=2
MNA (Y B nx VSS) nch_ulvt_mac w=wn l=30n nf=nn
MNB (nx A VSS VSS) nch_ulvt_mac w=wn l=30n nf=nn
MPA (Y A VDD VDD) pch_ulvt_mac w=wp l=30n nf=np
MPB (Y B VDD VDD) pch_ulvt_mac w=wp l=30n nf=np
// @RNL {
//   &VDD @ADD-TO $SUPPLY_NET_SET; &VSS @ADD-TO $GROUND_NET_SET;
//   # @SET-SYMBOL $NAND_2INPUT;
//   {#MPA #MPB} @SET-SYMBOL $PMOS; {#MNA #MNB} @SET-SYMBOL $NMOS;
//   {#MNA #MNB} @AS $MATCHED; {#MPA #MPB} @AS $MATCHED;
//   {#MNA #MNB #MPA #MPB} @GROUP; {#MNA #MNB #MPA #MPB} @TEXT("", key="model");
//   #MPA @PLACE(-4,6) => @ORIENT("R0");
//   #MPB @PLACE(6,6) => @ORIENT("R0");
//   #MNA @PLACE(0,-2) => @ORIENT("R0");
//   #MNB @PLACE(0,-10) => @ORIENT("R0");
//   %a1=(-10,6);
//   %b1=(-12,-2);
//   %yp=(-4,2);
//   %y1=(0,2);
//   %yb=(6,2);
//   %vp=(-4,13);
//   %v0=(0,13);
//   %vb=(6,13);
//   %g1=(0,-16);
//   %g2=(10,-10);
//   %a=$IO_PORT @ATTACH &A => @PLACE(-17,6) => @ORIENT("R0");
//   %b=$IO_PORT @ATTACH &B => @PLACE(-17,-2) => @ORIENT("R0");
//   %y=$IO_PORT @ATTACH &Y => @PLACE(16,2) => @ORIENT("MY");
//   %v=$SUPPLY @ATTACH &VDD => @PLACE(0,16) => @ORIENT("R0");
//   %g=$GROUND @ATTACH &VSS => @PLACE(0,-18) => @ORIENT("R0");
//   &A @WIRE(mode="straight") {%a:p %a1 #MPA:g};
//   &A @WIRE(mode="straight") {%a1 (-10,-10) #MNB:g};
//   &B @WIRE(mode="straight") {%b:p %b1 #MNA:g};
//   &B @WIRE(mode="straight") {%b1 (-12,11) (3,11) #MPB:g};
//   &Y @WIRE(mode="straight") {#MPA:d %yp %y1 %yb %y:p};
//   &Y @WIRE(mode="straight") {#MPB:d %yb};
//   &Y @WIRE(mode="straight") {%y1 #MNA:d};
//   &nx @WIRE(mode="straight") {#MNA:s #MNB:d};
//   &VDD @WIRE(mode="straight") {#MPA:s %vp %v0 %vb #MPB:s};
//   &VDD @WIRE(mode="straight") {%v0 %v:p};
//   &VSS @WIRE(mode="straight") {#MNB:s %g1 %g:p};
//   (-17,24) @TEXT("adc_clkgen_nand2", size=1.2, textcolor="#334155", bold=true, halign="start");
//   (-17,22) @TEXT("Y = NOT (A AND B); A controls the lower NMOS", size=0.8, textcolor="#334155", bold=false, halign="start");
//   (-17,-23) @TEXT("MPA/MPB: pch_ulvt_mac; W=wp, L=30n, nf=np", size=0.7, textcolor="#334155", bold=false, halign="start");
//   (-17,-25) @TEXT("MNA/MNB: nch_ulvt_mac; W=wn, L=30n, nf=nn", size=0.7, textcolor="#334155", bold=false, halign="start");
//   (-17,-28) @TEXT("Implicit bodies: pMOS to VDD; nMOS to VSS, including stacked MNA.", size=0.7, textcolor="#334155", bold=false, halign="start");
//   $JUNCTION @ATTACH %a1;
//   $JUNCTION @ATTACH %b1;
//   $JUNCTION @ATTACH %y1;
//   $JUNCTION @ATTACH %yb;
//   $JUNCTION @ATTACH %v0;
// }
ends adc_clkgen_nand2

subckt adc_clkgen_nor2 (A B Y VDD VSS)
parameters wn=1.2u wp=3.6u nn=2 np=4
MNA (Y A VSS VSS) nch_ulvt_mac w=wn l=30n nf=nn
MNB (Y B VSS VSS) nch_ulvt_mac w=wn l=30n nf=nn
MPA (px A VDD VDD) pch_ulvt_mac w=wp l=30n nf=np
MPB (Y B px VDD) pch_ulvt_mac w=wp l=30n nf=np
// @RNL {
//   &VDD @ADD-TO $SUPPLY_NET_SET; &VSS @ADD-TO $GROUND_NET_SET;
//   # @SET-SYMBOL $NOR_2INPUT;
//   {#MPA #MPB} @SET-SYMBOL $PMOS; {#MNA #MNB} @SET-SYMBOL $NMOS;
//   {#MNA #MNB} @AS $MATCHED; {#MPA #MPB} @AS $MATCHED;
//   {#MNA #MNB #MPA #MPB} @GROUP; {#MNA #MNB #MPA #MPB} @TEXT("", key="model");
//   #MPA @PLACE(0,10) => @ORIENT("R0");
//   #MPB @PLACE(0,2) => @ORIENT("R0");
//   #MNA @PLACE(-5,-7) => @ORIENT("R0");
//   #MNB @PLACE(7,-7) => @ORIENT("R0");
//   %a1=(-12,10);
//   %b1=(-6,2);
//   %y1=(0,-2);
//   %ya=(-5,-2);
//   %yb=(7,-2);
//   %v1=(0,15);
//   %pb=(11,10);
//   %ga=(-5,-13);
//   %gb=(7,-13);
//   %g0=(0,-13);
//   %gba=(-2,-13);
//   %gbb=(11,-13);
//   %a=$IO_PORT @ATTACH &A => @PLACE(-17,10) => @ORIENT("R0");
//   %b=$IO_PORT @ATTACH &B => @PLACE(-17,2) => @ORIENT("R0");
//   %y=$IO_PORT @ATTACH &Y => @PLACE(16,-2) => @ORIENT("MY");
//   %v=$SUPPLY @ATTACH &VDD => @PLACE(0,17) => @ORIENT("R0");
//   %g=$GROUND @ATTACH &VSS => @PLACE(0,-16) => @ORIENT("R0");
//   &A @WIRE(mode="straight") {%a:p %a1 #MPA:g};
//   &A @WIRE(mode="straight") {%a1 (-12,-7) #MNA:g};
//   &B @WIRE(mode="straight") {%b:p %b1 #MPB:g};
//   &B @WIRE(mode="straight") {%b1 (-6,-1) (3,-1) (3,-7) #MNB:g};
//   &px @WIRE(mode="straight") {#MPA:d #MPB:s};
//   &Y @WIRE(mode="straight") {#MPB:d %y1 %yb %y:p};
//   &Y @WIRE(mode="straight") {#MNA:d %ya %y1};
//   &Y @WIRE(mode="straight") {%yb #MNB:d};
//   &VDD @WIRE(mode="straight") {#MPA:s %v1 %v:p};
//   &VSS @WIRE(mode="straight") {#MNA:s %ga %g0 %gb};
//   &VSS @WIRE(mode="straight") {#MNB:s %gb};
//   &VSS @WIRE(mode="straight") {%g0 %g:p};
//   (-17,25) @TEXT("adc_clkgen_nor2", size=1.2, textcolor="#334155", bold=true, halign="start");
//   (-17,23) @TEXT("Y = NOT (A OR B); series PMOS, parallel NMOS", size=0.8, textcolor="#334155", bold=false, halign="start");
//   (-17,-21) @TEXT("MPA/MPB: pch_ulvt_mac; W=wp, L=30n, nf=np", size=0.7, textcolor="#334155", bold=false, halign="start");
//   (-17,-23) @TEXT("MNA/MNB: nch_ulvt_mac; W=wn, L=30n, nf=nn", size=0.7, textcolor="#334155", bold=false, halign="start");
//   (-17,-26) @TEXT("Implicit bodies: pMOS to VDD, including stacked MPB; nMOS to VSS.", size=0.7, textcolor="#334155", bold=false, halign="start");
//   $JUNCTION @ATTACH %a1;
//   $JUNCTION @ATTACH %b1;
//   $JUNCTION @ATTACH %y1;
//   $JUNCTION @ATTACH %yb;
//   $JUNCTION @ATTACH %g0;
// }
ends adc_clkgen_nor2

subckt adc_clkgen_gatecap (A VDD VSS)
parameters wn=2u wp=3u ln=90n lp=90n nn=4 np=4
MN (VSS A VSS VSS) nch_ulvt_mac w=wn l=ln nf=nn
MP (VDD A VDD VDD) pch_ulvt_mac w=wp l=lp nf=np
// @RNL {
//   &VDD @ADD-TO $SUPPLY_NET_SET; &VSS @ADD-TO $GROUND_NET_SET;
//   /* RNL 0.3 keeps subcircuits separate. This circuit-shaped symbol composes
//      standard MOS artwork without changing the electrical hierarchy.
//      Real ports: 1=A (both gates), 2=VDD (MP d/s/b), 3=VSS (MN d/s/b). */
//   %pmos_draw = @DEFINE-SYMBOL { $PMOS; ? @TEXT("", key="name"); ? @TEXT("", key="model"); };
//   %nmos_draw = @DEFINE-SYMBOL { $NMOS; ? @TEXT("", key="name"); ? @TEXT("", key="model"); };
//   %load = @DEFINE-SYMBOL(box=[-4,-9,2.5,7]) {
//     (-4,-9) @PIN(terminal="A", direction="down");
//     (0,7) @PIN(terminal="VDD", direction="up");
//     (0,-7) @PIN(terminal="VSS", direction="down");
//     $FIGURE @ATTACH (0,3) => @SET-SYMBOL %pmos_draw;
//     $FIGURE @ATTACH (0,-3) => @SET-SYMBOL %nmos_draw;
//     @LINE {(-4,-9) (-4,-3) (-4,3) (-3,3)}; @LINE {(-4,-3) (-3,-3)};
//     @LINE {(0,5) (0,6) (0,7)}; @LINE {(0,1) (2,1) (2,6) (0,6)};
//     @LINE {(0,-5) (0,-6) (0,-7)}; @LINE {(0,-1) (2,-1) (2,-6) (0,-6)};
//     $JUNCTION @ATTACH (-4,-3) => @SET-SYMBOL $JUNCTION_SYMBOL;
//     $JUNCTION @ATTACH (0,6) => @SET-SYMBOL $JUNCTION_SYMBOL;
//     $JUNCTION @ATTACH (0,-6) => @SET-SYMBOL $JUNCTION_SYMBOL;
//     (0.5,4.05) @TEXT("MP", size=0.65); (0.5,-2.6) @TEXT("MN", size=0.65);
//     ? @TEXT("${name}", key="name", size=0.75, halign="middle") => @PLACE(-0.3,-0.25);
//   }; # @SET-SYMBOL %load;
//   #MP @SET-SYMBOL $PMOS; #MN @SET-SYMBOL $NMOS;
//   {#MN #MP} @GROUP; {#MN #MP} @TEXT("", key="model");
//   #MP @PLACE(0,5) => @ORIENT("R0");
//   #MN @PLACE(0,-5) => @ORIENT("R0");
//   %ga=(-6,0);
//   %vp=(0,10);
//   %vn=(0,-10);
//   %pb=(4,5);
//   %nb=(4,-5);
//   %a=$IO_PORT @ATTACH &A => @PLACE(-10,0) => @ORIENT("R0");
//   %v=$SUPPLY @ATTACH &VDD => @PLACE(0,12) => @ORIENT("R0");
//   %g=$GROUND @ATTACH &VSS => @PLACE(0,-12) => @ORIENT("R0");
//   &A @WIRE(mode="straight") {%a:p %ga};
//   &A @WIRE(mode="straight") {#MP:g (-6,5) %ga (-6,-5) #MN:g};
//   &VDD @WIRE(mode="straight") {#MP:s %vp %v:p};
//   &VDD @WIRE(mode="straight") {#MP:d (4,3) %pb (4,10) %vp};
//   &VSS @WIRE(mode="straight") {#MN:s %vn %g:p};
//   &VSS @WIRE(mode="straight") {#MN:d (4,-3) %nb (4,-10) %vn};
//   #MN @TEXT("${name}", key="name", dx=5, dy=1, halign="start");
//   (-10,22) @TEXT("adc_clkgen_gatecap", size=1.2, textcolor="#334155", bold=true, halign="start");
//   (-10,20) @TEXT("Complementary MOS gate load", size=0.8, textcolor="#334155", bold=false, halign="start");
//   (-10,18) @TEXT("Each drain and source tied to its supply rail", size=0.75, textcolor="#334155", bold=false, halign="start");
//   (-10,-22) @TEXT("Implicit bodies: MP to VDD; MN to VSS. Both gates connect to A.", size=0.7, textcolor="#334155", bold=false, halign="start");
//   (-10,-17) @TEXT("MP: pch_ulvt_mac; W=wp, L=lp, nf=np", size=0.7, textcolor="#334155", bold=false, halign="start");
//   (-10,-19) @TEXT("MN: nch_ulvt_mac; W=wn, L=ln, nf=nn", size=0.7, textcolor="#334155", bold=false, halign="start");
//   $JUNCTION @ATTACH %ga;
//   $JUNCTION @ATTACH %vp;
//   $JUNCTION @ATTACH %vn;
// }
ends adc_clkgen_gatecap

subckt adc_clkgen (CLK PHI_S PHI_SB PHI_B PHI_BB CONV AVDD VSS)
// Sampling is inhibited until the loaded CONV output is low.
// Conversion is inhibited until both CLK and the loaded PHI_B output are low.
// Four physical inverter stages delay PHI_B relative to the loaded PHI_S.
// MOS gate loads slow internal edges without long-channel series resistance.
// CLK controls the lower NAND pull-down device to keep its internal node bounded.
XOFF (CONV coff AVDD VSS) adc_clkgen_inv wn=1.2u wp=1.8u nn=2 np=2
XSG (CLK coff sbar AVDD VSS) adc_clkgen_nand2 wn=800n wp=600n nn=2 np=2
XS1 (sbar s1 AVDD VSS) adc_clkgen_inv wn=1.2u wp=1.8u nn=2 np=2
XS2 (s1 s2 AVDD VSS) adc_clkgen_inv wn=2u wp=3u nn=4 np=4
XS3 (s2 PHI_S AVDD VSS) adc_clkgen_inv wn=8u wp=12u nn=8 np=12
XSB1 (sbar sb1 AVDD VSS) adc_clkgen_inv wn=600n wp=900n nn=2 np=2
XSB2 (sb1 PHI_SB AVDD VSS) adc_clkgen_inv wn=8u wp=12u nn=8 np=12
XB1 (PHI_S b1 AVDD VSS) adc_clkgen_inv wn=400n wp=600n nn=2 np=2
XB2 (b1 b2 AVDD VSS) adc_clkgen_inv wn=400n wp=600n nn=2 np=2
XB3 (b2 b3 AVDD VSS) adc_clkgen_inv wn=400n wp=600n nn=2 np=2
XB4 (b3 PHI_B AVDD VSS) adc_clkgen_inv wn=8u wp=4.8u nn=8 np=4
XBB1 (b3 bb1 AVDD VSS) adc_clkgen_inv wn=800n wp=1.2u nn=2 np=2
XBB2 (bb1 PHI_BB AVDD VSS) adc_clkgen_inv wn=2.4u wp=3.6u nn=4 np=4
XCG (CLK PHI_B ce AVDD VSS) adc_clkgen_nor2 wn=600n wp=1.8u nn=2 np=2
XC1 (ce cb AVDD VSS) adc_clkgen_inv wn=1.2u wp=1.8u nn=2 np=2
XC2 (cb CONV AVDD VSS) adc_clkgen_inv wn=2.4u wp=3.6u nn=4 np=4
XCS1 (s1 AVDD VSS) adc_clkgen_gatecap wn=2u wp=3u nn=4 np=4
XCS2 (s1 AVDD VSS) adc_clkgen_gatecap wn=2u wp=3u nn=4 np=4
XCS3 (s1 AVDD VSS) adc_clkgen_gatecap wn=2u wp=3u nn=4 np=4
XCB1 (b1 AVDD VSS) adc_clkgen_gatecap wn=2u wp=3u nn=4 np=4
XCB2 (b2 AVDD VSS) adc_clkgen_gatecap wn=2u wp=3u nn=4 np=4
XCC1 (cb AVDD VSS) adc_clkgen_gatecap wn=2u wp=3u nn=4 np=4
XCC2 (cb AVDD VSS) adc_clkgen_gatecap wn=2u wp=3u nn=4 np=4
XCE1 (ce AVDD VSS) adc_clkgen_gatecap wn=2u wp=3u nn=4 np=4
XCS4 (s1 AVDD VSS) adc_clkgen_gatecap wn=400n wp=600n nn=2 np=2
XCO1 (coff AVDD VSS) adc_clkgen_gatecap wn=400n wp=600n nn=2 np=2
XCO2 (coff AVDD VSS) adc_clkgen_gatecap wn=400n wp=600n nn=2 np=2
XCE2 (ce AVDD VSS) adc_clkgen_gatecap wn=400n wp=600n nn=2 np=2
// @RNL {
//   &AVDD @ADD-TO $SUPPLY_NET_SET; &VSS @ADD-TO $GROUND_NET_SET;
//   $clk_route = @DEFINE-STYLE(linecolor="#2563a6", textcolor="#2563a6") {};
//   $feedback_route = @DEFINE-STYLE(linecolor="#a75b13", textcolor="#a75b13") {};
//   $gate_ink = @DEFINE-STYLE(linecolor="#243b53", textcolor="#243b53") {};
//   # @SELECT-INSTANCE => @SET-STYLE $gate_ink;
//   {#XS1 #XS2 #XS3 #XSB1 #XSB2} @GROUP; {#XB1 #XB2 #XB3 #XB4 #XBB1 #XBB2} @GROUP;
//   {#XSG #XOFF} @GROUP; {#XCG #XC1 #XC2} @GROUP; {#XS3 #XSB2} @AS $MATCHED;
//   {#XCS1 #XCS2 #XCS3 #XCS4} @GROUP; {#XCB1 #XCB2} @GROUP; {#XCE1 #XCE2 #XCC1 #XCC2} @GROUP; {#XCO1 #XCO2} @GROUP;
//   #XSG @PLACE(8,0) => @ORIENT("R0");
//   #XSG @TEXT("${name}", key="name", dx=0, dy=2.5, size=0.95, halign="middle");
//   #XSG @TEXT("${wn}/${wp}", key="sizes", dx=0, dy=-3.5, size=0.75, halign="middle");
//   #XS1 @PLACE(20,0) => @ORIENT("R0");
//   #XS1 @TEXT("${name}", key="name", dx=0, dy=2.5, size=0.95, halign="middle");
//   #XS1 @TEXT("${wn}/${wp}", key="sizes", dx=0, dy=-3.5, size=0.75, halign="middle");
//   #XS2 @PLACE(32,0) => @ORIENT("R0");
//   #XS2 @TEXT("${name}", key="name", dx=0, dy=2.5, size=0.95, halign="middle");
//   #XS2 @TEXT("${wn}/${wp}", key="sizes", dx=0, dy=-3.5, size=0.75, halign="middle");
//   #XS3 @PLACE(44,0) => @ORIENT("R0");
//   #XS3 @TEXT("${name}", key="name", dx=0, dy=2.5, size=0.95, halign="middle");
//   #XS3 @TEXT("${wn}/${wp}", key="sizes", dx=0, dy=-3.5, size=0.75, halign="middle");
//   #XSB1 @PLACE(20,-12) => @ORIENT("R0");
//   #XSB1 @TEXT("${name}", key="name", dx=0, dy=2.5, size=0.95, halign="middle");
//   #XSB1 @TEXT("${wn}/${wp}", key="sizes", dx=0, dy=-3.5, size=0.75, halign="middle");
//   #XSB2 @PLACE(44,-12) => @ORIENT("R0");
//   #XSB2 @TEXT("${name}", key="name", dx=0, dy=2.5, size=0.95, halign="middle");
//   #XSB2 @TEXT("${wn}/${wp}", key="sizes", dx=0, dy=-3.5, size=0.75, halign="middle");
//   #XB1 @PLACE(64,0) => @ORIENT("R0");
//   #XB1 @TEXT("${name}", key="name", dx=0, dy=2.5, size=0.95, halign="middle");
//   #XB1 @TEXT("${wn}/${wp}", key="sizes", dx=0, dy=-3.5, size=0.75, halign="middle");
//   #XB2 @PLACE(76,0) => @ORIENT("R0");
//   #XB2 @TEXT("${name}", key="name", dx=0, dy=2.5, size=0.95, halign="middle");
//   #XB2 @TEXT("${wn}/${wp}", key="sizes", dx=0, dy=-3.5, size=0.75, halign="middle");
//   #XB3 @PLACE(88,0) => @ORIENT("R0");
//   #XB3 @TEXT("${name}", key="name", dx=0, dy=2.5, size=0.95, halign="middle");
//   #XB3 @TEXT("${wn}/${wp}", key="sizes", dx=0, dy=-3.5, size=0.75, halign="middle");
//   #XB4 @PLACE(100,0) => @ORIENT("R0");
//   #XB4 @TEXT("${name}", key="name", dx=0, dy=2.5, size=0.95, halign="middle");
//   #XB4 @TEXT("${wn}/${wp}", key="sizes", dx=0, dy=-3.5, size=0.75, halign="middle");
//   #XBB1 @PLACE(100,-12) => @ORIENT("R0");
//   #XBB1 @TEXT("${name}", key="name", dx=0, dy=2.5, size=0.95, halign="middle");
//   #XBB1 @TEXT("${wn}/${wp}", key="sizes", dx=0, dy=-3.5, size=0.75, halign="middle");
//   #XBB2 @PLACE(116,-12) => @ORIENT("R0");
//   #XBB2 @TEXT("${name}", key="name", dx=0, dy=2.5, size=0.95, halign="middle");
//   #XBB2 @TEXT("${wn}/${wp}", key="sizes", dx=0, dy=-3.5, size=0.75, halign="middle");
//   #XCG @PLACE(120,0) => @ORIENT("R0");
//   #XCG @TEXT("${name}", key="name", dx=0, dy=2.5, size=0.95, halign="middle");
//   #XCG @TEXT("${wn}/${wp}", key="sizes", dx=0, dy=-3.5, size=0.75, halign="middle");
//   #XC1 @PLACE(132,0) => @ORIENT("R0");
//   #XC1 @TEXT("${name}", key="name", dx=0, dy=2.5, size=0.95, halign="middle");
//   #XC1 @TEXT("${wn}/${wp}", key="sizes", dx=0, dy=-3.5, size=0.75, halign="middle");
//   #XC2 @PLACE(144,0) => @ORIENT("R0");
//   #XC2 @TEXT("${name}", key="name", dx=0, dy=2.5, size=0.95, halign="middle");
//   #XC2 @TEXT("${wn}/${wp}", key="sizes", dx=0, dy=-3.5, size=0.75, halign="middle");
//   #XOFF @PLACE(2,41) => @ORIENT("MY");
//   #XOFF @TEXT("${name}", key="name", dx=0, dy=2.5, size=0.95, halign="middle");
//   #XOFF @TEXT("${wn}/${wp}", key="sizes", dx=0, dy=-3.5, size=0.75, halign="middle");
//   #XCO1 @PLACE(-12,20) => @ORIENT("R0");
//   %v_XCO1=$SUPPLY @ATTACH &AVDD => @PLACE(-12,28) => @ORIENT("R0");
//   %g_XCO1=$GROUND @ATTACH &VSS => @PLACE(-12,12) => @ORIENT("R0");
//   &AVDD @WIRE(mode="straight") {#XCO1:VDD %v_XCO1:p};
//   &VSS @WIRE(mode="straight") {#XCO1:VSS %g_XCO1:p};
//   #XCO2 @PLACE(-3,20) => @ORIENT("R0");
//   %v_XCO2=$SUPPLY @ATTACH &AVDD => @PLACE(-3,28) => @ORIENT("R0");
//   %g_XCO2=$GROUND @ATTACH &VSS => @PLACE(-3,12) => @ORIENT("R0");
//   &AVDD @WIRE(mode="straight") {#XCO2:VDD %v_XCO2:p};
//   &VSS @WIRE(mode="straight") {#XCO2:VSS %g_XCO2:p};
//   #XCS1 @PLACE(14,20) => @ORIENT("R0");
//   %v_XCS1=$SUPPLY @ATTACH &AVDD => @PLACE(14,28) => @ORIENT("R0");
//   %g_XCS1=$GROUND @ATTACH &VSS => @PLACE(14,12) => @ORIENT("R0");
//   &AVDD @WIRE(mode="straight") {#XCS1:VDD %v_XCS1:p};
//   &VSS @WIRE(mode="straight") {#XCS1:VSS %g_XCS1:p};
//   #XCS2 @PLACE(24,20) => @ORIENT("R0");
//   %v_XCS2=$SUPPLY @ATTACH &AVDD => @PLACE(24,28) => @ORIENT("R0");
//   %g_XCS2=$GROUND @ATTACH &VSS => @PLACE(24,12) => @ORIENT("R0");
//   &AVDD @WIRE(mode="straight") {#XCS2:VDD %v_XCS2:p};
//   &VSS @WIRE(mode="straight") {#XCS2:VSS %g_XCS2:p};
//   #XCS3 @PLACE(34,20) => @ORIENT("R0");
//   %v_XCS3=$SUPPLY @ATTACH &AVDD => @PLACE(34,28) => @ORIENT("R0");
//   %g_XCS3=$GROUND @ATTACH &VSS => @PLACE(34,12) => @ORIENT("R0");
//   &AVDD @WIRE(mode="straight") {#XCS3:VDD %v_XCS3:p};
//   &VSS @WIRE(mode="straight") {#XCS3:VSS %g_XCS3:p};
//   #XCS4 @PLACE(44,20) => @ORIENT("R0");
//   %v_XCS4=$SUPPLY @ATTACH &AVDD => @PLACE(44,28) => @ORIENT("R0");
//   %g_XCS4=$GROUND @ATTACH &VSS => @PLACE(44,12) => @ORIENT("R0");
//   &AVDD @WIRE(mode="straight") {#XCS4:VDD %v_XCS4:p};
//   &VSS @WIRE(mode="straight") {#XCS4:VSS %g_XCS4:p};
//   #XCB1 @PLACE(70,20) => @ORIENT("R0");
//   %v_XCB1=$SUPPLY @ATTACH &AVDD => @PLACE(70,28) => @ORIENT("R0");
//   %g_XCB1=$GROUND @ATTACH &VSS => @PLACE(70,12) => @ORIENT("R0");
//   &AVDD @WIRE(mode="straight") {#XCB1:VDD %v_XCB1:p};
//   &VSS @WIRE(mode="straight") {#XCB1:VSS %g_XCB1:p};
//   #XCB2 @PLACE(82,20) => @ORIENT("R0");
//   %v_XCB2=$SUPPLY @ATTACH &AVDD => @PLACE(82,28) => @ORIENT("R0");
//   %g_XCB2=$GROUND @ATTACH &VSS => @PLACE(82,12) => @ORIENT("R0");
//   &AVDD @WIRE(mode="straight") {#XCB2:VDD %v_XCB2:p};
//   &VSS @WIRE(mode="straight") {#XCB2:VSS %g_XCB2:p};
//   #XCE1 @PLACE(120,20) => @ORIENT("R0");
//   %v_XCE1=$SUPPLY @ATTACH &AVDD => @PLACE(120,28) => @ORIENT("R0");
//   %g_XCE1=$GROUND @ATTACH &VSS => @PLACE(120,12) => @ORIENT("R0");
//   &AVDD @WIRE(mode="straight") {#XCE1:VDD %v_XCE1:p};
//   &VSS @WIRE(mode="straight") {#XCE1:VSS %g_XCE1:p};
//   #XCE2 @PLACE(129,20) => @ORIENT("R0");
//   %v_XCE2=$SUPPLY @ATTACH &AVDD => @PLACE(129,28) => @ORIENT("R0");
//   %g_XCE2=$GROUND @ATTACH &VSS => @PLACE(129,12) => @ORIENT("R0");
//   &AVDD @WIRE(mode="straight") {#XCE2:VDD %v_XCE2:p};
//   &VSS @WIRE(mode="straight") {#XCE2:VSS %g_XCE2:p};
//   #XCC1 @PLACE(141,20) => @ORIENT("R0");
//   %v_XCC1=$SUPPLY @ATTACH &AVDD => @PLACE(141,28) => @ORIENT("R0");
//   %g_XCC1=$GROUND @ATTACH &VSS => @PLACE(141,12) => @ORIENT("R0");
//   &AVDD @WIRE(mode="straight") {#XCC1:VDD %v_XCC1:p};
//   &VSS @WIRE(mode="straight") {#XCC1:VSS %g_XCC1:p};
//   #XCC2 @PLACE(150,20) => @ORIENT("R0");
//   %v_XCC2=$SUPPLY @ATTACH &AVDD => @PLACE(150,28) => @ORIENT("R0");
//   %g_XCC2=$GROUND @ATTACH &VSS => @PLACE(150,12) => @ORIENT("R0");
//   &AVDD @WIRE(mode="straight") {#XCC2:VDD %v_XCC2:p};
//   &VSS @WIRE(mode="straight") {#XCC2:VSS %g_XCC2:p};
//   %clk=(-24,1);
//   %coff=(-18,6);
//   %sbar=(14,0);
//   %s1=(26,0);
//   %s=(52,0);
//   %b1=(70,0);
//   %b2=(82,0);
//   %b3=(94,0);
//   %b=(108,0);
//   %ce=(126,0);
//   %cb=(138,0);
//   %conv=(156,0);
//   %pclk=$IO_PORT @ATTACH &CLK => @PLACE(-28,1) => @ORIENT("R0");
//   %ps=$IO_PORT @ATTACH &PHI_S => @PLACE(56,6) => @ORIENT("MY");
//   %psb=$IO_PORT @ATTACH &PHI_SB => @PLACE(56,-12) => @ORIENT("MY");
//   %pbb=$IO_PORT @ATTACH &PHI_BB => @PLACE(128,-12) => @ORIENT("MY");
//   %pc=$IO_PORT @ATTACH &CONV => @PLACE(164,0) => @ORIENT("MY");
//   %pb=$IO_PORT @ATTACH &PHI_B => @PLACE(104,6) => @ORIENT("R0");
//   &CLK @WIRE(mode="straight") {%pclk:p %clk #XSG:A} => @SET-STYLE $clk_route;
//   &CLK @WIRE(mode="straight") {%clk (-24,49) (114,49) (114,1) #XCG:A} => @SET-STYLE $clk_route;
//   &CONV @WIRE(mode="straight") {#XC2:Y %conv %pc:p} => @SET-STYLE $feedback_route;
//   &CONV @WIRE(mode="straight") {%conv (156,41) #XOFF:A} => @SET-STYLE $feedback_route;
//   &coff @WIRE(mode="straight") {#XOFF:Y (-18,41) %coff (-18,-1) #XSG:B} => @SET-STYLE $feedback_route;
//   &sbar @WIRE(mode="straight") {#XSG:Y %sbar #XS1:A};
//   &sbar @WIRE(mode="straight") {%sbar (14,-12) #XSB1:A};
//   &s1 @WIRE(mode="straight") {#XS1:Y %s1 #XS2:A};
//   &s2 @WIRE(mode="straight") {#XS2:Y #XS3:A};
//   &sb1 @WIRE(mode="straight") {#XSB1:Y #XSB2:A};
//   &PHI_S @WIRE(mode="straight") {#XS3:Y %s #XB1:A};
//   &PHI_S @WIRE(mode="straight") {%s (52,6) %ps:p};
//   &PHI_SB @WIRE(mode="straight") {#XSB2:Y %psb:p};
//   &b1 @WIRE(mode="straight") {#XB1:Y %b1 #XB2:A};
//   &b2 @WIRE(mode="straight") {#XB2:Y %b2 #XB3:A};
//   &b3 @WIRE(mode="straight") {#XB3:Y %b3 #XB4:A};
//   &b3 @WIRE(mode="straight") {%b3 (94,-12) #XBB1:A};
//   &bb1 @WIRE(mode="straight") {#XBB1:Y #XBB2:A};
//   &PHI_B @WIRE(mode="straight") {#XB4:Y %b (114,0) (114,-1) #XCG:B};
//   &PHI_B @WIRE(mode="straight") {%b (108,6) %pb:p};
//   &PHI_BB @WIRE(mode="straight") {#XBB2:Y %pbb:p};
//   &ce @WIRE(mode="straight") {#XCG:Y %ce #XC1:A};
//   &cb @WIRE(mode="straight") {#XC1:Y %cb #XC2:A};
//   %tap_XCO1=(-16,6);
//   %tap_XCO2=(-7,6);
//   &coff @WIRE(mode="straight") {%coff %tap_XCO1 %tap_XCO2} => @SET-STYLE $feedback_route;
//   &coff @WIRE(mode="straight") {%tap_XCO1 #XCO1:A};
//   &coff @WIRE(mode="straight") {%tap_XCO2 #XCO2:A};
//   %bank_s1=(26,6);
//   &s1 @WIRE(mode="straight") {%s1 %bank_s1};
//   %tap_XCS1=(10,6);
//   %tap_XCS2=(20,6);
//   %tap_XCS3=(30,6);
//   %tap_XCS4=(40,6);
//   &s1 @WIRE(mode="straight") {%tap_XCS1 %tap_XCS2 %bank_s1 %tap_XCS3 %tap_XCS4};
//   &s1 @WIRE(mode="straight") {%tap_XCS1 #XCS1:A};
//   &s1 @WIRE(mode="straight") {%tap_XCS2 #XCS2:A};
//   &s1 @WIRE(mode="straight") {%tap_XCS3 #XCS3:A};
//   &s1 @WIRE(mode="straight") {%tap_XCS4 #XCS4:A};
//   &b1 @WIRE(mode="straight") {%b1 (70,6) (66,6) #XCB1:A};
//   &b2 @WIRE(mode="straight") {%b2 (82,6) (78,6) #XCB2:A};
//   %bank_ce=(126,6);
//   &ce @WIRE(mode="straight") {%ce %bank_ce};
//   %tap_XCE1=(116,6);
//   %tap_XCE2=(125,6);
//   &ce @WIRE(mode="straight") {%tap_XCE1 %tap_XCE2 %bank_ce};
//   &ce @WIRE(mode="straight") {%tap_XCE1 #XCE1:A};
//   &ce @WIRE(mode="straight") {%tap_XCE2 #XCE2:A};
//   %bank_cb=(138,6);
//   &cb @WIRE(mode="straight") {%cb %bank_cb};
//   %tap_XCC1=(137,6);
//   %tap_XCC2=(146,6);
//   &cb @WIRE(mode="straight") {%tap_XCC1 %bank_cb %tap_XCC2};
//   &cb @WIRE(mode="straight") {%tap_XCC1 #XCC1:A};
//   &cb @WIRE(mode="straight") {%tap_XCC2 #XCC2:A};
//   (-28,57) @TEXT("adc_clkgen | static CMOS phase generator", size=1.6, textcolor="#334155", bold=true, halign="start");
//   (-28,54) @TEXT("16 standard logic gates + 12 visibly expanded complementary MOS loads = 60 MOS", size=1.0, textcolor="#334155", bold=false, halign="start");
//   (16,50.5) @TEXT("CLK: immediate turn-off path", size=0.9, textcolor="#2563a6", bold=false, halign="start");
//   (27,42.5) @TEXT("Loaded CONV feedback: sampling waits for conversion turn-off", size=1.0, textcolor="#a75b13", bold=false, halign="start");
//   (-18,34) @TEXT("Sample interlock", size=0.95, textcolor="#334155", bold=true, halign="start");
//   (10,34) @TEXT("Sample drivers", size=0.95, textcolor="#334155", bold=true, halign="start");
//   (63,34) @TEXT("Four-stage S-to-B delay", size=0.95, textcolor="#334155", bold=true, halign="start");
//   (120,34) @TEXT("Conversion interlock", size=0.95, textcolor="#334155", bold=true, halign="start");
//   (-28,-20) @TEXT("Logic-gate supplies: VDD=AVDD, VSS=VSS. All drawn pMOS bodies connect to AVDD; all nMOS bodies connect to VSS.", size=0.9, textcolor="#334155", bold=false, halign="start");
//   (-28,-23) @TEXT("Below each gate: total Wn/Wp; L=30n. Each load shows its real MP/MN, common A, and D/S supply ties; L=90n.", size=0.9, textcolor="#334155", bold=false, halign="start");
//   (-28,-26) @TEXT("Load Wn/Wp=2u/3u, except XCS4, XCO1, XCO2, XCE2=400n/600n. Dots appear only at real T or cross junctions.", size=0.9, textcolor="#334155", bold=false, halign="start");
//   $JUNCTION @ATTACH %clk;
//   $JUNCTION @ATTACH %coff;
//   $JUNCTION @ATTACH %sbar;
//   $JUNCTION @ATTACH %s1;
//   $JUNCTION @ATTACH %s;
//   $JUNCTION @ATTACH %b1;
//   $JUNCTION @ATTACH %b2;
//   $JUNCTION @ATTACH %b3;
//   $JUNCTION @ATTACH %b;
//   $JUNCTION @ATTACH %ce;
//   $JUNCTION @ATTACH %cb;
//   $JUNCTION @ATTACH %conv;
//   $JUNCTION @ATTACH %tap_XCO1;
//   $JUNCTION @ATTACH %bank_s1;
//   $JUNCTION @ATTACH %tap_XCS2;
//   $JUNCTION @ATTACH %tap_XCS3;
//   $JUNCTION @ATTACH %tap_XCE2;
//   $JUNCTION @ATTACH %bank_cb;
// }
ends adc_clkgen
