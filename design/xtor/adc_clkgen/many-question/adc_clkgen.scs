// adc_clkgen transistor view: static CMOS, loaded-output interlocks.
// @RNL(type="header") {
//   @VERSION("0.3");
//   @USE-PACKAGE(name="adc28", version="0.1", path="../../../rnl/adc28.rnl");
// }
simulator lang=spectre

// Sizes are total channel widths; each device's finger count is explicit.
// Primitive-cell schematics and top-level routing below are manually authored.
subckt adc_clkgen_inv (A Y VDD VSS)
parameters wn=400n wp=600n ln=30n lp=30n nn=2 np=2
MN (Y A VSS VSS) nch_ulvt_mac w=wn l=ln nf=nn
MP (Y A VDD VDD) pch_ulvt_mac w=wp l=lp nf=np
// @RNL {
//   &VDD @ADD-TO $SUPPLY_NET_SET; &VSS @ADD-TO $GROUND_NET_SET;
//   # @SET-SYMBOL $INVERTER;
//   {#MN #MP} @GROUP; {#MN #MP} @TEXT("", key="model");
//   #MP @PLACE(0,5) => @ORIENT("R0");
//   #MN @PLACE(0,-5) => @ORIENT("R0");
//   %ga=(-6,0); $JUNCTION @ATTACH %ga;
//   %out=(0,0); $JUNCTION @ATTACH %out;
//   %vp=(0,10); $JUNCTION @ATTACH %vp;
//   %vn=(0,-10); $JUNCTION @ATTACH %vn;
//   %a=$IO_PORT @ATTACH &A => @PLACE(-10,0) => @ORIENT("R0");
//   %y=$IO_PORT @ATTACH &Y => @PLACE(8,0) => @ORIENT("MY");
//   %v=$SUPPLY @ATTACH &VDD => @PLACE(0,12) => @ORIENT("R0");
//   %g=$GROUND @ATTACH &VSS => @PLACE(0,-12) => @ORIENT("R0");
//   &A @WIRE(mode="straight") {%a:p %ga};
//   &A @WIRE(mode="straight") {#MP:g (-6,5) %ga (-6,-5) #MN:g};
//   &Y @WIRE(mode="straight") {#MP:d %out #MN:d};
//   &Y @WIRE(mode="straight") {%out %y:p};
//   &VDD @WIRE(mode="straight") {#MP:s %vp %v:p};
//   &VDD @WIRE(mode="straight") {#MP:b (4,5) (4,10) %vp};
//   &VSS @WIRE(mode="straight") {#MN:s %vn %g:p};
//   &VSS @WIRE(mode="straight") {#MN:b (4,-5) (4,-10) %vn};
//   (-10,20) @TEXT("adc_clkgen_inv", size=1.2, textcolor="#334155", bold=true, halign="start");
//   (-10,18) @TEXT("Y = NOT A; explicit source and body ties", size=0.8, textcolor="#334155", bold=false, halign="start");
//   (-10,-17) @TEXT("MP: pch_ulvt_mac; W=wp, L=lp, nf=np", size=0.7, textcolor="#334155", bold=false, halign="start");
//   (-10,-19) @TEXT("MN: nch_ulvt_mac; W=wn, L=ln, nf=nn", size=0.7, textcolor="#334155", bold=false, halign="start");
// }
ends adc_clkgen_inv

subckt adc_clkgen_nand2 (A B Y VDD VSS)
parameters wn=800n wp=600n nn=2 np=2
MNA (Y B nx VSS) nch_ulvt_mac w=wn l=30n nf=nn
MNB (nx A VSS VSS) nch_ulvt_mac w=wn l=30n nf=nn
MPA (Y A VDD VDD) pch_ulvt_mac w=wp l=30n nf=np
MPB (Y B VDD VDD) pch_ulvt_mac w=wp l=30n nf=np
// @RNL {
//   &VDD @ADD-TO $SUPPLY_NET_SET; &VSS @ADD-TO $GROUND_NET_SET;
//   # @SET-SYMBOL $NAND_2INPUT;
//   {#MNA #MNB} @AS $MATCHED; {#MPA #MPB} @AS $MATCHED;
//   {#MNA #MNB #MPA #MPB} @GROUP; {#MNA #MNB #MPA #MPB} @TEXT("", key="model");
//   #MPA @PLACE(-4,6) => @ORIENT("R0");
//   #MPB @PLACE(6,6) => @ORIENT("R0");
//   #MNA @PLACE(0,-2) => @ORIENT("R0");
//   #MNB @PLACE(0,-10) => @ORIENT("R0");
//   %a1=(-10,6); $JUNCTION @ATTACH %a1;
//   %b1=(-12,-2); $JUNCTION @ATTACH %b1;
//   %yp=(-4,2); $JUNCTION @ATTACH %yp;
//   %y1=(0,2); $JUNCTION @ATTACH %y1;
//   %yb=(6,2); $JUNCTION @ATTACH %yb;
//   %vp=(-4,13); $JUNCTION @ATTACH %vp;
//   %v0=(0,13); $JUNCTION @ATTACH %v0;
//   %vb=(6,13); $JUNCTION @ATTACH %vb;
//   %g1=(0,-16); $JUNCTION @ATTACH %g1;
//   %g2=(10,-10); $JUNCTION @ATTACH %g2;
//   %a=$IO_PORT @ATTACH &A => @PLACE(-17,6) => @ORIENT("R0");
//   %b=$IO_PORT @ATTACH &B => @PLACE(-17,-2) => @ORIENT("R0");
//   %y=$IO_PORT @ATTACH &Y => @PLACE(16,2) => @ORIENT("MY");
//   %v=$SUPPLY @ATTACH &VDD => @PLACE(0,16) => @ORIENT("R0");
//   %g=$GROUND @ATTACH &VSS => @PLACE(0,-18) => @ORIENT("R0");
//   &A @WIRE(mode="straight") {%a:p %a1 #MPA:g};
//   &A @WIRE(mode="straight") {%a1 (-10,-10) #MNB:g};
//   &B @WIRE(mode="straight") {%b:p %b1 #MNA:g};
//   &B @WIRE(mode="straight") {%b1 (-12,11) (3,11) #MPB:g};
//   &Y @WIRE(mode="straight") {#MPA:d %yp %y1 %yb %y:p};
//   &Y @WIRE(mode="straight") {#MPB:d %yb};
//   &Y @WIRE(mode="straight") {%y1 #MNA:d};
//   &nx @WIRE(mode="straight") {#MNA:s #MNB:d};
//   &VDD @WIRE(mode="straight") {#MPA:s %vp %v0 %vb #MPB:s};
//   &VDD @WIRE(mode="straight") {%v0 %v:p};
//   &VDD @WIRE(mode="straight") {#MPA:b (-1,6) (-1,13) %v0};
//   &VDD @WIRE(mode="straight") {#MPB:b (10,6) (10,13) %vb};
//   &VSS @WIRE(mode="straight") {#MNB:s %g1 %g:p};
//   &VSS @WIRE(mode="straight") {#MNA:b (10,-2) %g2 (10,-16) %g1};
//   &VSS @WIRE(mode="straight") {#MNB:b %g2};
//   (-17,24) @TEXT("adc_clkgen_nand2", size=1.2, textcolor="#334155", bold=true, halign="start");
//   (-17,22) @TEXT("Y = NOT (A AND B); A controls the lower NMOS", size=0.8, textcolor="#334155", bold=false, halign="start");
//   (-17,-23) @TEXT("MPA/MPB: pch_ulvt_mac; W=wp, L=30n, nf=np", size=0.7, textcolor="#334155", bold=false, halign="start");
//   (-17,-25) @TEXT("MNA/MNB: nch_ulvt_mac; W=wn, L=30n, nf=nn", size=0.7, textcolor="#334155", bold=false, halign="start");
// }
ends adc_clkgen_nand2

subckt adc_clkgen_nor2 (A B Y VDD VSS)
parameters wn=1.2u wp=3.6u nn=2 np=4
MNA (Y A VSS VSS) nch_ulvt_mac w=wn l=30n nf=nn
MNB (Y B VSS VSS) nch_ulvt_mac w=wn l=30n nf=nn
MPA (px A VDD VDD) pch_ulvt_mac w=wp l=30n nf=np
MPB (Y B px VDD) pch_ulvt_mac w=wp l=30n nf=np
// @RNL {
//   &VDD @ADD-TO $SUPPLY_NET_SET; &VSS @ADD-TO $GROUND_NET_SET;
//   # @SET-SYMBOL $NOR_2INPUT;
//   {#MNA #MNB} @AS $MATCHED; {#MPA #MPB} @AS $MATCHED;
//   {#MNA #MNB #MPA #MPB} @GROUP; {#MNA #MNB #MPA #MPB} @TEXT("", key="model");
//   #MPA @PLACE(0,10) => @ORIENT("R0");
//   #MPB @PLACE(0,2) => @ORIENT("R0");
//   #MNA @PLACE(-5,-7) => @ORIENT("R0");
//   #MNB @PLACE(7,-7) => @ORIENT("R0");
//   %a1=(-12,10); $JUNCTION @ATTACH %a1;
//   %b1=(-6,2); $JUNCTION @ATTACH %b1;
//   %y1=(0,-2); $JUNCTION @ATTACH %y1;
//   %ya=(-5,-2); $JUNCTION @ATTACH %ya;
//   %yb=(7,-2); $JUNCTION @ATTACH %yb;
//   %v1=(0,15); $JUNCTION @ATTACH %v1;
//   %pb=(11,10); $JUNCTION @ATTACH %pb;
//   %ga=(-5,-13); $JUNCTION @ATTACH %ga;
//   %gb=(7,-13); $JUNCTION @ATTACH %gb;
//   %g0=(0,-13); $JUNCTION @ATTACH %g0;
//   %gba=(-2,-13); $JUNCTION @ATTACH %gba;
//   %gbb=(11,-13); $JUNCTION @ATTACH %gbb;
//   %a=$IO_PORT @ATTACH &A => @PLACE(-17,10) => @ORIENT("R0");
//   %b=$IO_PORT @ATTACH &B => @PLACE(-17,2) => @ORIENT("R0");
//   %y=$IO_PORT @ATTACH &Y => @PLACE(16,-2) => @ORIENT("MY");
//   %v=$SUPPLY @ATTACH &VDD => @PLACE(0,17) => @ORIENT("R0");
//   %g=$GROUND @ATTACH &VSS => @PLACE(0,-16) => @ORIENT("R0");
//   &A @WIRE(mode="straight") {%a:p %a1 #MPA:g};
//   &A @WIRE(mode="straight") {%a1 (-12,-7) #MNA:g};
//   &B @WIRE(mode="straight") {%b:p %b1 #MPB:g};
//   &B @WIRE(mode="straight") {%b1 (-6,-1) (3,-1) (3,-7) #MNB:g};
//   &px @WIRE(mode="straight") {#MPA:d #MPB:s};
//   &Y @WIRE(mode="straight") {#MPB:d %y1 %yb %y:p};
//   &Y @WIRE(mode="straight") {#MNA:d %ya %y1};
//   &Y @WIRE(mode="straight") {%yb #MNB:d};
//   &VDD @WIRE(mode="straight") {#MPA:s %v1 %v:p};
//   &VDD @WIRE(mode="straight") {#MPB:b (11,2) %pb (11,15) %v1};
//   &VDD @WIRE(mode="straight") {#MPA:b %pb};
//   &VSS @WIRE(mode="straight") {#MNA:s %ga %gba %g0 %gb %gbb};
//   &VSS @WIRE(mode="straight") {#MNB:s %gb};
//   &VSS @WIRE(mode="straight") {%g0 %g:p};
//   &VSS @WIRE(mode="straight") {#MNA:b (-2,-7) %gba};
//   &VSS @WIRE(mode="straight") {#MNB:b (11,-7) %gbb};
//   (-17,25) @TEXT("adc_clkgen_nor2", size=1.2, textcolor="#334155", bold=true, halign="start");
//   (-17,23) @TEXT("Y = NOT (A OR B); series PMOS, parallel NMOS", size=0.8, textcolor="#334155", bold=false, halign="start");
//   (-17,-21) @TEXT("MPA/MPB: pch_ulvt_mac; W=wp, L=30n, nf=np", size=0.7, textcolor="#334155", bold=false, halign="start");
//   (-17,-23) @TEXT("MNA/MNB: nch_ulvt_mac; W=wn, L=30n, nf=nn", size=0.7, textcolor="#334155", bold=false, halign="start");
// }
ends adc_clkgen_nor2

subckt adc_clkgen_gatecap (A VDD VSS)
parameters wn=2u wp=3u ln=90n lp=90n nn=4 np=4
MN (VSS A VSS VSS) nch_ulvt_mac w=wn l=ln nf=nn
MP (VDD A VDD VDD) pch_ulvt_mac w=wp l=lp nf=np
// @RNL {
//   &VDD @ADD-TO $SUPPLY_NET_SET; &VSS @ADD-TO $GROUND_NET_SET;
//   /* Gate load is a two-MOS subcircuit, not a logic gate or an ideal capacitor. */
//   %load = @DEFINE-SYMBOL(box=[-2,-3,2,2]) {
//     @RECTANGLE {(-2,-1.5) (2,1.5)};
//     (0,-3) @PIN(terminal=1, direction="down"); @LINE {(0,-3) (0,-1.5)};
//     (0,-0.25) @TEXT("2 MOS", halign="middle", size=0.65);
//     ? @TEXT("${name}", key="name", size=0.9, halign="middle") => @PLACE(0,2.5);
//   }; # @SET-SYMBOL %load;
//   {#MN #MP} @GROUP; {#MN #MP} @TEXT("", key="model");
//   #MP @PLACE(0,5) => @ORIENT("R0");
//   #MN @PLACE(0,-5) => @ORIENT("R0");
//   %ga=(-6,0); $JUNCTION @ATTACH %ga;
//   %vp=(0,10); $JUNCTION @ATTACH %vp;
//   %vn=(0,-10); $JUNCTION @ATTACH %vn;
//   %pb=(4,5); $JUNCTION @ATTACH %pb;
//   %nb=(4,-5); $JUNCTION @ATTACH %nb;
//   %a=$IO_PORT @ATTACH &A => @PLACE(-10,0) => @ORIENT("R0");
//   %v=$SUPPLY @ATTACH &VDD => @PLACE(0,12) => @ORIENT("R0");
//   %g=$GROUND @ATTACH &VSS => @PLACE(0,-12) => @ORIENT("R0");
//   &A @WIRE(mode="straight") {%a:p %ga};
//   &A @WIRE(mode="straight") {#MP:g (-6,5) %ga (-6,-5) #MN:g};
//   &VDD @WIRE(mode="straight") {#MP:s %vp %v:p};
//   &VDD @WIRE(mode="straight") {#MP:d (4,3) %pb (4,10) %vp};
//   &VDD @WIRE(mode="straight") {#MP:b %pb};
//   &VSS @WIRE(mode="straight") {#MN:s %vn %g:p};
//   &VSS @WIRE(mode="straight") {#MN:d (4,-3) %nb (4,-10) %vn};
//   &VSS @WIRE(mode="straight") {#MN:b %nb};
//   #MN @TEXT("${name}", key="name", dx=5, dy=1, halign="start");
//   (-10,22) @TEXT("adc_clkgen_gatecap", size=1.2, textcolor="#334155", bold=true, halign="start");
//   (-10,20) @TEXT("Complementary MOS gate load", size=0.8, textcolor="#334155", bold=false, halign="start");
//   (-10,18) @TEXT("Source, drain and body tied to each rail", size=0.75, textcolor="#334155", bold=false, halign="start");
//   (-10,-17) @TEXT("MP: pch_ulvt_mac; W=wp, L=lp, nf=np", size=0.7, textcolor="#334155", bold=false, halign="start");
//   (-10,-19) @TEXT("MN: nch_ulvt_mac; W=wn, L=ln, nf=nn", size=0.7, textcolor="#334155", bold=false, halign="start");
// }
ends adc_clkgen_gatecap

subckt adc_clkgen (CLK PHI_S PHI_SB PHI_B PHI_BB CONV AVDD VSS)
// Sampling is inhibited until the loaded CONV output is low.
// Conversion is inhibited until both CLK and the loaded PHI_B output are low.
// Four physical inverter stages delay PHI_B relative to the loaded PHI_S.
// MOS gate loads slow internal edges without long-channel series resistance.
// CLK controls the lower NAND pull-down device to keep its internal node bounded.
XOFF (CONV coff AVDD VSS) adc_clkgen_inv wn=1.2u wp=1.8u nn=2 np=2
XSG (CLK coff sbar AVDD VSS) adc_clkgen_nand2 wn=800n wp=600n nn=2 np=2
XS1 (sbar s1 AVDD VSS) adc_clkgen_inv wn=1.2u wp=1.8u nn=2 np=2
XS2 (s1 s2 AVDD VSS) adc_clkgen_inv wn=2u wp=3u nn=4 np=4
XS3 (s2 PHI_S AVDD VSS) adc_clkgen_inv wn=8u wp=12u nn=8 np=12
XSB1 (sbar sb1 AVDD VSS) adc_clkgen_inv wn=600n wp=900n nn=2 np=2
XSB2 (sb1 PHI_SB AVDD VSS) adc_clkgen_inv wn=8u wp=12u nn=8 np=12
XB1 (PHI_S b1 AVDD VSS) adc_clkgen_inv wn=400n wp=600n nn=2 np=2
XB2 (b1 b2 AVDD VSS) adc_clkgen_inv wn=400n wp=600n nn=2 np=2
XB3 (b2 b3 AVDD VSS) adc_clkgen_inv wn=400n wp=600n nn=2 np=2
XB4 (b3 PHI_B AVDD VSS) adc_clkgen_inv wn=8u wp=4.8u nn=8 np=4
XBB1 (b3 bb1 AVDD VSS) adc_clkgen_inv wn=800n wp=1.2u nn=2 np=2
XBB2 (bb1 PHI_BB AVDD VSS) adc_clkgen_inv wn=2.4u wp=3.6u nn=4 np=4
XCG (CLK PHI_B ce AVDD VSS) adc_clkgen_nor2 wn=600n wp=1.8u nn=2 np=2
XC1 (ce cb AVDD VSS) adc_clkgen_inv wn=1.2u wp=1.8u nn=2 np=2
XC2 (cb CONV AVDD VSS) adc_clkgen_inv wn=2.4u wp=3.6u nn=4 np=4
XCS1 (s1 AVDD VSS) adc_clkgen_gatecap wn=2u wp=3u nn=4 np=4
XCS2 (s1 AVDD VSS) adc_clkgen_gatecap wn=2u wp=3u nn=4 np=4
XCS3 (s1 AVDD VSS) adc_clkgen_gatecap wn=2u wp=3u nn=4 np=4
XCB1 (b1 AVDD VSS) adc_clkgen_gatecap wn=2u wp=3u nn=4 np=4
XCB2 (b2 AVDD VSS) adc_clkgen_gatecap wn=2u wp=3u nn=4 np=4
XCC1 (cb AVDD VSS) adc_clkgen_gatecap wn=2u wp=3u nn=4 np=4
XCC2 (cb AVDD VSS) adc_clkgen_gatecap wn=2u wp=3u nn=4 np=4
XCE1 (ce AVDD VSS) adc_clkgen_gatecap wn=2u wp=3u nn=4 np=4
XCS4 (s1 AVDD VSS) adc_clkgen_gatecap wn=400n wp=600n nn=2 np=2
XCO1 (coff AVDD VSS) adc_clkgen_gatecap wn=400n wp=600n nn=2 np=2
XCO2 (coff AVDD VSS) adc_clkgen_gatecap wn=400n wp=600n nn=2 np=2
XCE2 (ce AVDD VSS) adc_clkgen_gatecap wn=400n wp=600n nn=2 np=2
// @RNL {
//   &AVDD @ADD-TO $SUPPLY_NET_SET; &VSS @ADD-TO $GROUND_NET_SET;
//   $clk_route = @DEFINE-STYLE(linecolor="#2563a6", textcolor="#2563a6") {};
//   $feedback_route = @DEFINE-STYLE(linecolor="#a75b13", textcolor="#a75b13") {};
//   $gate_ink = @DEFINE-STYLE(linecolor="#243b53", textcolor="#243b53") {};
//   # @SELECT-INSTANCE => @SET-STYLE $gate_ink;
//   {#XS1 #XS2 #XS3 #XSB1 #XSB2} @GROUP; {#XB1 #XB2 #XB3 #XB4 #XBB1 #XBB2} @GROUP;
//   {#XSG #XOFF} @GROUP; {#XCG #XC1 #XC2} @GROUP; {#XS3 #XSB2} @AS $MATCHED;
//   {#XCS1 #XCS2 #XCS3 #XCS4} @GROUP; {#XCB1 #XCB2} @GROUP; {#XCE1 #XCE2 #XCC1 #XCC2} @GROUP; {#XCO1 #XCO2} @GROUP;
//   #XSG @PLACE(8,0) => @ORIENT("R0");
//   #XSG @TEXT("${name}", key="name", dx=0, dy=2.5, size=0.95, halign="middle");
//   #XSG @TEXT("${wn}/${wp}", key="sizes", dx=0, dy=-3.5, size=0.75, halign="middle");
//   #XS1 @PLACE(20,0) => @ORIENT("R0");
//   #XS1 @TEXT("${name}", key="name", dx=0, dy=2.5, size=0.95, halign="middle");
//   #XS1 @TEXT("${wn}/${wp}", key="sizes", dx=0, dy=-3.5, size=0.75, halign="middle");
//   #XS2 @PLACE(32,0) => @ORIENT("R0");
//   #XS2 @TEXT("${name}", key="name", dx=0, dy=2.5, size=0.95, halign="middle");
//   #XS2 @TEXT("${wn}/${wp}", key="sizes", dx=0, dy=-3.5, size=0.75, halign="middle");
//   #XS3 @PLACE(44,0) => @ORIENT("R0");
//   #XS3 @TEXT("${name}", key="name", dx=0, dy=2.5, size=0.95, halign="middle");
//   #XS3 @TEXT("${wn}/${wp}", key="sizes", dx=0, dy=-3.5, size=0.75, halign="middle");
//   #XSB1 @PLACE(20,-12) => @ORIENT("R0");
//   #XSB1 @TEXT("${name}", key="name", dx=0, dy=2.5, size=0.95, halign="middle");
//   #XSB1 @TEXT("${wn}/${wp}", key="sizes", dx=0, dy=-3.5, size=0.75, halign="middle");
//   #XSB2 @PLACE(44,-12) => @ORIENT("R0");
//   #XSB2 @TEXT("${name}", key="name", dx=0, dy=2.5, size=0.95, halign="middle");
//   #XSB2 @TEXT("${wn}/${wp}", key="sizes", dx=0, dy=-3.5, size=0.75, halign="middle");
//   #XB1 @PLACE(64,0) => @ORIENT("R0");
//   #XB1 @TEXT("${name}", key="name", dx=0, dy=2.5, size=0.95, halign="middle");
//   #XB1 @TEXT("${wn}/${wp}", key="sizes", dx=0, dy=-3.5, size=0.75, halign="middle");
//   #XB2 @PLACE(76,0) => @ORIENT("R0");
//   #XB2 @TEXT("${name}", key="name", dx=0, dy=2.5, size=0.95, halign="middle");
//   #XB2 @TEXT("${wn}/${wp}", key="sizes", dx=0, dy=-3.5, size=0.75, halign="middle");
//   #XB3 @PLACE(88,0) => @ORIENT("R0");
//   #XB3 @TEXT("${name}", key="name", dx=0, dy=2.5, size=0.95, halign="middle");
//   #XB3 @TEXT("${wn}/${wp}", key="sizes", dx=0, dy=-3.5, size=0.75, halign="middle");
//   #XB4 @PLACE(100,0) => @ORIENT("R0");
//   #XB4 @TEXT("${name}", key="name", dx=0, dy=2.5, size=0.95, halign="middle");
//   #XB4 @TEXT("${wn}/${wp}", key="sizes", dx=0, dy=-3.5, size=0.75, halign="middle");
//   #XBB1 @PLACE(100,-12) => @ORIENT("R0");
//   #XBB1 @TEXT("${name}", key="name", dx=0, dy=2.5, size=0.95, halign="middle");
//   #XBB1 @TEXT("${wn}/${wp}", key="sizes", dx=0, dy=-3.5, size=0.75, halign="middle");
//   #XBB2 @PLACE(116,-12) => @ORIENT("R0");
//   #XBB2 @TEXT("${name}", key="name", dx=0, dy=2.5, size=0.95, halign="middle");
//   #XBB2 @TEXT("${wn}/${wp}", key="sizes", dx=0, dy=-3.5, size=0.75, halign="middle");
//   #XCG @PLACE(120,0) => @ORIENT("R0");
//   #XCG @TEXT("${name}", key="name", dx=0, dy=2.5, size=0.95, halign="middle");
//   #XCG @TEXT("${wn}/${wp}", key="sizes", dx=0, dy=-3.5, size=0.75, halign="middle");
//   #XC1 @PLACE(132,0) => @ORIENT("R0");
//   #XC1 @TEXT("${name}", key="name", dx=0, dy=2.5, size=0.95, halign="middle");
//   #XC1 @TEXT("${wn}/${wp}", key="sizes", dx=0, dy=-3.5, size=0.75, halign="middle");
//   #XC2 @PLACE(144,0) => @ORIENT("R0");
//   #XC2 @TEXT("${name}", key="name", dx=0, dy=2.5, size=0.95, halign="middle");
//   #XC2 @TEXT("${wn}/${wp}", key="sizes", dx=0, dy=-3.5, size=0.75, halign="middle");
//   #XOFF @PLACE(2,30) => @ORIENT("MY");
//   #XOFF @TEXT("${name}", key="name", dx=0, dy=2.5, size=0.95, halign="middle");
//   #XOFF @TEXT("${wn}/${wp}", key="sizes", dx=0, dy=-3.5, size=0.75, halign="middle");
//   #XCO1 @PLACE(-12,18) => @ORIENT("R0");
//   #XCO2 @PLACE(-3,18) => @ORIENT("R0");
//   #XCS1 @PLACE(14,18) => @ORIENT("R0");
//   #XCS2 @PLACE(24,18) => @ORIENT("R0");
//   #XCS3 @PLACE(34,18) => @ORIENT("R0");
//   #XCS4 @PLACE(44,18) => @ORIENT("R0");
//   #XCB1 @PLACE(70,18) => @ORIENT("R0");
//   #XCB2 @PLACE(82,18) => @ORIENT("R0");
//   #XCE1 @PLACE(120,18) => @ORIENT("R0");
//   #XCE2 @PLACE(129,18) => @ORIENT("R0");
//   #XCC1 @PLACE(141,18) => @ORIENT("R0");
//   #XCC2 @PLACE(150,18) => @ORIENT("R0");
//   %clk=(-24,1); $JUNCTION @ATTACH %clk;
//   %coff=(-18,10); $JUNCTION @ATTACH %coff;
//   %sbar=(14,0); $JUNCTION @ATTACH %sbar;
//   %s1=(26,0); $JUNCTION @ATTACH %s1;
//   %s=(52,0); $JUNCTION @ATTACH %s;
//   %b1=(70,0); $JUNCTION @ATTACH %b1;
//   %b2=(82,0); $JUNCTION @ATTACH %b2;
//   %b3=(94,0); $JUNCTION @ATTACH %b3;
//   %b=(108,0); $JUNCTION @ATTACH %b;
//   %ce=(126,0); $JUNCTION @ATTACH %ce;
//   %cb=(138,0); $JUNCTION @ATTACH %cb;
//   %conv=(156,0); $JUNCTION @ATTACH %conv;
//   %pclk=$IO_PORT @ATTACH &CLK => @PLACE(-28,1) => @ORIENT("R0");
//   %ps=$IO_PORT @ATTACH &PHI_S => @PLACE(56,6) => @ORIENT("MY");
//   %psb=$IO_PORT @ATTACH &PHI_SB => @PLACE(56,-12) => @ORIENT("MY");
//   %pb=$IO_PORT @ATTACH &PHI_B => @PLACE(112,6) => @ORIENT("MY");
//   %pbb=$IO_PORT @ATTACH &PHI_BB => @PLACE(128,-12) => @ORIENT("MY");
//   %pc=$IO_PORT @ATTACH &CONV => @PLACE(164,0) => @ORIENT("MY");
//   &CLK @WIRE(mode="straight") {%pclk:p %clk #XSG:A} => @SET-STYLE $clk_route;
//   &CLK @WIRE(mode="straight") {%clk (-24,42) (114,42) (114,1) #XCG:A} => @SET-STYLE $clk_route;
//   &CONV @WIRE(mode="straight") {#XC2:Y %conv %pc:p} => @SET-STYLE $feedback_route;
//   &CONV @WIRE(mode="straight") {%conv (156,30) #XOFF:A} => @SET-STYLE $feedback_route;
//   &coff @WIRE(mode="straight") {#XOFF:Y (-18,30) %coff (-18,-1) #XSG:B} => @SET-STYLE $feedback_route;
//   &sbar @WIRE(mode="straight") {#XSG:Y %sbar #XS1:A};
//   &sbar @WIRE(mode="straight") {%sbar (14,-12) #XSB1:A};
//   &s1 @WIRE(mode="straight") {#XS1:Y %s1 #XS2:A};
//   &s2 @WIRE(mode="straight") {#XS2:Y #XS3:A};
//   &sb1 @WIRE(mode="straight") {#XSB1:Y #XSB2:A};
//   &PHI_S @WIRE(mode="straight") {#XS3:Y %s #XB1:A};
//   &PHI_S @WIRE(mode="straight") {%s (52,6) %ps:p};
//   &PHI_SB @WIRE(mode="straight") {#XSB2:Y %psb:p};
//   &b1 @WIRE(mode="straight") {#XB1:Y %b1 #XB2:A};
//   &b2 @WIRE(mode="straight") {#XB2:Y %b2 #XB3:A};
//   &b3 @WIRE(mode="straight") {#XB3:Y %b3 #XB4:A};
//   &b3 @WIRE(mode="straight") {%b3 (94,-12) #XBB1:A};
//   &bb1 @WIRE(mode="straight") {#XBB1:Y #XBB2:A};
//   &PHI_B @WIRE(mode="straight") {#XB4:Y %b (114,0) (114,-1) #XCG:B};
//   &PHI_B @WIRE(mode="straight") {%b (108,6) %pb:p};
//   &PHI_BB @WIRE(mode="straight") {#XBB2:Y %pbb:p};
//   &ce @WIRE(mode="straight") {#XCG:Y %ce #XC1:A};
//   &cb @WIRE(mode="straight") {#XC1:Y %cb #XC2:A};
//   %tap_XCO1=(-12,10); $JUNCTION @ATTACH %tap_XCO1;
//   %tap_XCO2=(-3,10); $JUNCTION @ATTACH %tap_XCO2;
//   &coff @WIRE(mode="straight") {%coff %tap_XCO1 %tap_XCO2} => @SET-STYLE $feedback_route;
//   &coff @WIRE(mode="straight") {%tap_XCO1 #XCO1:A};
//   &coff @WIRE(mode="straight") {%tap_XCO2 #XCO2:A};
//   %bank_s1=(26,8); $JUNCTION @ATTACH %bank_s1;
//   &s1 @WIRE(mode="straight") {%s1 %bank_s1};
//   %tap_XCS1=(14,8); $JUNCTION @ATTACH %tap_XCS1;
//   %tap_XCS2=(24,8); $JUNCTION @ATTACH %tap_XCS2;
//   %tap_XCS3=(34,8); $JUNCTION @ATTACH %tap_XCS3;
//   %tap_XCS4=(44,8); $JUNCTION @ATTACH %tap_XCS4;
//   &s1 @WIRE(mode="straight") {%tap_XCS1 %tap_XCS2 %bank_s1 %tap_XCS3 %tap_XCS4};
//   &s1 @WIRE(mode="straight") {%tap_XCS1 #XCS1:A};
//   &s1 @WIRE(mode="straight") {%tap_XCS2 #XCS2:A};
//   &s1 @WIRE(mode="straight") {%tap_XCS3 #XCS3:A};
//   &s1 @WIRE(mode="straight") {%tap_XCS4 #XCS4:A};
//   &b1 @WIRE(mode="straight") {%b1 #XCB1:A};
//   &b2 @WIRE(mode="straight") {%b2 #XCB2:A};
//   %bank_ce=(126,8); $JUNCTION @ATTACH %bank_ce;
//   &ce @WIRE(mode="straight") {%ce %bank_ce};
//   %tap_XCE1=(120,8); $JUNCTION @ATTACH %tap_XCE1;
//   %tap_XCE2=(129,8); $JUNCTION @ATTACH %tap_XCE2;
//   &ce @WIRE(mode="straight") {%tap_XCE1 %bank_ce %tap_XCE2};
//   &ce @WIRE(mode="straight") {%tap_XCE1 #XCE1:A};
//   &ce @WIRE(mode="straight") {%tap_XCE2 #XCE2:A};
//   %bank_cb=(138,10); $JUNCTION @ATTACH %bank_cb;
//   &cb @WIRE(mode="straight") {%cb %bank_cb};
//   %tap_XCC1=(141,10); $JUNCTION @ATTACH %tap_XCC1;
//   %tap_XCC2=(150,10); $JUNCTION @ATTACH %tap_XCC2;
//   &cb @WIRE(mode="straight") {%bank_cb %tap_XCC1 %tap_XCC2};
//   &cb @WIRE(mode="straight") {%tap_XCC1 #XCC1:A};
//   &cb @WIRE(mode="straight") {%tap_XCC2 #XCC2:A};
//   (-28,50) @TEXT("adc_clkgen | static CMOS phase generator", size=1.6, textcolor="#334155", bold=true, halign="start");
//   (-28,47) @TEXT("16 logic gates + 12 complementary MOS loads = 60 MOS", size=1.0, textcolor="#334155", bold=false, halign="start");
//   (16,43.5) @TEXT("CLK: immediate turn-off path", size=0.9, textcolor="#2563a6", bold=false, halign="start");
//   (27,31.5) @TEXT("Loaded CONV feedback: sampling waits for conversion turn-off", size=1.0, textcolor="#a75b13", bold=false, halign="start");
//   (-18,24.5) @TEXT("Sample interlock", size=0.95, textcolor="#334155", bold=true, halign="start");
//   (10,24.5) @TEXT("Sample drivers", size=0.95, textcolor="#334155", bold=true, halign="start");
//   (63,24.5) @TEXT("Four-stage S-to-B delay", size=0.95, textcolor="#334155", bold=true, halign="start");
//   (120,24.5) @TEXT("Conversion interlock", size=0.95, textcolor="#334155", bold=true, halign="start");
//   (-28,-20) @TEXT("Logic symbols: rnl-std-logic 0.3. All cells: VDD=AVDD, VSS=VSS; power pins omitted in this logic view.", size=0.9, textcolor="#334155", bold=false, halign="start");
//   (-28,-23) @TEXT("Labels below gates: total Wn/Wp; gate L=30n. 2 MOS boxes are gate-load subcircuits; see their transistor view.", size=0.9, textcolor="#334155", bold=false, halign="start");
//   (-28,-26) @TEXT("Gate loads: Wn/Wp=2u/3u, except XCS4, XCO1, XCO2, XCE2=400n/600n; L=90n. Dots mark joined wires.", size=0.9, textcolor="#334155", bold=false, halign="start");
// }
ends adc_clkgen
