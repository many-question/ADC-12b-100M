// tb_top_sine: full ADC, coherent differential sine from 50 ohm per side
// @RNL(type="header") {
//   @VERSION("0.3");
//   @USE-PACKAGE(name="adc28", version="0.1", path="../../design/rnl/adc28.rnl")
// }
// generated by `python -m adcflow gen` from specs/ -- do not edit (tools/adcflow/gen_tb.py)
// Globals vdd, vdd18, tempc, noise_en, devnoise, beh_speed, vref_in come from the run deck.
simulator lang=spectre
// fin here is only a placeholder: the test's prepare step (adcflow.measure.top:prepare) replaces it with the coherent frequency (odd bin) for npts; run the test through python -m adcflow sim
parameters fin=49.8962402e6 amp_dbfs=-1 npts=1024 ncal=1024 nskip=4 duty=0.5 fsamp=100e6 \
        fs_peak=0.9930 vcm_in=0.45 rsrc=50 cload=50f nfmax=20G
parameters amp=fs_peak*pow(10, amp_dbfs/20) tper=1/fsamp \
        tstart=(nskip-0.5)*tper tstop=(nskip+ncal+npts+0.6)*tper
XDUT (VINP VINN CLK VREF_IN D13 D12 D11 D10 D9 D8 D7 D6 D5 D4 D3 D2 D1 D0 RDY AVDD DVDD \
        AVDD18 0) adc_top
// differential sine, each side through rsrc (no input driver)
VSP (SRCP 0) vsource type=sine sinedc=vcm_in ampl=amp/2 freq=fin
VSN (SRCN 0) vsource type=sine sinedc=vcm_in ampl=-amp/2 freq=fin
// source resistor, noiseless with the behavioral CDAC (its kT/C source already counts it)
RSP (SRCP VINP) tb_rsrc_va r=rsrc noisy=1-cdac_behav
RSN (SRCN VINN) tb_rsrc_va r=rsrc noisy=1-cdac_behav
// sampling clock: high = track
VCLK (CLK 0) vsource type=pulse val0=0 val1=vdd period=tper width=duty*tper-20p rise=20p fall=20p
VREF (VREF_IN 0) vsource dc=vref_in
// one line per RDY rise; also loads every output with cload
ICAP (CLK RDY D13 D12 D11 D10 D9 D8 D7 D6 D5 D4 D3 D2 D1 D0 0) tb_capture_va vth=vdd/2 tstart=tstart cload=cload fname="capture.txt"
VAVDD (AVDD_S 0) vsource dc=vdd
IMAVDD (AVDD_S AVDD) tb_imeter_va tstart=tstart tstop=tstop label="AVDD" fname="power.txt"
VDVDD (DVDD_S 0) vsource dc=vdd
IMDVDD (DVDD_S DVDD) tb_imeter_va tstart=tstart tstop=tstop label="DVDD" fname="power.txt"
VAVDD18 (AVDD18_S 0) vsource dc=vdd18
IMAVDD18 (AVDD18_S AVDD18) tb_imeter_va tstart=tstart tstop=tstop label="AVDD18" fname="power.txt"
tran1 tran stop=tstop noisefmax=nfmax*noise_en noiseseed=1 outputstart=tstop errpreset=conservative
tbopts options save=none
// @RNL {
//   /* pins connected by net name: the net-name label of rnl-std-fill on every unwired pin, placed below by its key netname */
//   $LABEL_TERMINAL_SET @TEXT("${net}", key="netname", size=0.6);
//   /* --- semantics --- */
//   &0 @ADD-TO $GROUND_NET_SET;
//   #XDUT @PLACE(8, 0);
//   #VSP @PLACE(-16, 7);
//   #VSN @PLACE(-16, -2);
//   #RSP @PLACE(-16, -11);
//   #RSN @PLACE(-16, -20);
//   #VCLK @PLACE(-16, -29);
//   #VREF @PLACE(-16, -38);
//   #ICAP @PLACE(40, 5);
//   #VAVDD @PLACE(0, 19);
//   #IMAVDD @PLACE(12, 20);
//   #VDVDD @PLACE(24, 19);
//   #IMDVDD @PLACE(36, 20);
//   #VAVDD18 @PLACE(48, 19);
//   #IMAVDD18 @PLACE(60, 20);
//   #XDUT:VINP @TEXT("${net}", key="netname", size=0.6, halign="end", valign="middle", dx=-0.4, dy=0);
//   #XDUT:VINN @TEXT("${net}", key="netname", size=0.6, halign="end", valign="middle", dx=-0.4, dy=0);
//   #XDUT:CLK @TEXT("${net}", key="netname", size=0.6, halign="end", valign="middle", dx=-0.4, dy=0);
//   #XDUT:VREF_IN @TEXT("${net}", key="netname", size=0.6, halign="end", valign="middle", dx=-0.4, dy=0);
//   %bs1 = {&D13 &D12 &D11 &D10 &D9 &D8 &D7 &D6 &D5 &D4 &D3 &D2 &D1 &D0} @WIRE {#XDUT:D13 (20, 2)};
//   %bs1 @TEXT("D<13:0>", size=0.6, halign="start", valign="middle") => @PLACE(20.3, 2);
//   #XDUT:RDY @TEXT("${net}", key="netname", size=0.6, halign="start", valign="middle", dx=0.4, dy=0);
//   #XDUT:AVDD @TEXT("${net}", key="netname", size=0.6, halign="start", valign="middle", rotate=90, dx=0, dy=0.4);
//   #XDUT:DVDD @TEXT("${net}", key="netname", size=0.6, halign="start", valign="middle", rotate=90, dx=0, dy=0.4);
//   #XDUT:AVDD18 @TEXT("${net}", key="netname", size=0.6, halign="start", valign="middle", rotate=90, dx=0, dy=0.4);
//   %g1 = $GROUND @ATTACH &0 => @PLACE(10, -8.5);
//   &0 @WIRE {#XDUT:VSS %g1:p};
//   #VSP:1 @TEXT("${net}", key="netname", size=0.6, halign="start", valign="middle", rotate=90, dx=0, dy=0.4);
//   %g2 = $GROUND @ATTACH &0 => @PLACE(-16, 3.5);
//   &0 @WIRE {#VSP:2 %g2:p};
//   #VSN:1 @TEXT("${net}", key="netname", size=0.6, halign="start", valign="middle", rotate=90, dx=0, dy=0.4);
//   %g3 = $GROUND @ATTACH &0 => @PLACE(-16, -5.5);
//   &0 @WIRE {#VSN:2 %g3:p};
//   #RSP:P @TEXT("${net}", key="netname", size=0.6, halign="start", valign="middle", rotate=90, dx=0, dy=0.4);
//   #RSP:N @TEXT("${net}", key="netname", size=0.6, halign="end", valign="middle", rotate=90, dx=0, dy=-0.4);
//   #RSN:P @TEXT("${net}", key="netname", size=0.6, halign="start", valign="middle", rotate=90, dx=0, dy=0.4);
//   #RSN:N @TEXT("${net}", key="netname", size=0.6, halign="end", valign="middle", rotate=90, dx=0, dy=-0.4);
//   #VCLK:1 @TEXT("${net}", key="netname", size=0.6, halign="start", valign="middle", rotate=90, dx=0, dy=0.4);
//   %g4 = $GROUND @ATTACH &0 => @PLACE(-16, -32.5);
//   &0 @WIRE {#VCLK:2 %g4:p};
//   #VREF:1 @TEXT("${net}", key="netname", size=0.6, halign="start", valign="middle", rotate=90, dx=0, dy=0.4);
//   %g5 = $GROUND @ATTACH &0 => @PLACE(-16, -41.5);
//   &0 @WIRE {#VREF:2 %g5:p};
//   #ICAP:CLK @TEXT("${net}", key="netname", size=0.6, halign="end", valign="middle", dx=-0.4, dy=0);
//   #ICAP:RDY @TEXT("${net}", key="netname", size=0.6, halign="end", valign="middle", dx=-0.4, dy=0);
//   %bs2 = {&D13 &D12 &D11 &D10 &D9 &D8 &D7 &D6 &D5 &D4 &D3 &D2 &D1 &D0} @WIRE {#ICAP:D13 (32, 3)};
//   %bs2 @TEXT("D<13:0>", size=0.6, halign="end", valign="middle") => @PLACE(31.7, 3);
//   %g6 = $GROUND @ATTACH &0 => @PLACE(40, -1.5);
//   &0 @WIRE {#ICAP:VSS %g6:p};
//   #VAVDD:1 @TEXT("${net}", key="netname", size=0.6, halign="start", valign="middle", rotate=90, dx=0, dy=0.4);
//   %g7 = $GROUND @ATTACH &0 => @PLACE(0, 15.5);
//   &0 @WIRE {#VAVDD:2 %g7:p};
//   #IMAVDD:P @TEXT("${net}", key="netname", size=0.6, halign="start", valign="middle", rotate=90, dx=0, dy=0.4);
//   #IMAVDD:N @TEXT("${net}", key="netname", size=0.6, halign="end", valign="middle", rotate=90, dx=0, dy=-0.4);
//   #VDVDD:1 @TEXT("${net}", key="netname", size=0.6, halign="start", valign="middle", rotate=90, dx=0, dy=0.4);
//   %g8 = $GROUND @ATTACH &0 => @PLACE(24, 15.5);
//   &0 @WIRE {#VDVDD:2 %g8:p};
//   #IMDVDD:P @TEXT("${net}", key="netname", size=0.6, halign="start", valign="middle", rotate=90, dx=0, dy=0.4);
//   #IMDVDD:N @TEXT("${net}", key="netname", size=0.6, halign="end", valign="middle", rotate=90, dx=0, dy=-0.4);
//   #VAVDD18:1 @TEXT("${net}", key="netname", size=0.6, halign="start", valign="middle", rotate=90, dx=0, dy=0.4);
//   %g9 = $GROUND @ATTACH &0 => @PLACE(48, 15.5);
//   &0 @WIRE {#VAVDD18:2 %g9:p};
//   #IMAVDD18:P @TEXT("${net}", key="netname", size=0.6, halign="start", valign="middle", rotate=90, dx=0, dy=0.4);
//   #IMAVDD18:N @TEXT("${net}", key="netname", size=0.6, halign="end", valign="middle", rotate=90, dx=0, dy=-0.4);
//   (-30, 33) @TEXT("tb_top_sine: full ADC, coherent differential sine from 50 ohm per side", halign="start") => @SET-STYLE $title_style;
//   (-30, 31.4) @TEXT("capture.txt: D13..D0 and CLK-fall -> RDY time per conversion; power.txt: average supply currents", halign="start") => @SET-STYLE $note_style;
//   (-30, 29.8) @TEXT("the first ncal conversions calibrate the weights, the next npts are judged (adcflow.calib)", halign="start") => @SET-STYLE $note_style
// }
