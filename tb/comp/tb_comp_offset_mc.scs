// tb_comp_offset_mc: input offset under device mismatch (Monte Carlo)
// @RNL(type="header") {
//   @VERSION("0.3");
//   @USE-PACKAGE(name="adc28", version="0.1", path="../../design/rnl/adc28.rnl")
// }
// generated by `python -m adcflow gen` from specs/ -- do not edit (tools/adcflow/gen_tb.py)
// Globals vdd, vdd18, tempc, noise_en, devnoise, beh_speed, vref_in come from the run deck.
simulator lang=spectre
parameters vcm=0.49 cload=10f tcyc=1e-09 vrange=0.025 nbits=13 vchk=5e-05 vos_beh=0.002 mc_runs=50 mc_seed=6303
parameters tstop=100p+(nbits+4)*tcyc mm_beh=0
XDUT (INP INN CLKC OUTP OUTN AVDD 0) adc_comp
// successive-approximation search of the offset, one decision per CLKC cycle; appends every sample to offset.txt
ISRCH (INPS INN CLKC OUTP OUTN 0) tb_offset_search_va vcm=vcm vth=vdd/2 vrange=vrange nbits=nbits vchk=vchk fname="offset.txt"
// series offset source: comp_behav*vos_beh*N(0, 1) per sample (only while adc_comp is behavioral)
XVOS (INP INPS) tb_mm_vos
VCK (CLKC 0) vsource type=pulse val0=0 val1=vdd period=tcyc delay=100p width=tcyc/2-10p rise=10p fall=10p
COP (OUTP 0) capacitor c=cload
CON (OUTN 0) capacitor c=cload
VAVDD (AVDD 0) vsource dc=vdd
// The behavioral comparator has no device statistics. While adc_comp is behavioral (deck global
// comp_behav = 1) this source in series with INP stands in for them: mm_beh is drawn for every
// subcircuit instance in every Monte Carlo sample (mismatch statistics below), so the offset found
// in each sample is -vos_beh*N(0, 1). With a transistor-level comparator it is 0 V.
subckt tb_mm_vos (P N)
V0 (P N) vsource dc=comp_behav*vos_beh*mm_beh
// @RNL {
//   #V0 @PLACE(0, 0);
//   %p = $IO_PORT @ATTACH &P => @PLACE(0, 5) => @ORIENT("R270");
//   &P @WIRE {#V0:1 %p:p};
//   %n = $IO_PORT @ATTACH &N => @PLACE(0, -5) => @ORIENT("R90");
//   &N @WIRE {#V0:2 %n:p}
// }
ends tb_mm_vos
// (continuation lines: the drawing tools read the statistics block as one statement)
statistics { \
  mismatch { \
    vary mm_beh dist=gauss std=1
  }
}
mc1 montecarlo numruns=mc_runs seed=mc_seed firstrun=1 donominal=no variations=mismatch annotate=status {
tran1 tran stop=tstop errpreset=conservative
}
tbopts options save=none
// @RNL {
//   /* pins connected by net name: the net-name label of rnl-std-fill on every unwired pin, placed below by its key netname */
//   $LABEL_TERMINAL_SET @TEXT("${net}", key="netname", size=0.6);
//   /* --- semantics --- */
//   &0 @ADD-TO $GROUND_NET_SET;
//   #XDUT @PLACE(6, 0);
//   #ISRCH @PLACE(-16, 5);
//   #XVOS @PLACE(-16, -4);
//   #VCK @PLACE(-16, -13);
//   #XVOS @SET-SYMBOL $VOLTAGE_SOURCE;
//   #COP @PLACE(0, -15);
//   #CON @PLACE(8, -15);
//   #VAVDD @PLACE(0, 17);
//   #XDUT:INP @TEXT("${net}", key="netname", size=0.6, halign="end", valign="middle", dx=-0.4, dy=0);
//   #XDUT:INN @TEXT("${net}", key="netname", size=0.6, halign="end", valign="middle", dx=-0.4, dy=0);
//   #XDUT:CLKC @TEXT("${net}", key="netname", size=0.6, halign="end", valign="middle", rotate=90, dx=0, dy=-0.4);
//   #XDUT:OUTP @TEXT("${net}", key="netname", size=0.6, halign="start", valign="middle", dx=0.4, dy=0);
//   #XDUT:OUTN @TEXT("${net}", key="netname", size=0.6, halign="start", valign="middle", dx=0.4, dy=0);
//   #XDUT:AVDD @TEXT("${net}", key="netname", size=0.6, halign="start", valign="middle", rotate=90, dx=0, dy=0.4);
//   %g1 = $GROUND @ATTACH &0 => @PLACE(4, -6.5);
//   &0 @WIRE {#XDUT:VSS %g1:p};
//   #ISRCH:P @TEXT("${net}", key="netname", size=0.6, halign="start", valign="middle", dx=0.4, dy=0);
//   #ISRCH:N @TEXT("${net}", key="netname", size=0.6, halign="start", valign="middle", dx=0.4, dy=0);
//   #ISRCH:CLKC @TEXT("${net}", key="netname", size=0.6, halign="end", valign="middle", dx=-0.4, dy=0);
//   #ISRCH:OUTP @TEXT("${net}", key="netname", size=0.6, halign="end", valign="middle", dx=-0.4, dy=0);
//   #ISRCH:OUTN @TEXT("${net}", key="netname", size=0.6, halign="end", valign="middle", dx=-0.4, dy=0);
//   %g2 = $GROUND @ATTACH &0 => @PLACE(-16, -1.5);
//   &0 @WIRE {#ISRCH:VSS %g2:p};
//   #XVOS:1 @TEXT("${net}", key="netname", size=0.6, halign="start", valign="middle", rotate=90, dx=0, dy=0.4);
//   #XVOS:2 @TEXT("${net}", key="netname", size=0.6, halign="end", valign="middle", rotate=90, dx=0, dy=-0.4);
//   #VCK:1 @TEXT("${net}", key="netname", size=0.6, halign="start", valign="middle", rotate=90, dx=0, dy=0.4);
//   %g3 = $GROUND @ATTACH &0 => @PLACE(-16, -16.5);
//   &0 @WIRE {#VCK:2 %g3:p};
//   #COP:1 @TEXT("${net}", key="netname", size=0.6, halign="start", valign="middle", rotate=90, dx=0, dy=0.4);
//   %g4 = $GROUND @ATTACH &0 => @PLACE(0, -18.5);
//   &0 @WIRE {#COP:2 %g4:p};
//   #CON:1 @TEXT("${net}", key="netname", size=0.6, halign="start", valign="middle", rotate=90, dx=0, dy=0.4);
//   %g5 = $GROUND @ATTACH &0 => @PLACE(8, -18.5);
//   &0 @WIRE {#CON:2 %g5:p};
//   #VAVDD:1 @TEXT("${net}", key="netname", size=0.6, halign="start", valign="middle", rotate=90, dx=0, dy=0.4);
//   %g6 = $GROUND @ATTACH &0 => @PLACE(0, 13.5);
//   &0 @WIRE {#VAVDD:2 %g6:p};
//   (-30, 31) @TEXT("tb_comp_offset_mc: input offset under device mismatch (Monte Carlo)", halign="start") => @SET-STYLE $title_style;
//   (-30, 29.4) @TEXT("one montecarlo analysis: mc_runs samples (50, seed 6303, mismatch only, no nominal run), transient noise off", halign="start") => @SET-STYLE $note_style;
//   (-30, 27.8) @TEXT("each sample: vd = +/-25 mV must give OUTP / OUTN, 13 halvings (6.1 uV), then offset +/- 50 uV re-checked", halign="start") => @SET-STYLE $note_style;
//   (-30, 26.2) @TEXT("XVOS: stand-in offset of the behavioral comparator (0 V with a transistor-level view)", halign="start") => @SET-STYLE $note_style
// }
