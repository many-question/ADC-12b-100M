// tb_comp_soa: per-device SOA at the largest input and the short reset
// @RNL(type="header") {
//   @VERSION("0.3");
//   @USE-PACKAGE(name="adc28", version="0.1", path="../../design/rnl/adc28.rnl")
// }
// generated by `python -m adcflow gen` from specs/ -- do not edit (tools/adcflow/gen_tb.py)
// Globals vdd, vdd18, tempc, noise_en, devnoise, beh_speed, vref_in come from the run deck.
simulator lang=spectre
parameters cload=10f
parameters tstop=1.204e-08
XDUT (INP INN CLKC OUTP OUTN AVDD 0) adc_comp
VDP (INP 0) vsource type=pwl wave=[0.0000e+00 0.9 4.8000e-10 0.9 4.9000e-10 0.08 8.8000e-10 0.08 8.9000e-10 0.54 1.2800e-09 0.54 1.2900e-09 0.44 1.6800e-09 0.44 1.6900e-09 0.4905 2.0800e-09 0.4905 2.0900e-09 0.4895 2.4800e-09 0.4895 2.4900e-09 0.490005 2.8800e-09 0.490005 2.8900e-09 0.489995 3.2800e-09 0.489995 3.2900e-09 0.9 3.6800e-09 0.9 3.6900e-09 0.08 4.0800e-09 0.08 4.0900e-09 0.54 4.4800e-09 0.54 4.4900e-09 0.44 4.8800e-09 0.44 4.8900e-09 0.4905 5.2800e-09 0.4905 5.2900e-09 0.4895 5.6800e-09 0.4895 5.6900e-09 0.490005 6.0800e-09 0.490005 6.0900e-09 0.489995 6.4800e-09 0.489995 6.4900e-09 0.9 6.8800e-09 0.9 6.8900e-09 0.08 7.2800e-09 0.08 7.2900e-09 0.54 7.6800e-09 0.54 7.6900e-09 0.44 8.0800e-09 0.44 8.0900e-09 0.4905 8.4800e-09 0.4905 8.4900e-09 0.4895 8.8800e-09 0.4895 8.8900e-09 0.490005 9.2800e-09 0.490005 9.2900e-09 0.489995 9.6800e-09 0.489995 9.6900e-09 0.9 9.8200e-09 0.9 9.8300e-09 0.08 9.9600e-09 0.08 9.9700e-09 0.54 1.0100e-08 0.54 1.0110e-08 0.44 1.0240e-08 0.44 1.0250e-08 0.4905 1.0380e-08 0.4905 1.0390e-08 0.4895 1.0520e-08 0.4895 1.0530e-08 0.490005 1.0660e-08 0.490005 1.0670e-08 0.489995 1.0800e-08 0.489995 1.0810e-08 0.9 1.0940e-08 0.9 1.0950e-08 0.08 1.1080e-08 0.08 1.1090e-08 0.54 1.1220e-08 0.54 1.1230e-08 0.44 1.1360e-08 0.44 1.1370e-08 0.4905 1.1500e-08 0.4905 1.1510e-08 0.4895 1.1640e-08 0.4895 1.1650e-08 0.490005 1.1780e-08 0.490005 1.1790e-08 0.489995]
VDN (INN 0) vsource type=pwl wave=[0.0000e+00 0.08 4.8000e-10 0.08 4.9000e-10 0.9 8.8000e-10 0.9 8.9000e-10 0.44 1.2800e-09 0.44 1.2900e-09 0.54 1.6800e-09 0.54 1.6900e-09 0.4895 2.0800e-09 0.4895 2.0900e-09 0.4905 2.4800e-09 0.4905 2.4900e-09 0.489995 2.8800e-09 0.489995 2.8900e-09 0.490005 3.2800e-09 0.490005 3.2900e-09 0.08 3.6800e-09 0.08 3.6900e-09 0.9 4.0800e-09 0.9 4.0900e-09 0.44 4.4800e-09 0.44 4.4900e-09 0.54 4.8800e-09 0.54 4.8900e-09 0.4895 5.2800e-09 0.4895 5.2900e-09 0.4905 5.6800e-09 0.4905 5.6900e-09 0.489995 6.0800e-09 0.489995 6.0900e-09 0.490005 6.4800e-09 0.490005 6.4900e-09 0.08 6.8800e-09 0.08 6.8900e-09 0.9 7.2800e-09 0.9 7.2900e-09 0.44 7.6800e-09 0.44 7.6900e-09 0.54 8.0800e-09 0.54 8.0900e-09 0.4895 8.4800e-09 0.4895 8.4900e-09 0.4905 8.8800e-09 0.4905 8.8900e-09 0.489995 9.2800e-09 0.489995 9.2900e-09 0.490005 9.6800e-09 0.490005 9.6900e-09 0.08 9.8200e-09 0.08 9.8300e-09 0.9 9.9600e-09 0.9 9.9700e-09 0.44 1.0100e-08 0.44 1.0110e-08 0.54 1.0240e-08 0.54 1.0250e-08 0.4895 1.0380e-08 0.4895 1.0390e-08 0.4905 1.0520e-08 0.4905 1.0530e-08 0.489995 1.0660e-08 0.489995 1.0670e-08 0.490005 1.0800e-08 0.490005 1.0810e-08 0.08 1.0940e-08 0.08 1.0950e-08 0.9 1.1080e-08 0.9 1.1090e-08 0.44 1.1220e-08 0.44 1.1230e-08 0.54 1.1360e-08 0.54 1.1370e-08 0.4895 1.1500e-08 0.4895 1.1510e-08 0.4905 1.1640e-08 0.4905 1.1650e-08 0.489995 1.1780e-08 0.489995 1.1790e-08 0.490005]
VCK (CLKC 0) vsource type=pwl wave=[0.0000e+00 0 1.0000e-10 0 1.1000e-10 vdd 3.0000e-10 vdd 3.1000e-10 0 5.0000e-10 0 5.1000e-10 vdd 7.0000e-10 vdd 7.1000e-10 0 9.0000e-10 0 9.1000e-10 vdd 1.1000e-09 vdd 1.1100e-09 0 1.3000e-09 0 1.3100e-09 vdd 1.5000e-09 vdd 1.5100e-09 0 1.7000e-09 0 1.7100e-09 vdd 1.9000e-09 vdd 1.9100e-09 0 2.1000e-09 0 2.1100e-09 vdd 2.3000e-09 vdd 2.3100e-09 0 2.5000e-09 0 2.5100e-09 vdd 2.7000e-09 vdd 2.7100e-09 0 2.9000e-09 0 2.9100e-09 vdd 3.1000e-09 vdd 3.1100e-09 0 3.3000e-09 0 3.3100e-09 vdd 3.5000e-09 vdd 3.5100e-09 0 3.7000e-09 0 3.7100e-09 vdd 3.9000e-09 vdd 3.9100e-09 0 4.1000e-09 0 4.1100e-09 vdd 4.3000e-09 vdd 4.3100e-09 0 4.5000e-09 0 4.5100e-09 vdd 4.7000e-09 vdd 4.7100e-09 0 4.9000e-09 0 4.9100e-09 vdd 5.1000e-09 vdd 5.1100e-09 0 5.3000e-09 0 5.3100e-09 vdd 5.5000e-09 vdd 5.5100e-09 0 5.7000e-09 0 5.7100e-09 vdd 5.9000e-09 vdd 5.9100e-09 0 6.1000e-09 0 6.1100e-09 vdd 6.3000e-09 vdd 6.3100e-09 0 6.5000e-09 0 6.5100e-09 vdd 6.7000e-09 vdd 6.7100e-09 0 6.9000e-09 0 6.9100e-09 vdd 7.1000e-09 vdd 7.1100e-09 0 7.3000e-09 0 7.3100e-09 vdd 7.5000e-09 vdd 7.5100e-09 0 7.7000e-09 0 7.7100e-09 vdd 7.9000e-09 vdd 7.9100e-09 0 8.1000e-09 0 8.1100e-09 vdd 8.3000e-09 vdd 8.3100e-09 0 8.5000e-09 0 8.5100e-09 vdd 8.7000e-09 vdd 8.7100e-09 0 8.9000e-09 0 8.9100e-09 vdd 9.1000e-09 vdd 9.1100e-09 0 9.3000e-09 0 9.3100e-09 vdd 9.5000e-09 vdd 9.5100e-09 0 9.7000e-09 0 9.7100e-09 vdd 9.8100e-09 vdd 9.8200e-09 0 9.8400e-09 0 9.8500e-09 vdd 9.9500e-09 vdd 9.9600e-09 0 9.9800e-09 0 9.9900e-09 vdd 1.0090e-08 vdd 1.0100e-08 0 1.0120e-08 0 1.0130e-08 vdd 1.0230e-08 vdd 1.0240e-08 0 1.0260e-08 0 1.0270e-08 vdd 1.0370e-08 vdd 1.0380e-08 0 1.0400e-08 0 1.0410e-08 vdd 1.0510e-08 vdd 1.0520e-08 0 1.0540e-08 0 1.0550e-08 vdd 1.0650e-08 vdd 1.0660e-08 0 1.0680e-08 0 1.0690e-08 vdd 1.0790e-08 vdd 1.0800e-08 0 1.0820e-08 0 1.0830e-08 vdd 1.0930e-08 vdd 1.0940e-08 0 1.0960e-08 0 1.0970e-08 vdd 1.1070e-08 vdd 1.1080e-08 0 1.1100e-08 0 1.1110e-08 vdd 1.1210e-08 vdd 1.1220e-08 0 1.1240e-08 0 1.1250e-08 vdd 1.1350e-08 vdd 1.1360e-08 0 1.1380e-08 0 1.1390e-08 vdd 1.1490e-08 vdd 1.1500e-08 0 1.1520e-08 0 1.1530e-08 vdd 1.1630e-08 vdd 1.1640e-08 0 1.1660e-08 0 1.1670e-08 vdd 1.1770e-08 vdd 1.1780e-08 0 1.1800e-08 0 1.1810e-08 vdd 1.1910e-08 vdd 1.1920e-08 0]
COP (OUTP 0) capacitor c=cload
CON (OUTN 0) capacitor c=cload
VAVDD (AVDD 0) vsource dc=vdd
tran1 tran stop=tstop errpreset=conservative
save INP INN CLKC OUTP OUTN
waveopts options save=selected
// @RNL {
//   /* pins connected by net name: the net-name label of rnl-std-fill on every unwired pin, placed below by its key netname */
//   $LABEL_TERMINAL_SET @TEXT("${net}", key="netname", size=0.6);
//   /* --- semantics --- */
//   &0 @ADD-TO $GROUND_NET_SET;
//   #XDUT @PLACE(6, 0);
//   #VDP @PLACE(-16, 5);
//   #VDN @PLACE(-16, -4);
//   #VCK @PLACE(-16, -13);
//   #COP @PLACE(0, -15);
//   #CON @PLACE(8, -15);
//   #VAVDD @PLACE(0, 17);
//   #XDUT:INP @TEXT("${net}", key="netname", size=0.6, halign="end", valign="middle", dx=-0.4, dy=0);
//   #XDUT:INN @TEXT("${net}", key="netname", size=0.6, halign="end", valign="middle", dx=-0.4, dy=0);
//   #XDUT:CLKC @TEXT("${net}", key="netname", size=0.6, halign="end", valign="middle", rotate=90, dx=0, dy=-0.4);
//   #XDUT:OUTP @TEXT("${net}", key="netname", size=0.6, halign="start", valign="middle", dx=0.4, dy=0);
//   #XDUT:OUTN @TEXT("${net}", key="netname", size=0.6, halign="start", valign="middle", dx=0.4, dy=0);
//   #XDUT:AVDD @TEXT("${net}", key="netname", size=0.6, halign="start", valign="middle", rotate=90, dx=0, dy=0.4);
//   %g1 = $GROUND @ATTACH &0 => @PLACE(4, -6.5);
//   &0 @WIRE {#XDUT:VSS %g1:p};
//   #VDP:1 @TEXT("${net}", key="netname", size=0.6, halign="start", valign="middle", rotate=90, dx=0, dy=0.4);
//   %g2 = $GROUND @ATTACH &0 => @PLACE(-16, 1.5);
//   &0 @WIRE {#VDP:2 %g2:p};
//   #VDN:1 @TEXT("${net}", key="netname", size=0.6, halign="start", valign="middle", rotate=90, dx=0, dy=0.4);
//   %g3 = $GROUND @ATTACH &0 => @PLACE(-16, -7.5);
//   &0 @WIRE {#VDN:2 %g3:p};
//   #VCK:1 @TEXT("${net}", key="netname", size=0.6, halign="start", valign="middle", rotate=90, dx=0, dy=0.4);
//   %g4 = $GROUND @ATTACH &0 => @PLACE(-16, -16.5);
//   &0 @WIRE {#VCK:2 %g4:p};
//   #COP:1 @TEXT("${net}", key="netname", size=0.6, halign="start", valign="middle", rotate=90, dx=0, dy=0.4);
//   %g5 = $GROUND @ATTACH &0 => @PLACE(0, -18.5);
//   &0 @WIRE {#COP:2 %g5:p};
//   #CON:1 @TEXT("${net}", key="netname", size=0.6, halign="start", valign="middle", rotate=90, dx=0, dy=0.4);
//   %g6 = $GROUND @ATTACH &0 => @PLACE(8, -18.5);
//   &0 @WIRE {#CON:2 %g6:p};
//   #VAVDD:1 @TEXT("${net}", key="netname", size=0.6, halign="start", valign="middle", rotate=90, dx=0, dy=0.4);
//   %g7 = $GROUND @ATTACH &0 => @PLACE(0, 13.5);
//   &0 @WIRE {#VAVDD:2 %g7:p};
//   (-30, 31) @TEXT("tb_comp_soa: per-device SOA at the largest input and the short reset", halign="start") => @SET-STYLE $title_style;
//   (-30, 29.4) @TEXT("vd cycles through +/-0.82, 0.1, 0.001, 1e-05 V, CM 0.49 V: 24 decisions per 400 ps as tb_comp_delay, then 16 with CLKC low for 40 ps", halign="start") => @SET-STYLE $note_style
// }
