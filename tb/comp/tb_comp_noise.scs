// tb_comp_noise: input-referred noise and offset from P(OUTP) vs vd
// @RNL(type="header") {
//   @VERSION("0.4");
//   @USE-PACKAGE(name="adc28", version="0.2", path="../../design/rnl/0.4/adc28.rnl")
// }
// generated by `python -m adcflow gen` from specs/ -- do not edit (tools/adcflow/gen_tb.py)
// Globals vdd, vdd18, tempc, noise_en, devnoise, beh_speed, vref_in come from the run deck.
simulator lang=spectre
parameters cload=10f nfmax=50G
parameters tstop=3.4817e-06
XDUT (INP INN CLKC OUTP OUTN AVDD 0) adc_comp
VDP (INP 0) vsource type=pwl wave=[0.0000e+00 0.4896 2.0479e-07 0.4896 2.0480e-07 0.48965 4.0959e-07 0.48965 4.0960e-07 0.4897 6.1439e-07 0.4897 6.1440e-07 0.48975 8.1919e-07 0.48975 8.1920e-07 0.4898 1.02399000e-06 0.4898 1.0240e-06 0.48985 1.22879000e-06 0.48985 1.2288e-06 0.4899 1.43359000e-06 0.4899 1.4336e-06 0.48995 1.63839000e-06 0.48995 1.6384e-06 0.49 1.84319000e-06 0.49 1.8432e-06 0.49005 2.04799000e-06 0.49005 2.0480e-06 0.4901 2.25279000e-06 0.4901 2.2528e-06 0.49015 2.45759000e-06 0.49015 2.4576e-06 0.4902 2.66239000e-06 0.4902 2.6624e-06 0.49025 2.86719000e-06 0.49025 2.8672e-06 0.4903 3.07199000e-06 0.4903 3.0720e-06 0.49035 3.27679000e-06 0.49035 3.2768e-06 0.4904]
VDN (INN 0) vsource type=pwl wave=[0.0000e+00 0.4904 2.0479e-07 0.4904 2.0480e-07 0.49035 4.0959e-07 0.49035 4.0960e-07 0.4903 6.1439e-07 0.4903 6.1440e-07 0.49025 8.1919e-07 0.49025 8.1920e-07 0.4902 1.02399000e-06 0.4902 1.0240e-06 0.49015 1.22879000e-06 0.49015 1.2288e-06 0.4901 1.43359000e-06 0.4901 1.4336e-06 0.49005 1.63839000e-06 0.49005 1.6384e-06 0.49 1.84319000e-06 0.49 1.8432e-06 0.48995 2.04799000e-06 0.48995 2.0480e-06 0.4899 2.25279000e-06 0.4899 2.2528e-06 0.48985 2.45759000e-06 0.48985 2.4576e-06 0.4898 2.66239000e-06 0.4898 2.6624e-06 0.48975 2.86719000e-06 0.48975 2.8672e-06 0.4897 3.07199000e-06 0.4897 3.0720e-06 0.48965 3.27679000e-06 0.48965 3.2768e-06 0.4896]
VCK (CLKC 0) vsource type=pulse val0=0 val1=vdd period=4e-10 delay=100p width=1.9e-10 rise=10p fall=10p
COP (OUTP 0) capacitor c=cload
CON (OUTN 0) capacitor c=cload
// decision of every cycle, sampled when CLKC falls
ISMP (OUTP OUTN CLKC 0) tb_sampler_va vth=vdd/2 dir=-1 delay=0 fname="decisions.txt"
VAVDD (AVDD 0) vsource dc=vdd
tran1 tran stop=tstop noisefmax=nfmax*noise_en*devnoise noiseseed=1 outputstart=tstop errpreset=conservative
tbopts options save=none
// @RNL {
//   /* every pin is wired here or labelled with its net: no net-label stubs from the fill */
//   # @SELECT-PIN => @REMOVE-FROM $LABEL_FILL_SET;
//   /* --- semantics --- */
//   &0 @ADD-TO $GROUND_NET_SET;
//   #XDUT @PLACE(6, 0);
//   #VDP @PLACE(-16, 5);
//   #VDN @PLACE(-16, -4);
//   #VCK @PLACE(-16, -13);
//   #ISMP @PLACE(33, 4);
//   #COP @PLACE(0, -15);
//   #CON @PLACE(8, -15);
//   #VAVDD @PLACE(0, 17);
//   #XDUT:INP @TEXT("${net}", key="netname", size=0.6, halign="end", valign="middle", dx=-0.4, dy=0);
//   #XDUT:INN @TEXT("${net}", key="netname", size=0.6, halign="end", valign="middle", dx=-0.4, dy=0);
//   #XDUT:CLKC @TEXT("${net}", key="netname", size=0.6, halign="end", valign="middle", rotate=90, dx=0, dy=-0.4);
//   #XDUT:OUTP @TEXT("${net}", key="netname", size=0.6, halign="start", valign="middle", dx=0.4, dy=0);
//   #XDUT:OUTN @TEXT("${net}", key="netname", size=0.6, halign="start", valign="middle", dx=0.4, dy=0);
//   #XDUT:AVDD @TEXT("${net}", key="netname", size=0.6, halign="start", valign="middle", rotate=90, dx=0, dy=0.4);
//   %g1 = $GROUND @ATTACH &0 => @PLACE(4, -6.5);
//   &0 @WIRE {#XDUT:VSS %g1::pin};
//   #VDP:1 @TEXT("${net}", key="netname", size=0.6, halign="start", valign="middle", rotate=90, dx=0, dy=0.4);
//   %g2 = $GROUND @ATTACH &0 => @PLACE(-16, 1.5);
//   &0 @WIRE {#VDP:2 %g2::pin};
//   #VDN:1 @TEXT("${net}", key="netname", size=0.6, halign="start", valign="middle", rotate=90, dx=0, dy=0.4);
//   %g3 = $GROUND @ATTACH &0 => @PLACE(-16, -7.5);
//   &0 @WIRE {#VDN:2 %g3::pin};
//   #VCK:1 @TEXT("${net}", key="netname", size=0.6, halign="start", valign="middle", rotate=90, dx=0, dy=0.4);
//   %g4 = $GROUND @ATTACH &0 => @PLACE(-16, -16.5);
//   &0 @WIRE {#VCK:2 %g4::pin};
//   #COP:1 @TEXT("${net}", key="netname", size=0.6, halign="start", valign="middle", rotate=90, dx=0, dy=0.4);
//   %g5 = $GROUND @ATTACH &0 => @PLACE(0, -18.5);
//   &0 @WIRE {#COP:2 %g5::pin};
//   #CON:1 @TEXT("${net}", key="netname", size=0.6, halign="start", valign="middle", rotate=90, dx=0, dy=0.4);
//   %g6 = $GROUND @ATTACH &0 => @PLACE(8, -18.5);
//   &0 @WIRE {#CON:2 %g6::pin};
//   #ISMP:P @TEXT("${net}", key="netname", size=0.6, halign="end", valign="middle", dx=-0.4, dy=0);
//   #ISMP:N @TEXT("${net}", key="netname", size=0.6, halign="end", valign="middle", dx=-0.4, dy=0);
//   #ISMP:TRIG @TEXT("${net}", key="netname", size=0.6, halign="end", valign="middle", rotate=90, dx=0, dy=-0.4);
//   %g7 = $GROUND @ATTACH &0 => @PLACE(35, -1.5);
//   &0 @WIRE {#ISMP:VSS %g7::pin};
//   #VAVDD:1 @TEXT("${net}", key="netname", size=0.6, halign="start", valign="middle", rotate=90, dx=0, dy=0.4);
//   %g8 = $GROUND @ATTACH &0 => @PLACE(0, 13.5);
//   &0 @WIRE {#VAVDD:2 %g8::pin};
//   (-30, 31) @TEXT("tb_comp_noise: input-referred noise and offset from P(OUTP) vs vd", halign="start") => @SET-STYLE $title_style;
//   (-30, 29.4) @TEXT("17 levels of vd from -800 to 800 uV, 512 decisions each", halign="start") => @SET-STYLE $note_style;
//   (-30, 27.8) @TEXT("Gaussian CDF fit gives sigma (noise) and mean (offset)", halign="start") => @SET-STYLE $note_style
// }
