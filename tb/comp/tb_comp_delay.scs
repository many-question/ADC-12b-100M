// tb_comp_delay: comparator delay, regeneration, reset and energy
// @RNL(type="header") {
//   @VERSION("0.3");
//   @USE-PACKAGE(name="adc28", version="0.1", path="../../design/rnl/adc28.rnl")
// }
// generated by `python -m adcflow gen` from specs/ -- do not edit (tools/adcflow/gen_tb.py)
// Globals vdd, vdd18, tempc, noise_en, devnoise, beh_speed, vref_in come from the run deck.
simulator lang=spectre
parameters cload=10f
parameters tstart=1e-10 tstop=1.45e-08
XDUT (INP INN CLKC OUTP OUTN AVDD 0) adc_comp
VDP (INP 0) vsource type=pwl wave=[0.0000e+00 0.54 3.9000e-10 0.54 4.0000e-10 0.44 7.9000e-10 0.44 8.0000e-10 0.505 1.1900e-09 0.505 1.2000e-09 0.475 1.5900e-09 0.475 1.6000e-09 0.495 1.9900e-09 0.495 2.0000e-09 0.485 2.3900e-09 0.485 2.4000e-09 0.4915 2.7900e-09 0.4915 2.8000e-09 0.4885 3.1900e-09 0.4885 3.2000e-09 0.4905 3.5900e-09 0.4905 3.6000e-09 0.4895 3.9900e-09 0.4895 4.0000e-09 0.49015 4.3900e-09 0.49015 4.4000e-09 0.48985 4.7900e-09 0.48985 4.8000e-09 0.49005 5.1900e-09 0.49005 5.2000e-09 0.48995 5.5900e-09 0.48995 5.6000e-09 0.490015 5.9900e-09 0.490015 6.0000e-09 0.489985 6.3900e-09 0.489985 6.4000e-09 0.490005 6.7900e-09 0.490005 6.8000e-09 0.489995 7.1900e-09 0.489995 7.2000e-09 0.54 7.5900e-09 0.54 7.6000e-09 0.44 7.9900e-09 0.44 8.0000e-09 0.505 8.3900e-09 0.505 8.4000e-09 0.475 8.7900e-09 0.475 8.8000e-09 0.495 9.1900e-09 0.495 9.2000e-09 0.485 9.5900e-09 0.485 9.6000e-09 0.4915 9.9900e-09 0.4915 1.0000e-08 0.4885 1.0390e-08 0.4885 1.0400e-08 0.4905 1.0790e-08 0.4905 1.0800e-08 0.4895 1.1190e-08 0.4895 1.1200e-08 0.49015 1.1590e-08 0.49015 1.1600e-08 0.48985 1.1990e-08 0.48985 1.2000e-08 0.49005 1.2390e-08 0.49005 1.2400e-08 0.48995 1.2790e-08 0.48995 1.2800e-08 0.490015 1.3190e-08 0.490015 1.3200e-08 0.489985 1.3590e-08 0.489985 1.3600e-08 0.490005 1.3990e-08 0.490005 1.4000e-08 0.489995]
VDN (INN 0) vsource type=pwl wave=[0.0000e+00 0.44 3.9000e-10 0.44 4.0000e-10 0.54 7.9000e-10 0.54 8.0000e-10 0.475 1.1900e-09 0.475 1.2000e-09 0.505 1.5900e-09 0.505 1.6000e-09 0.485 1.9900e-09 0.485 2.0000e-09 0.495 2.3900e-09 0.495 2.4000e-09 0.4885 2.7900e-09 0.4885 2.8000e-09 0.4915 3.1900e-09 0.4915 3.2000e-09 0.4895 3.5900e-09 0.4895 3.6000e-09 0.4905 3.9900e-09 0.4905 4.0000e-09 0.48985 4.3900e-09 0.48985 4.4000e-09 0.49015 4.7900e-09 0.49015 4.8000e-09 0.48995 5.1900e-09 0.48995 5.2000e-09 0.49005 5.5900e-09 0.49005 5.6000e-09 0.489985 5.9900e-09 0.489985 6.0000e-09 0.490015 6.3900e-09 0.490015 6.4000e-09 0.489995 6.7900e-09 0.489995 6.8000e-09 0.490005 7.1900e-09 0.490005 7.2000e-09 0.44 7.5900e-09 0.44 7.6000e-09 0.54 7.9900e-09 0.54 8.0000e-09 0.475 8.3900e-09 0.475 8.4000e-09 0.505 8.7900e-09 0.505 8.8000e-09 0.485 9.1900e-09 0.485 9.2000e-09 0.495 9.5900e-09 0.495 9.6000e-09 0.4885 9.9900e-09 0.4885 1.0000e-08 0.4915 1.0390e-08 0.4915 1.0400e-08 0.4895 1.0790e-08 0.4895 1.0800e-08 0.4905 1.1190e-08 0.4905 1.1200e-08 0.48985 1.1590e-08 0.48985 1.1600e-08 0.49015 1.1990e-08 0.49015 1.2000e-08 0.48995 1.2390e-08 0.48995 1.2400e-08 0.49005 1.2790e-08 0.49005 1.2800e-08 0.489985 1.3190e-08 0.489985 1.3200e-08 0.490015 1.3590e-08 0.490015 1.3600e-08 0.489995 1.3990e-08 0.489995 1.4000e-08 0.490005]
VCK (CLKC 0) vsource type=pulse val0=0 val1=vdd period=4e-10 delay=100p width=1.9e-10 rise=10p fall=10p
COP (OUTP 0) capacitor c=cload
CON (OUTN 0) capacitor c=cload
VAVDD (AVDD_S 0) vsource dc=vdd
IMAVDD (AVDD_S AVDD) tb_imeter_va tstart=tstart tstop=tstop label="AVDD" fname="power.txt"
tran1 tran stop=tstop errpreset=conservative
save INP INN CLKC OUTP OUTN
waveopts options save=selected
// @RNL {
//   /* pins connected by net name: the net-name label of rnl-std-fill on every unwired pin, placed below by its key netname */
//   $LABEL_TERMINAL_SET @TEXT("${net}", key="netname", size=0.6);
//   /* --- semantics --- */
//   &0 @ADD-TO $GROUND_NET_SET;
//   #XDUT @PLACE(6, 0);
//   #VDP @PLACE(-16, 5);
//   #VDN @PLACE(-16, -4);
//   #VCK @PLACE(-16, -13);
//   #COP @PLACE(0, -15);
//   #CON @PLACE(8, -15);
//   #VAVDD @PLACE(0, 17);
//   #IMAVDD @PLACE(12, 18);
//   #XDUT:INP @TEXT("${net}", key="netname", size=0.6, halign="end", valign="middle", dx=-0.4, dy=0);
//   #XDUT:INN @TEXT("${net}", key="netname", size=0.6, halign="end", valign="middle", dx=-0.4, dy=0);
//   #XDUT:CLKC @TEXT("${net}", key="netname", size=0.6, halign="end", valign="middle", rotate=90, dx=0, dy=-0.4);
//   #XDUT:OUTP @TEXT("${net}", key="netname", size=0.6, halign="start", valign="middle", dx=0.4, dy=0);
//   #XDUT:OUTN @TEXT("${net}", key="netname", size=0.6, halign="start", valign="middle", dx=0.4, dy=0);
//   #XDUT:AVDD @TEXT("${net}", key="netname", size=0.6, halign="start", valign="middle", rotate=90, dx=0, dy=0.4);
//   %g1 = $GROUND @ATTACH &0 => @PLACE(4, -6.5);
//   &0 @WIRE {#XDUT:VSS %g1:p};
//   #VDP:1 @TEXT("${net}", key="netname", size=0.6, halign="start", valign="middle", rotate=90, dx=0, dy=0.4);
//   %g2 = $GROUND @ATTACH &0 => @PLACE(-16, 1.5);
//   &0 @WIRE {#VDP:2 %g2:p};
//   #VDN:1 @TEXT("${net}", key="netname", size=0.6, halign="start", valign="middle", rotate=90, dx=0, dy=0.4);
//   %g3 = $GROUND @ATTACH &0 => @PLACE(-16, -7.5);
//   &0 @WIRE {#VDN:2 %g3:p};
//   #VCK:1 @TEXT("${net}", key="netname", size=0.6, halign="start", valign="middle", rotate=90, dx=0, dy=0.4);
//   %g4 = $GROUND @ATTACH &0 => @PLACE(-16, -16.5);
//   &0 @WIRE {#VCK:2 %g4:p};
//   #COP:1 @TEXT("${net}", key="netname", size=0.6, halign="start", valign="middle", rotate=90, dx=0, dy=0.4);
//   %g5 = $GROUND @ATTACH &0 => @PLACE(0, -18.5);
//   &0 @WIRE {#COP:2 %g5:p};
//   #CON:1 @TEXT("${net}", key="netname", size=0.6, halign="start", valign="middle", rotate=90, dx=0, dy=0.4);
//   %g6 = $GROUND @ATTACH &0 => @PLACE(8, -18.5);
//   &0 @WIRE {#CON:2 %g6:p};
//   #VAVDD:1 @TEXT("${net}", key="netname", size=0.6, halign="start", valign="middle", rotate=90, dx=0, dy=0.4);
//   %g7 = $GROUND @ATTACH &0 => @PLACE(0, 13.5);
//   &0 @WIRE {#VAVDD:2 %g7:p};
//   #IMAVDD:P @TEXT("${net}", key="netname", size=0.6, halign="start", valign="middle", rotate=90, dx=0, dy=0.4);
//   #IMAVDD:N @TEXT("${net}", key="netname", size=0.6, halign="end", valign="middle", rotate=90, dx=0, dy=-0.4);
//   (-30, 31) @TEXT("tb_comp_delay: comparator delay, regeneration, reset and energy", halign="start") => @SET-STYLE $title_style;
//   (-30, 29.4) @TEXT("vd steps through +/-0.1, 0.03, 0.01, 0.003, 0.001, 0.0003, 0.0001, 3e-05, 1e-05 V (twice), CM 0.49 V, one decision per 400 ps", halign="start") => @SET-STYLE $note_style;
//   (-30, 27.8) @TEXT("transient noise off; power.txt: AVDD over the 36 CLKC cycles from the first rising edge (100 ps .. tstop)", halign="start") => @SET-STYLE $note_style
// }
