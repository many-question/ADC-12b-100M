// tb_ref_replay: VREFP under the CDAC charge sequence of a near-Nyquist conversion
// @RNL(type="header") {
//   @VERSION("0.3");
//   @USE-PACKAGE(name="adc28", version="0.1", path="../../design/rnl/adc28.rnl")
// }
// generated by `python -m adcflow gen` from specs/ -- do not edit (tools/adcflow/gen_tb.py)
// Globals vdd, vdd18, tempc, noise_en, devnoise, beh_speed, vref_in come from the run deck.
simulator lang=spectre
// fin here is only a placeholder: the test's prepare step (adcflow.measure.ref:replay_prepare) replaces it with the coherent frequency (odd bin) for npts; run the test through python -m adcflow sim
parameters npts=1024 nwarm=32 fin=48.828125e6 ccdac=1.2p
parameters tstop=(nwarm+npts+2)*10n
XDUT (VREF_IN VREFP VCM AVDD18 AVDD 0) adc_ref
VREF (VREF_IN 0) vsource dc=vref_in
VH (AVDD18 0) vsource dc=vdd18
VA (AVDD 0) vsource dc=vdd
// CDAC bottom plates seen from VREFP (both sides)
CDB (VREFP 0) capacitor c=ccdac
// CDAC charge per conversion from the system model: start + 13 switch pulses
ILD (VREFP 0) isource type=pwl file="iload.pwl"
// toggles at the comparator clock of every decision and just before each start
VTRIG (TRIG 0) vsource type=pwl file="trig.pwl"
// VREFP at every toggle
ISMP (VREFP 0 TRIG 0) tb_sampler_va vth=0.5 dir=0 delay=0 fname="vdec.txt"
tran1 tran stop=tstop outputstart=tstop errpreset=conservative
tbopts options save=none
// @RNL {
//   /* pins connected by net name: the net-name label of rnl-std-fill on every unwired pin, placed below by its key netname */
//   $LABEL_TERMINAL_SET @TEXT("${net}", key="netname", size=0.6);
//   /* --- semantics --- */
//   &0 @ADD-TO $GROUND_NET_SET;
//   #XDUT @PLACE(6, 0);
//   #VREF @PLACE(-16, 5);
//   #VTRIG @PLACE(-16, -4);
//   #ISMP @PLACE(36, 4);
//   #CDB @PLACE(0, -15);
//   #ILD @PLACE(8, -15);
//   #VH @PLACE(0, 17);
//   #VA @PLACE(12, 17);
//   #XDUT:VREF_IN @TEXT("${net}", key="netname", size=0.6, halign="end", valign="middle", dx=-0.4, dy=0);
//   #XDUT:VREFP @TEXT("${net}", key="netname", size=0.6, halign="start", valign="middle", dx=0.4, dy=0);
//   #XDUT:VCM @TEXT("${net}", key="netname", size=0.6, halign="start", valign="middle", dx=0.4, dy=0);
//   #XDUT:AVDD18 @TEXT("${net}", key="netname", size=0.6, halign="start", valign="middle", rotate=90, dx=0, dy=0.4);
//   #XDUT:AVDD @TEXT("${net}", key="netname", size=0.6, halign="start", valign="middle", rotate=90, dx=0, dy=0.4);
//   %g1 = $GROUND @ATTACH &0 => @PLACE(6, -6.5);
//   &0 @WIRE {#XDUT:VSS %g1:p};
//   #VREF:1 @TEXT("${net}", key="netname", size=0.6, halign="start", valign="middle", rotate=90, dx=0, dy=0.4);
//   %g2 = $GROUND @ATTACH &0 => @PLACE(-16, 1.5);
//   &0 @WIRE {#VREF:2 %g2:p};
//   #VH:1 @TEXT("${net}", key="netname", size=0.6, halign="start", valign="middle", rotate=90, dx=0, dy=0.4);
//   %g3 = $GROUND @ATTACH &0 => @PLACE(0, 13.5);
//   &0 @WIRE {#VH:2 %g3:p};
//   #VA:1 @TEXT("${net}", key="netname", size=0.6, halign="start", valign="middle", rotate=90, dx=0, dy=0.4);
//   %g4 = $GROUND @ATTACH &0 => @PLACE(12, 13.5);
//   &0 @WIRE {#VA:2 %g4:p};
//   #CDB:1 @TEXT("${net}", key="netname", size=0.6, halign="start", valign="middle", rotate=90, dx=0, dy=0.4);
//   %g5 = $GROUND @ATTACH &0 => @PLACE(0, -18.5);
//   &0 @WIRE {#CDB:2 %g5:p};
//   #ILD:1 @TEXT("${net}", key="netname", size=0.6, halign="start", valign="middle", rotate=90, dx=0, dy=0.4);
//   %g6 = $GROUND @ATTACH &0 => @PLACE(8, -18.5);
//   &0 @WIRE {#ILD:2 %g6:p};
//   #VTRIG:1 @TEXT("${net}", key="netname", size=0.6, halign="start", valign="middle", rotate=90, dx=0, dy=0.4);
//   %g7 = $GROUND @ATTACH &0 => @PLACE(-16, -7.5);
//   &0 @WIRE {#VTRIG:2 %g7:p};
//   #ISMP:P @TEXT("${net}", key="netname", size=0.6, halign="end", valign="middle", dx=-0.4, dy=0);
//   %g8 = $GROUND @ATTACH &0 => @PLACE(29.5, 3);
//   &0 @WIRE {#ISMP:N (29.5, 3) (29.5, 3) %g8:p};
//   #ISMP:TRIG @TEXT("${net}", key="netname", size=0.6, halign="end", valign="middle", rotate=90, dx=0, dy=-0.4);
//   %g9 = $GROUND @ATTACH &0 => @PLACE(38, -1.5);
//   &0 @WIRE {#ISMP:VSS %g9:p};
//   (-30, 31) @TEXT("tb_ref_replay: VREFP under the CDAC charge sequence of a near-Nyquist conversion", halign="start") => @SET-STYLE $title_style;
//   (-30, 29.4) @TEXT("iload.pwl / trig.pwl are written into the job directory by adcflow.measure.ref:replay_prepare", halign="start") => @SET-STYLE $note_style
// }
