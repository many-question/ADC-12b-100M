// tb_ref_noise: VREFP and VCM noise, 1 kHz - 100 GHz
// @RNL(type="header") {
//   @VERSION("0.3");
//   @USE-PACKAGE(name="adc28", version="0.1", path="../../design/rnl/adc28.rnl")
// }
// generated by `python -m adcflow gen` from specs/ -- do not edit (tools/adcflow/gen_tb.py)
// Globals vdd, vdd18, tempc, noise_en, devnoise, beh_speed, vref_in come from the run deck.
simulator lang=spectre
parameters iload=200u ccdac=1.2p
XDUT (VREF_IN VREFP VCM AVDD18 AVDD 0) adc_ref
VREF (VREF_IN 0) vsource dc=vref_in
VH (AVDD18 0) vsource dc=vdd18
VA (AVDD 0) vsource dc=vdd
IL (VREFP 0) isource dc=iload
CDB (VREFP 0) capacitor c=ccdac
noise1 (VREFP 0) noise start=1k stop=100G dec=20
noise2 (VCM 0) noise start=1k stop=100G dec=20
save VREFP VCM
waveopts options save=selected
// @RNL {
//   /* pins connected by net name: the net-name label of rnl-std-fill on every unwired pin, placed below by its key netname */
//   $LABEL_TERMINAL_SET @TEXT("${net}", key="netname", size=0.6);
//   /* --- semantics --- */
//   &0 @ADD-TO $GROUND_NET_SET;
//   #XDUT @PLACE(6, 0);
//   #VREF @PLACE(-16, 5);
//   #IL @PLACE(0, -15);
//   #CDB @PLACE(8, -15);
//   #VH @PLACE(0, 17);
//   #VA @PLACE(12, 17);
//   #XDUT:VREF_IN @TEXT("${net}", key="netname", size=0.6, halign="end", valign="middle", dx=-0.4, dy=0);
//   #XDUT:VREFP @TEXT("${net}", key="netname", size=0.6, halign="start", valign="middle", dx=0.4, dy=0);
//   #XDUT:VCM @TEXT("${net}", key="netname", size=0.6, halign="start", valign="middle", dx=0.4, dy=0);
//   #XDUT:AVDD18 @TEXT("${net}", key="netname", size=0.6, halign="start", valign="middle", rotate=90, dx=0, dy=0.4);
//   #XDUT:AVDD @TEXT("${net}", key="netname", size=0.6, halign="start", valign="middle", rotate=90, dx=0, dy=0.4);
//   %g1 = $GROUND @ATTACH &0 => @PLACE(6, -6.5);
//   &0 @WIRE {#XDUT:VSS %g1:p};
//   #VREF:1 @TEXT("${net}", key="netname", size=0.6, halign="start", valign="middle", rotate=90, dx=0, dy=0.4);
//   %g2 = $GROUND @ATTACH &0 => @PLACE(-16, 1.5);
//   &0 @WIRE {#VREF:2 %g2:p};
//   #VH:1 @TEXT("${net}", key="netname", size=0.6, halign="start", valign="middle", rotate=90, dx=0, dy=0.4);
//   %g3 = $GROUND @ATTACH &0 => @PLACE(0, 13.5);
//   &0 @WIRE {#VH:2 %g3:p};
//   #VA:1 @TEXT("${net}", key="netname", size=0.6, halign="start", valign="middle", rotate=90, dx=0, dy=0.4);
//   %g4 = $GROUND @ATTACH &0 => @PLACE(12, 13.5);
//   &0 @WIRE {#VA:2 %g4:p};
//   #IL:1 @TEXT("${net}", key="netname", size=0.6, halign="start", valign="middle", rotate=90, dx=0, dy=0.4);
//   %g5 = $GROUND @ATTACH &0 => @PLACE(0, -18.5);
//   &0 @WIRE {#IL:2 %g5:p};
//   #CDB:1 @TEXT("${net}", key="netname", size=0.6, halign="start", valign="middle", rotate=90, dx=0, dy=0.4);
//   %g6 = $GROUND @ATTACH &0 => @PLACE(8, -18.5);
//   &0 @WIRE {#CDB:2 %g6:p};
//   (-30, 31) @TEXT("tb_ref_noise: VREFP and VCM noise, 1 kHz - 100 GHz", halign="start") => @SET-STYLE $title_style
// }
