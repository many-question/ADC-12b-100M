// tb_ref_startup: VREFP / VCM over the supported power-up sequence
// @RNL(type="header") {
//   @VERSION("0.3");
//   @USE-PACKAGE(name="adc28", version="0.1", path="../../design/rnl/adc28.rnl")
// }
// generated by `python -m adcflow gen` from specs/ -- do not edit (tools/adcflow/gen_tb.py)
// Globals vdd, vdd18, tempc, noise_en, devnoise, beh_speed, vref_in come from the run deck.
simulator lang=spectre
parameters ccdac=1.2p ctot=2.50p
parameters tstop=2.5100e-05
XDUT (VREF_IN VREFP VCM AVDD18 AVDD 0) adc_ref
// VREF_IN held at 0 V while the supplies rise and 5 us after them, then a 10 us ramp
VREF (VREF_IN 0) vsource type=pwl wave=[0 0 6.1000e-06 0 1.6100e-05 vref_in]
// AVDD18 and AVDD ramp together (AVDD not later than AVDD18) in 1 us
VH (AVDD18 0) vsource type=pwl wave=[0 0 1.0000e-07 0 1.1000e-06 vdd18]
VA (AVDD 0) vsource type=pwl wave=[0 0 1.0000e-07 0 1.1000e-06 vdd]
// CDAC bottom plates seen from VREFP (both sides)
CDB (VREFP 0) capacitor c=ccdac
// the two top plates on VCM (C_tot each)
CVP (VCM 0) capacitor c=ctot
CVN (VCM 0) capacitor c=ctot
tran1 tran stop=tstop maxstep=1n errpreset=conservative
save VREFP VCM VREF_IN AVDD AVDD18
waveopts options save=selected
// @RNL {
//   /* pins connected by net name: the net-name label of rnl-std-fill on every unwired pin, placed below by its key netname */
//   $LABEL_TERMINAL_SET @TEXT("${net}", key="netname", size=0.6);
//   /* --- semantics --- */
//   &0 @ADD-TO $GROUND_NET_SET;
//   #XDUT @PLACE(6, 0);
//   #VREF @PLACE(-16, 5);
//   #CDB @PLACE(0, -15);
//   #CVP @PLACE(8, -15);
//   #CVN @PLACE(16, -15);
//   #VH @PLACE(0, 17);
//   #VA @PLACE(12, 17);
//   #XDUT:VREF_IN @TEXT("${net}", key="netname", size=0.6, halign="end", valign="middle", dx=-0.4, dy=0);
//   #XDUT:VREFP @TEXT("${net}", key="netname", size=0.6, halign="start", valign="middle", dx=0.4, dy=0);
//   #XDUT:VCM @TEXT("${net}", key="netname", size=0.6, halign="start", valign="middle", dx=0.4, dy=0);
//   #XDUT:AVDD18 @TEXT("${net}", key="netname", size=0.6, halign="start", valign="middle", rotate=90, dx=0, dy=0.4);
//   #XDUT:AVDD @TEXT("${net}", key="netname", size=0.6, halign="start", valign="middle", rotate=90, dx=0, dy=0.4);
//   %g1 = $GROUND @ATTACH &0 => @PLACE(6, -6.5);
//   &0 @WIRE {#XDUT:VSS %g1:p};
//   #VREF:1 @TEXT("${net}", key="netname", size=0.6, halign="start", valign="middle", rotate=90, dx=0, dy=0.4);
//   %g2 = $GROUND @ATTACH &0 => @PLACE(-16, 1.5);
//   &0 @WIRE {#VREF:2 %g2:p};
//   #VH:1 @TEXT("${net}", key="netname", size=0.6, halign="start", valign="middle", rotate=90, dx=0, dy=0.4);
//   %g3 = $GROUND @ATTACH &0 => @PLACE(0, 13.5);
//   &0 @WIRE {#VH:2 %g3:p};
//   #VA:1 @TEXT("${net}", key="netname", size=0.6, halign="start", valign="middle", rotate=90, dx=0, dy=0.4);
//   %g4 = $GROUND @ATTACH &0 => @PLACE(12, 13.5);
//   &0 @WIRE {#VA:2 %g4:p};
//   #CDB:1 @TEXT("${net}", key="netname", size=0.6, halign="start", valign="middle", rotate=90, dx=0, dy=0.4);
//   %g5 = $GROUND @ATTACH &0 => @PLACE(0, -18.5);
//   &0 @WIRE {#CDB:2 %g5:p};
//   #CVP:1 @TEXT("${net}", key="netname", size=0.6, halign="start", valign="middle", rotate=90, dx=0, dy=0.4);
//   %g6 = $GROUND @ATTACH &0 => @PLACE(8, -18.5);
//   &0 @WIRE {#CVP:2 %g6:p};
//   #CVN:1 @TEXT("${net}", key="netname", size=0.6, halign="start", valign="middle", rotate=90, dx=0, dy=0.4);
//   %g7 = $GROUND @ATTACH &0 => @PLACE(16, -18.5);
//   &0 @WIRE {#CVN:2 %g7:p};
//   (-30, 31) @TEXT("tb_ref_startup: VREFP / VCM over the supported power-up sequence", halign="start") => @SET-STYLE $title_style;
//   (-30, 29.4) @TEXT("supplies 0.1-1.1 us, VREF_IN 6.1-16.1 us, ready 21.1 us (CLK static before: no DC load), end 25.1 us", halign="start") => @SET-STYLE $note_style;
//   (-30, 27.8) @TEXT("transient settings: errpreset conservative, maxstep 1n (spec numerics); convergence cross-check: adcflow sim --crosscheck", halign="start") => @SET-STYLE $note_style
// }
