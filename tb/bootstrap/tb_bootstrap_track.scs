// tb_bootstrap_track: differential tracking linearity with the reference switch
// @RNL(type="header") {
//   @VERSION("0.3");
//   @USE-PACKAGE(name="adc28", version="0.1", path="../../design/rnl/adc28.rnl")
// }
// generated by `python -m adcflow gen` from specs/ -- do not edit (tools/adcflow/gen_tb.py)
// Globals vdd, vdd18, tempc, noise_en, devnoise, beh_speed, vref_in come from the run deck.
simulator lang=spectre
// fin here is only a placeholder: the test's prepare step (adcflow.measure.top:prepare) replaces it with the coherent frequency (odd bin) for npts; run the test through python -m adcflow sim
parameters fin=49.8046875e6 amp_dbfs=-1 npts=256 nskip=4 tper=10n fs_peak=0.9930 vcm_in=0.45 rsrc=50 wsw=96u nfsw=48 cs=2.0570p
parameters amp=fs_peak*pow(10, amp_dbfs/20) tstart=nskip*tper tstop=(nskip+npts+0.5)*tper
XBSP (VINP PHI_B PHI_BB VGP AVDD 0) adc_bootstrap
XBSN (VINN PHI_B PHI_BB VGN AVDD 0) adc_bootstrap
VSP (SRCP 0) vsource type=sine sinedc=vcm_in ampl=amp/2 freq=fin
VSN (SRCN 0) vsource type=sine sinedc=vcm_in ampl=-amp/2 freq=fin
RSP (SRCP VINP) resistor r=rsrc
RSN (SRCN VINN) resistor r=rsrc
// bottom-plate voltages at the PHI_S falling edges
ISMP (BPP BPN PHI_S 0) tb_sampler_va dir=-1 delay=0 tstart=tstart fname="samples.txt"
// reference input switch of one CDAC side
MSWP (BPP VGP VINP 0) nch_ulvt_mac w=wsw l=30n nf=nfsw
CSP (BPP TOPRP) capacitor c=cs
STOPP (TOPRP VCM PHI_S 0) relay vt1=0.35 vt2=0.55 ropen=1e12 rclosed=20
CVGP (VGP 0) capacitor c=10f
// reference input switch of one CDAC side
MSWN (BPN VGN VINN 0) nch_ulvt_mac w=wsw l=30n nf=nfsw
CSN (BPN TOPRN) capacitor c=cs
STOPN (TOPRN VCM PHI_S 0) relay vt1=0.35 vt2=0.55 ropen=1e12 rclosed=20
CVGN (VGN 0) capacitor c=10f
VCLK (CLK 0) vsource type=pulse val0=0 val1=vdd period=tper width=tper/2-20p rise=20p fall=20p
// ideal sampling phases
ICG (CLK PHI_S PHI_SB PHI_B PHI_BB CONV VDDA 0) adc_clkgen_va
VDDA (VDDA 0) vsource dc=vdd
VVCM (VCM 0) vsource dc=vref_in/2
VAVDD (AVDD 0) vsource dc=vdd
tran1 tran stop=tstop outputstart=tstop maxstep=1p method=traponly
tbopts options save=none reltol=1e-07 vabstol=1e-08
// @RNL {
//   /* pins connected by net name: the net-name label of rnl-std-fill on every unwired pin, placed below by its key netname */
//   $LABEL_TERMINAL_SET @TEXT("${net}", key="netname", size=0.6);
//   /* --- semantics --- */
//   &0 @ADD-TO $GROUND_NET_SET;
//   #XBSP @PLACE(6, 0);
//   #XBSN @PLACE(34, 0);
//   #VSP @PLACE(-16, 5);
//   #VSN @PLACE(-16, -4);
//   #RSP @PLACE(-16, -13);
//   #RSN @PLACE(-16, -22);
//   #VCLK @PLACE(-16, -31);
//   #ISMP @PLACE(61, 4);
//   #ICG @PLACE(62, -17);
//   #MSWP @PLACE(0, -15);
//   #CSP @PLACE(8, -15);
//   #STOPP @PLACE(16, -15);
//   #CVGP @PLACE(24, -15);
//   #MSWN @PLACE(32, -15);
//   #CSN @PLACE(40, -15);
//   #STOPN @PLACE(48, -15);
//   #CVGN @PLACE(56, -15);
//   #VDDA @PLACE(0, 17);
//   #VVCM @PLACE(12, 17);
//   #VAVDD @PLACE(24, 17);
//   #XBSP:VIN @TEXT("${net}", key="netname", size=0.6, halign="end", valign="middle", dx=-0.4, dy=0);
//   #XBSP:PHI_B @TEXT("${net}", key="netname", size=0.6, halign="end", valign="middle", dx=-0.4, dy=0);
//   #XBSP:PHI_BB @TEXT("${net}", key="netname", size=0.6, halign="end", valign="middle", dx=-0.4, dy=0);
//   #XBSP:VG @TEXT("${net}", key="netname", size=0.6, halign="start", valign="middle", dx=0.4, dy=0);
//   #XBSP:AVDD @TEXT("${net}", key="netname", size=0.6, halign="start", valign="middle", rotate=90, dx=0, dy=0.4);
//   %g1 = $GROUND @ATTACH &0 => @PLACE(10, -6.5);
//   &0 @WIRE {#XBSP:VSS %g1:p};
//   #XBSN:VIN @TEXT("${net}", key="netname", size=0.6, halign="end", valign="middle", dx=-0.4, dy=0);
//   #XBSN:PHI_B @TEXT("${net}", key="netname", size=0.6, halign="end", valign="middle", dx=-0.4, dy=0);
//   #XBSN:PHI_BB @TEXT("${net}", key="netname", size=0.6, halign="end", valign="middle", dx=-0.4, dy=0);
//   #XBSN:VG @TEXT("${net}", key="netname", size=0.6, halign="start", valign="middle", dx=0.4, dy=0);
//   #XBSN:AVDD @TEXT("${net}", key="netname", size=0.6, halign="start", valign="middle", rotate=90, dx=0, dy=0.4);
//   %g2 = $GROUND @ATTACH &0 => @PLACE(38, -6.5);
//   &0 @WIRE {#XBSN:VSS %g2:p};
//   #VSP:1 @TEXT("${net}", key="netname", size=0.6, halign="start", valign="middle", rotate=90, dx=0, dy=0.4);
//   %g3 = $GROUND @ATTACH &0 => @PLACE(-16, 1.5);
//   &0 @WIRE {#VSP:2 %g3:p};
//   #VSN:1 @TEXT("${net}", key="netname", size=0.6, halign="start", valign="middle", rotate=90, dx=0, dy=0.4);
//   %g4 = $GROUND @ATTACH &0 => @PLACE(-16, -7.5);
//   &0 @WIRE {#VSN:2 %g4:p};
//   #RSP:1 @TEXT("${net}", key="netname", size=0.6, halign="start", valign="middle", rotate=90, dx=0, dy=0.4);
//   #RSP:2 @TEXT("${net}", key="netname", size=0.6, halign="end", valign="middle", rotate=90, dx=0, dy=-0.4);
//   #RSN:1 @TEXT("${net}", key="netname", size=0.6, halign="start", valign="middle", rotate=90, dx=0, dy=0.4);
//   #RSN:2 @TEXT("${net}", key="netname", size=0.6, halign="end", valign="middle", rotate=90, dx=0, dy=-0.4);
//   #ISMP:P @TEXT("${net}", key="netname", size=0.6, halign="end", valign="middle", dx=-0.4, dy=0);
//   #ISMP:N @TEXT("${net}", key="netname", size=0.6, halign="end", valign="middle", dx=-0.4, dy=0);
//   #ISMP:TRIG @TEXT("${net}", key="netname", size=0.6, halign="end", valign="middle", rotate=90, dx=0, dy=-0.4);
//   %g5 = $GROUND @ATTACH &0 => @PLACE(63, -1.5);
//   &0 @WIRE {#ISMP:VSS %g5:p};
//   #MSWP:1 @TEXT("${net}", key="netname", size=0.6, halign="start", valign="middle", rotate=90, dx=0, dy=0.4);
//   #MSWP:2 @TEXT("${net}", key="netname", size=0.6, halign="end", valign="middle", dx=-0.4, dy=0);
//   #MSWP:3 @TEXT("${net}", key="netname", size=0.6, halign="end", valign="middle", rotate=90, dx=0, dy=-0.4);
//   %g6 = $GROUND @ATTACH &0 => @PLACE(2.5, -15);
//   &0 @WIRE {#MSWP:4 (2.5, -15) (2.5, -15) %g6:p};
//   #CSP:1 @TEXT("${net}", key="netname", size=0.6, halign="start", valign="middle", rotate=90, dx=0, dy=0.4);
//   #CSP:2 @TEXT("${net}", key="netname", size=0.6, halign="end", valign="middle", rotate=90, dx=0, dy=-0.4);
//   #STOPP:1 @TEXT("${net}", key="netname", size=0.6, halign="end", valign="middle", dx=-0.4, dy=0);
//   #STOPP:2 @TEXT("${net}", key="netname", size=0.6, halign="start", valign="middle", dx=0.4, dy=0);
//   #STOPP:3 @TEXT("${net}", key="netname", size=0.6, halign="end", valign="middle", dx=-0.4, dy=0);
//   %g7 = $GROUND @ATTACH &0 => @PLACE(19.5, -18);
//   &0 @WIRE {#STOPP:4 (19.5, -18) (19.5, -18) %g7:p};
//   #CVGP:1 @TEXT("${net}", key="netname", size=0.6, halign="start", valign="middle", rotate=90, dx=0, dy=0.4);
//   %g8 = $GROUND @ATTACH &0 => @PLACE(24, -18.5);
//   &0 @WIRE {#CVGP:2 %g8:p};
//   #MSWN:1 @TEXT("${net}", key="netname", size=0.6, halign="start", valign="middle", rotate=90, dx=0, dy=0.4);
//   #MSWN:2 @TEXT("${net}", key="netname", size=0.6, halign="end", valign="middle", dx=-0.4, dy=0);
//   #MSWN:3 @TEXT("${net}", key="netname", size=0.6, halign="end", valign="middle", rotate=90, dx=0, dy=-0.4);
//   %g9 = $GROUND @ATTACH &0 => @PLACE(34.5, -15);
//   &0 @WIRE {#MSWN:4 (34.5, -15) (34.5, -15) %g9:p};
//   #CSN:1 @TEXT("${net}", key="netname", size=0.6, halign="start", valign="middle", rotate=90, dx=0, dy=0.4);
//   #CSN:2 @TEXT("${net}", key="netname", size=0.6, halign="end", valign="middle", rotate=90, dx=0, dy=-0.4);
//   #STOPN:1 @TEXT("${net}", key="netname", size=0.6, halign="end", valign="middle", dx=-0.4, dy=0);
//   #STOPN:2 @TEXT("${net}", key="netname", size=0.6, halign="start", valign="middle", dx=0.4, dy=0);
//   #STOPN:3 @TEXT("${net}", key="netname", size=0.6, halign="end", valign="middle", dx=-0.4, dy=0);
//   %g10 = $GROUND @ATTACH &0 => @PLACE(51.5, -18);
//   &0 @WIRE {#STOPN:4 (51.5, -18) (51.5, -18) %g10:p};
//   #CVGN:1 @TEXT("${net}", key="netname", size=0.6, halign="start", valign="middle", rotate=90, dx=0, dy=0.4);
//   %g11 = $GROUND @ATTACH &0 => @PLACE(56, -18.5);
//   &0 @WIRE {#CVGN:2 %g11:p};
//   #VCLK:1 @TEXT("${net}", key="netname", size=0.6, halign="start", valign="middle", rotate=90, dx=0, dy=0.4);
//   %g12 = $GROUND @ATTACH &0 => @PLACE(-16, -34.5);
//   &0 @WIRE {#VCLK:2 %g12:p};
//   #ICG:CLK @TEXT("${net}", key="netname", size=0.6, halign="end", valign="middle", dx=-0.4, dy=0);
//   #ICG:PHI_S @TEXT("${net}", key="netname", size=0.6, halign="start", valign="middle", dx=0.4, dy=0);
//   #ICG:PHI_SB @TEXT("${net}", key="netname", size=0.6, halign="start", valign="middle", dx=0.4, dy=0);
//   #ICG:PHI_B @TEXT("${net}", key="netname", size=0.6, halign="start", valign="middle", dx=0.4, dy=0);
//   #ICG:PHI_BB @TEXT("${net}", key="netname", size=0.6, halign="start", valign="middle", dx=0.4, dy=0);
//   #ICG:CONV @TEXT("${net}", key="netname", size=0.6, halign="start", valign="middle", dx=0.4, dy=0);
//   #ICG:AVDD @TEXT("${net}", key="netname", size=0.6, halign="start", valign="middle", rotate=90, dx=0, dy=0.4);
//   %g13 = $GROUND @ATTACH &0 => @PLACE(62, -25.5);
//   &0 @WIRE {#ICG:VSS %g13:p};
//   #VDDA:1 @TEXT("${net}", key="netname", size=0.6, halign="start", valign="middle", rotate=90, dx=0, dy=0.4);
//   %g14 = $GROUND @ATTACH &0 => @PLACE(0, 13.5);
//   &0 @WIRE {#VDDA:2 %g14:p};
//   #VVCM:1 @TEXT("${net}", key="netname", size=0.6, halign="start", valign="middle", rotate=90, dx=0, dy=0.4);
//   %g15 = $GROUND @ATTACH &0 => @PLACE(12, 13.5);
//   &0 @WIRE {#VVCM:2 %g15:p};
//   #VAVDD:1 @TEXT("${net}", key="netname", size=0.6, halign="start", valign="middle", rotate=90, dx=0, dy=0.4);
//   %g16 = $GROUND @ATTACH &0 => @PLACE(24, 13.5);
//   &0 @WIRE {#VAVDD:2 %g16:p};
//   (-30, 31) @TEXT("tb_bootstrap_track: differential tracking linearity with the reference switch", halign="start") => @SET-STYLE $title_style;
//   (-30, 29.4) @TEXT("transient settings from the spec (numerics): reltol 1e-07, vabstol 1e-08, maxstep 1p, method traponly; convergence cross-check: adcflow sim --crosscheck", halign="start") => @SET-STYLE $note_style
// }
