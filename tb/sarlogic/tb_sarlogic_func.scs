// tb_sarlogic_func: SAR controller against a comparator emulator
// @RNL(type="header") {
//   @VERSION("0.3");
//   @USE-PACKAGE(name="adc28", version="0.1", path="../../design/rnl/adc28.rnl")
// }
// generated by `python -m adcflow gen` from specs/ -- do not edit (tools/adcflow/gen_tb.py)
// Globals vdd, vdd18, tempc, noise_en, devnoise, beh_speed, vref_in come from the run deck.
simulator lang=spectre
parameters nconv=60 t0cmp=45p stuck=0 nowave=0 tper=10n tconv=4.8n tdel=0.12n cupdn=15f cclk=20f cload=50f
parameters tstop=nconv*tper+tdel+1n
XDUT (CONVX OUTP OUTN CLKC UP12 UP11 UP10 UP9 UP8 UP7 UP6 UP5 UP4 UP3 UP2 UP1 UP0 DN12 DN11 \
        DN10 DN9 DN8 DN7 DN6 DN5 DN4 DN3 DN2 DN1 DN0 D13 D12 D11 D10 D9 D8 D7 D6 D5 D4 D3 D2 \
        D1 D0 RDY DVDD 0) adc_sarlogic
// conversion window as adc_clkgen makes it
VCONV (CONV 0) vsource type=pulse val0=0 val1=vdd period=tper delay=tdel width=tconv-20p rise=20p fall=20p
VCONVB (CONVB 0) vsource type=pulse val0=vdd val1=0 period=tper delay=tdel width=tconv-20p rise=20p fall=20p
VDDE (VDDE 0) vsource dc=vdd
// comparator emulator: random input per conversion, decision from the UP/DN DAC level
IEMU (CONV CLKC UP12 UP11 UP10 UP9 UP8 UP7 UP6 UP5 UP4 UP3 UP2 UP1 UP0 DN12 DN11 DN10 DN9 \
        DN8 DN7 DN6 DN5 DN4 DN3 DN2 DN1 DN0 OUTPE OUTNE VDDE 0) tb_cmp_emu_va t0=t0cmp tau=8p cload=cupdn cclk=cclk stuck_k=stuck fname="emu.txt"
// charge into the DUT input net CONVX (input capacitance)
QMCV (CONV CONVX QCV 0) tb_qmeter_va
// charge into the DUT input net OUTP (input capacitance)
QMOP (OUTPE OUTP QOP 0) tb_qmeter_va
// charge into the DUT input net OUTN (input capacitance)
QMON (OUTNE OUTN QON 0) tb_qmeter_va
ICAP (CONVB RDY D13 D12 D11 D10 D9 D8 D7 D6 D5 D4 D3 D2 D1 D0 0) tb_capture_va vth=vdd/2 cload=cload fname="capture.txt"
VDVDD (DVDD_S 0) vsource dc=vdd
IMDVDD (DVDD_S DVDD) tb_imeter_va tstart=tper tstop=tstop label="DVDD" fname="power.txt"
tran1 tran stop=tstop outputstart=nowave*tstop errpreset=conservative
save CONV CLKC OUTP OUTN RDY UP12 DN12 UP11 DN11 UP10 DN10 UP9 DN9 UP8 DN8 UP7 DN7 UP6 DN6 UP4 DN4 UP0 DN0 D0 QCV QOP QON
waveopts options save=selected
// @RNL {
//   /* pins connected by net name: the net-name label of rnl-std-fill on every unwired pin, placed below by its key netname */
//   $LABEL_TERMINAL_SET @TEXT("${net}", key="netname", size=0.6);
//   /* --- semantics --- */
//   &0 @ADD-TO $GROUND_NET_SET;
//   #XDUT @PLACE(7, 0);
//   #VCONV @PLACE(-16, 8);
//   #VCONVB @PLACE(-16, -1);
//   #VDDE @PLACE(-16, -10);
//   #IEMU @PLACE(38, 2);
//   #QMCV @PLACE(34, -17);
//   #QMOP @PLACE(34, -33);
//   #QMON @PLACE(34, -49);
//   #ICAP @PLACE(37, -64);
//   #VDVDD @PLACE(0, 20);
//   #IMDVDD @PLACE(12, 21);
//   #XDUT:CONV @TEXT("${net}", key="netname", size=0.6, halign="end", valign="middle", dx=-0.4, dy=0);
//   #XDUT:OUTP @TEXT("${net}", key="netname", size=0.6, halign="end", valign="middle", dx=-0.4, dy=0);
//   #XDUT:OUTN @TEXT("${net}", key="netname", size=0.6, halign="end", valign="middle", dx=-0.4, dy=0);
//   #XDUT:CLKC @TEXT("${net}", key="netname", size=0.6, halign="end", valign="middle", dx=-0.4, dy=0);
//   %bs1 = {&UP12 &UP11 &UP10 &UP9 &UP8 &UP7 &UP6 &UP5 &UP4 &UP3 &UP2 &UP1 &UP0} @WIRE {#XDUT:UP12 (17, 3)};
//   %bs1 @TEXT("UP<12:0>", size=0.6, halign="start", valign="middle") => @PLACE(17.3, 3);
//   %bs2 = {&DN12 &DN11 &DN10 &DN9 &DN8 &DN7 &DN6 &DN5 &DN4 &DN3 &DN2 &DN1 &DN0} @WIRE {#XDUT:DN12 (17, -3)};
//   %bs2 @TEXT("DN<12:0>", size=0.6, halign="start", valign="middle") => @PLACE(17.3, -3);
//   %bs3 = {&D13 &D12 &D11 &D10 &D9 &D8 &D7 &D6 &D5 &D4 &D3 &D2 &D1 &D0} @WIRE {#XDUT:D13 (5, -11)};
//   %bs3 @TEXT("D<13:0>", size=0.6, halign="end", valign="middle", rotate=90) => @PLACE(5, -11.3);
//   #XDUT:RDY @TEXT("${net}", key="netname", size=0.6, halign="end", valign="middle", rotate=90, dx=0, dy=-0.4);
//   #XDUT:DVDD @TEXT("${net}", key="netname", size=0.6, halign="start", valign="middle", rotate=90, dx=0, dy=0.4);
//   %g1 = $GROUND @ATTACH &0 => @PLACE(12, -9.5);
//   &0 @WIRE {#XDUT:VSS %g1:p};
//   #VCONV:1 @TEXT("${net}", key="netname", size=0.6, halign="start", valign="middle", rotate=90, dx=0, dy=0.4);
//   %g2 = $GROUND @ATTACH &0 => @PLACE(-16, 4.5);
//   &0 @WIRE {#VCONV:2 %g2:p};
//   #VCONVB:1 @TEXT("${net}", key="netname", size=0.6, halign="start", valign="middle", rotate=90, dx=0, dy=0.4);
//   %g3 = $GROUND @ATTACH &0 => @PLACE(-16, -4.5);
//   &0 @WIRE {#VCONVB:2 %g3:p};
//   #VDDE:1 @TEXT("${net}", key="netname", size=0.6, halign="start", valign="middle", rotate=90, dx=0, dy=0.4);
//   %g4 = $GROUND @ATTACH &0 => @PLACE(-16, -13.5);
//   &0 @WIRE {#VDDE:2 %g4:p};
//   #IEMU:CONV @TEXT("${net}", key="netname", size=0.6, halign="end", valign="middle", dx=-0.4, dy=0);
//   #IEMU:CLKC @TEXT("${net}", key="netname", size=0.6, halign="end", valign="middle", dx=-0.4, dy=0);
//   %bs4 = {&UP12 &UP11 &UP10 &UP9 &UP8 &UP7 &UP6 &UP5 &UP4 &UP3 &UP2 &UP1 &UP0} @WIRE {#IEMU:UP12 (48, 4)};
//   %bs4 @TEXT("UP<12:0>", size=0.6, halign="start", valign="middle") => @PLACE(48.3, 4);
//   %bs5 = {&DN12 &DN11 &DN10 &DN9 &DN8 &DN7 &DN6 &DN5 &DN4 &DN3 &DN2 &DN1 &DN0} @WIRE {#IEMU:DN12 (48, 0)};
//   %bs5 @TEXT("DN<12:0>", size=0.6, halign="start", valign="middle") => @PLACE(48.3, 0);
//   #IEMU:OUTP @TEXT("${net}", key="netname", size=0.6, halign="end", valign="middle", dx=-0.4, dy=0);
//   #IEMU:OUTN @TEXT("${net}", key="netname", size=0.6, halign="end", valign="middle", dx=-0.4, dy=0);
//   #IEMU:VDD @TEXT("${net}", key="netname", size=0.6, halign="start", valign="middle", rotate=90, dx=0, dy=0.4);
//   %g5 = $GROUND @ATTACH &0 => @PLACE(38, -5.5);
//   &0 @WIRE {#IEMU:VSS %g5:p};
//   #QMCV:P @TEXT("${net}", key="netname", size=0.6, halign="start", valign="middle", rotate=90, dx=0, dy=0.4);
//   #QMCV:N @TEXT("${net}", key="netname", size=0.6, halign="end", valign="middle", rotate=90, dx=0, dy=-0.4);
//   #QMCV:Q @TEXT("${net}", key="netname", size=0.6, halign="start", valign="middle", dx=0.4, dy=0);
//   %g6 = $GROUND @ATTACH &0 => @PLACE(29.5, -17);
//   &0 @WIRE {#QMCV:VSS (29.5, -17) (29.5, -17) %g6:p};
//   #QMOP:P @TEXT("${net}", key="netname", size=0.6, halign="start", valign="middle", rotate=90, dx=0, dy=0.4);
//   #QMOP:N @TEXT("${net}", key="netname", size=0.6, halign="end", valign="middle", rotate=90, dx=0, dy=-0.4);
//   #QMOP:Q @TEXT("${net}", key="netname", size=0.6, halign="start", valign="middle", dx=0.4, dy=0);
//   %g7 = $GROUND @ATTACH &0 => @PLACE(29.5, -33);
//   &0 @WIRE {#QMOP:VSS (29.5, -33) (29.5, -33) %g7:p};
//   #QMON:P @TEXT("${net}", key="netname", size=0.6, halign="start", valign="middle", rotate=90, dx=0, dy=0.4);
//   #QMON:N @TEXT("${net}", key="netname", size=0.6, halign="end", valign="middle", rotate=90, dx=0, dy=-0.4);
//   #QMON:Q @TEXT("${net}", key="netname", size=0.6, halign="start", valign="middle", dx=0.4, dy=0);
//   %g8 = $GROUND @ATTACH &0 => @PLACE(29.5, -49);
//   &0 @WIRE {#QMON:VSS (29.5, -49) (29.5, -49) %g8:p};
//   #ICAP:CLK @TEXT("${net}", key="netname", size=0.6, halign="end", valign="middle", dx=-0.4, dy=0);
//   #ICAP:RDY @TEXT("${net}", key="netname", size=0.6, halign="end", valign="middle", dx=-0.4, dy=0);
//   %bs6 = {&D13 &D12 &D11 &D10 &D9 &D8 &D7 &D6 &D5 &D4 &D3 &D2 &D1 &D0} @WIRE {#ICAP:D13 (29, -66)};
//   %bs6 @TEXT("D<13:0>", size=0.6, halign="end", valign="middle") => @PLACE(28.7, -66);
//   %g9 = $GROUND @ATTACH &0 => @PLACE(37, -70.5);
//   &0 @WIRE {#ICAP:VSS %g9:p};
//   #VDVDD:1 @TEXT("${net}", key="netname", size=0.6, halign="start", valign="middle", rotate=90, dx=0, dy=0.4);
//   %g10 = $GROUND @ATTACH &0 => @PLACE(0, 16.5);
//   &0 @WIRE {#VDVDD:2 %g10:p};
//   #IMDVDD:P @TEXT("${net}", key="netname", size=0.6, halign="start", valign="middle", rotate=90, dx=0, dy=0.4);
//   #IMDVDD:N @TEXT("${net}", key="netname", size=0.6, halign="end", valign="middle", rotate=90, dx=0, dy=-0.4);
//   (-30, 34) @TEXT("tb_sarlogic_func: SAR controller against a comparator emulator", halign="start") => @SET-STYLE $title_style;
//   (-30, 32.4) @TEXT("UP/DN loaded by cupdn and CLKC by cclk inside the emulator, D/RDY by cload inside the capture", halign="start") => @SET-STYLE $note_style;
//   (-30, 30.8) @TEXT("QMCV / QMOP / QMON: the charge into CONV, OUTP, OUTN per rising edge / VDD (LOG-14, LOG-15)", halign="start") => @SET-STYLE $note_style;
//   (-30, 29.2) @TEXT("stuck=k: the emulator never answers decision k of every odd conversion (timeout test); nowave=1 writes no waveforms (long functional runs)", halign="start") => @SET-STYLE $note_style
// }
