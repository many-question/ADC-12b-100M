// tb_clkgen_jitter: PHI_S falling-edge jitter with transient noise
// @RNL(type="header") {
//   @VERSION("0.3");
//   @USE-PACKAGE(name="adc28", version="0.1", path="../../design/rnl/adc28.rnl")
// }
// generated by `python -m adcflow gen` from specs/ -- do not edit (tools/adcflow/gen_tb.py)
// Globals vdd, vdd18, tempc, noise_en, devnoise, beh_speed, vref_in come from the run deck.
simulator lang=spectre
parameters ncyc=200 nfmax=50G
parameters tstop=(ncyc+1)*10n
XDUT (CLK PHI_S PHI_SB PHI_B PHI_BB CONV AVDD 0) adc_clkgen
VCLK (CLK 0) vsource type=pulse val0=0 val1=vdd period=10n width=4.98n rise=20p fall=20p
// time of every PHI_S falling crossing
ISMP (PHI_S 0 PHI_S 0) tb_sampler_va vth=vdd/2 dir=-1 delay=0 tstart=10n fname="edges.txt"
CLPHI_S (PHI_S 0) capacitor c=100f
CLPHI_SB (PHI_SB 0) capacitor c=100f
CLPHI_B (PHI_B 0) capacitor c=40f
CLPHI_BB (PHI_BB 0) capacitor c=40f
CLCONV (CONV 0) capacitor c=250f
VAVDD (AVDD 0) vsource dc=vdd
tran1 tran stop=tstop noisefmax=nfmax*noise_en*devnoise noiseseed=1 outputstart=tstop errpreset=conservative
tbopts options save=none
// @RNL {
//   /* pins connected by net name: the net-name label of rnl-std-fill on every unwired pin, placed below by its key netname */
//   $LABEL_TERMINAL_SET @TEXT("${net}", key="netname", size=0.6);
//   /* --- semantics --- */
//   &0 @ADD-TO $GROUND_NET_SET;
//   #XDUT @PLACE(6, 0);
//   #VCLK @PLACE(-16, 7);
//   #ISMP @PLACE(33, 6);
//   #CLPHI_S @PLACE(0, -17);
//   #CLPHI_SB @PLACE(8, -17);
//   #CLPHI_B @PLACE(16, -17);
//   #CLPHI_BB @PLACE(24, -17);
//   #CLCONV @PLACE(32, -17);
//   #VAVDD @PLACE(0, 19);
//   #XDUT:CLK @TEXT("${net}", key="netname", size=0.6, halign="end", valign="middle", dx=-0.4, dy=0);
//   #XDUT:PHI_S @TEXT("${net}", key="netname", size=0.6, halign="start", valign="middle", dx=0.4, dy=0);
//   #XDUT:PHI_SB @TEXT("${net}", key="netname", size=0.6, halign="start", valign="middle", dx=0.4, dy=0);
//   #XDUT:PHI_B @TEXT("${net}", key="netname", size=0.6, halign="start", valign="middle", dx=0.4, dy=0);
//   #XDUT:PHI_BB @TEXT("${net}", key="netname", size=0.6, halign="start", valign="middle", dx=0.4, dy=0);
//   #XDUT:CONV @TEXT("${net}", key="netname", size=0.6, halign="start", valign="middle", dx=0.4, dy=0);
//   #XDUT:AVDD @TEXT("${net}", key="netname", size=0.6, halign="start", valign="middle", rotate=90, dx=0, dy=0.4);
//   %g1 = $GROUND @ATTACH &0 => @PLACE(6, -8.5);
//   &0 @WIRE {#XDUT:VSS %g1:p};
//   #VCLK:1 @TEXT("${net}", key="netname", size=0.6, halign="start", valign="middle", rotate=90, dx=0, dy=0.4);
//   %g2 = $GROUND @ATTACH &0 => @PLACE(-16, 3.5);
//   &0 @WIRE {#VCLK:2 %g2:p};
//   #ISMP:P @TEXT("${net}", key="netname", size=0.6, halign="end", valign="middle", dx=-0.4, dy=0);
//   %g3 = $GROUND @ATTACH &0 => @PLACE(26.5, 5);
//   &0 @WIRE {#ISMP:N (26.5, 5) (26.5, 5) %g3:p};
//   #ISMP:TRIG @TEXT("${net}", key="netname", size=0.6, halign="end", valign="middle", rotate=90, dx=0, dy=-0.4);
//   %g4 = $GROUND @ATTACH &0 => @PLACE(35, 0.5);
//   &0 @WIRE {#ISMP:VSS %g4:p};
//   #CLPHI_S:1 @TEXT("${net}", key="netname", size=0.6, halign="start", valign="middle", rotate=90, dx=0, dy=0.4);
//   %g5 = $GROUND @ATTACH &0 => @PLACE(0, -20.5);
//   &0 @WIRE {#CLPHI_S:2 %g5:p};
//   #CLPHI_SB:1 @TEXT("${net}", key="netname", size=0.6, halign="start", valign="middle", rotate=90, dx=0, dy=0.4);
//   %g6 = $GROUND @ATTACH &0 => @PLACE(8, -20.5);
//   &0 @WIRE {#CLPHI_SB:2 %g6:p};
//   #CLPHI_B:1 @TEXT("${net}", key="netname", size=0.6, halign="start", valign="middle", rotate=90, dx=0, dy=0.4);
//   %g7 = $GROUND @ATTACH &0 => @PLACE(16, -20.5);
//   &0 @WIRE {#CLPHI_B:2 %g7:p};
//   #CLPHI_BB:1 @TEXT("${net}", key="netname", size=0.6, halign="start", valign="middle", rotate=90, dx=0, dy=0.4);
//   %g8 = $GROUND @ATTACH &0 => @PLACE(24, -20.5);
//   &0 @WIRE {#CLPHI_BB:2 %g8:p};
//   #CLCONV:1 @TEXT("${net}", key="netname", size=0.6, halign="start", valign="middle", rotate=90, dx=0, dy=0.4);
//   %g9 = $GROUND @ATTACH &0 => @PLACE(32, -20.5);
//   &0 @WIRE {#CLCONV:2 %g9:p};
//   #VAVDD:1 @TEXT("${net}", key="netname", size=0.6, halign="start", valign="middle", rotate=90, dx=0, dy=0.4);
//   %g10 = $GROUND @ATTACH &0 => @PLACE(0, 15.5);
//   &0 @WIRE {#VAVDD:2 %g10:p};
//   (-30, 33) @TEXT("tb_clkgen_jitter: PHI_S falling-edge jitter with transient noise", halign="start") => @SET-STYLE $title_style;
//   (-30, 31.4) @TEXT("output loads from adc_clkgen.yaml operating.loads, 530 fF in total", halign="start") => @SET-STYLE $note_style
// }
