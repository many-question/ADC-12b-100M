// tb_clkgen_timing: phase order, delays, skews and edge rates
// @RNL(type="header") {
//   @VERSION("0.3");
//   @USE-PACKAGE(name="adc28", version="0.1", path="../../design/rnl/adc28.rnl")
// }
// generated by `python -m adcflow gen` from specs/ -- do not edit (tools/adcflow/gen_tb.py)
// Globals vdd, vdd18, tempc, noise_en, devnoise, beh_speed, vref_in come from the run deck.
simulator lang=spectre
parameters tstop=161n
XDUT (CLK PHI_S PHI_SB PHI_B PHI_BB CONV AVDD 0) adc_clkgen
// 8 cycles at 50 % duty, 4 at 45 %, 4 at 55 % (20 ps edges)
VCLK (CLK 0) vsource type=pwl wave=[0.0000e+00 0 1.0000e-09 0 1.0200e-09 vdd 6.0000e-09 vdd 6.0200e-09 0 1.1000e-08 0 1.1020e-08 vdd 1.6000e-08 vdd 1.6020e-08 0 2.1000e-08 0 2.1020e-08 vdd 2.6000e-08 vdd 2.6020e-08 0 3.1000e-08 0 3.1020e-08 vdd 3.6000e-08 vdd 3.6020e-08 0 4.1000e-08 0 4.1020e-08 vdd 4.6000e-08 vdd 4.6020e-08 0 5.1000e-08 0 5.1020e-08 vdd 5.6000e-08 vdd 5.6020e-08 0 6.1000e-08 0 6.1020e-08 vdd 6.6000e-08 vdd 6.6020e-08 0 7.1000e-08 0 7.1020e-08 vdd 7.6000e-08 vdd 7.6020e-08 0 8.1000e-08 0 8.1020e-08 vdd 8.5500e-08 vdd 8.5520e-08 0 9.1000e-08 0 9.1020e-08 vdd 9.5500e-08 vdd 9.5520e-08 0 1.0100e-07 0 1.0102e-07 vdd 1.0550e-07 vdd 1.0552e-07 0 1.1100e-07 0 1.1102e-07 vdd 1.1550e-07 vdd 1.1552e-07 0 1.2100e-07 0 1.2102e-07 vdd 1.2650e-07 vdd 1.2652e-07 0 1.3100e-07 0 1.3102e-07 vdd 1.3650e-07 vdd 1.3652e-07 0 1.4100e-07 0 1.4102e-07 vdd 1.4650e-07 vdd 1.4652e-07 0 1.5100e-07 0 1.5102e-07 vdd 1.5650e-07 vdd 1.5652e-07 0]
CLPHI_S (PHI_S 0) capacitor c=100f
CLPHI_SB (PHI_SB 0) capacitor c=100f
CLPHI_B (PHI_B 0) capacitor c=40f
CLPHI_BB (PHI_BB 0) capacitor c=40f
CLCONV (CONV 0) capacitor c=250f
VAVDD (AVDD_S 0) vsource dc=vdd
IMAVDD (AVDD_S AVDD) tb_imeter_va tstart=10n tstop=80n label="AVDD" fname="power.txt"
tran1 tran stop=tstop maxstep=1p method=traponly errpreset=conservative
tbopts options reltol=1e-07 vabstol=1e-08
save CLK PHI_S PHI_SB PHI_B PHI_BB CONV
// @RNL {
//   /* pins connected by net name: the net-name label of rnl-std-fill on every unwired pin, placed below by its key netname */
//   $LABEL_TERMINAL_SET @TEXT("${net}", key="netname", size=0.6);
//   /* --- semantics --- */
//   &0 @ADD-TO $GROUND_NET_SET;
//   #XDUT @PLACE(6, 0);
//   #VCLK @PLACE(-16, 7);
//   #CLPHI_S @PLACE(0, -17);
//   #CLPHI_SB @PLACE(8, -17);
//   #CLPHI_B @PLACE(16, -17);
//   #CLPHI_BB @PLACE(24, -17);
//   #CLCONV @PLACE(32, -17);
//   #VAVDD @PLACE(0, 19);
//   #IMAVDD @PLACE(12, 20);
//   #XDUT:CLK @TEXT("${net}", key="netname", size=0.6, halign="end", valign="middle", dx=-0.4, dy=0);
//   #XDUT:PHI_S @TEXT("${net}", key="netname", size=0.6, halign="start", valign="middle", dx=0.4, dy=0);
//   #XDUT:PHI_SB @TEXT("${net}", key="netname", size=0.6, halign="start", valign="middle", dx=0.4, dy=0);
//   #XDUT:PHI_B @TEXT("${net}", key="netname", size=0.6, halign="start", valign="middle", dx=0.4, dy=0);
//   #XDUT:PHI_BB @TEXT("${net}", key="netname", size=0.6, halign="start", valign="middle", dx=0.4, dy=0);
//   #XDUT:CONV @TEXT("${net}", key="netname", size=0.6, halign="start", valign="middle", dx=0.4, dy=0);
//   #XDUT:AVDD @TEXT("${net}", key="netname", size=0.6, halign="start", valign="middle", rotate=90, dx=0, dy=0.4);
//   %g1 = $GROUND @ATTACH &0 => @PLACE(6, -8.5);
//   &0 @WIRE {#XDUT:VSS %g1:p};
//   #VCLK:1 @TEXT("${net}", key="netname", size=0.6, halign="start", valign="middle", rotate=90, dx=0, dy=0.4);
//   %g2 = $GROUND @ATTACH &0 => @PLACE(-16, 3.5);
//   &0 @WIRE {#VCLK:2 %g2:p};
//   #CLPHI_S:1 @TEXT("${net}", key="netname", size=0.6, halign="start", valign="middle", rotate=90, dx=0, dy=0.4);
//   %g3 = $GROUND @ATTACH &0 => @PLACE(0, -20.5);
//   &0 @WIRE {#CLPHI_S:2 %g3:p};
//   #CLPHI_SB:1 @TEXT("${net}", key="netname", size=0.6, halign="start", valign="middle", rotate=90, dx=0, dy=0.4);
//   %g4 = $GROUND @ATTACH &0 => @PLACE(8, -20.5);
//   &0 @WIRE {#CLPHI_SB:2 %g4:p};
//   #CLPHI_B:1 @TEXT("${net}", key="netname", size=0.6, halign="start", valign="middle", rotate=90, dx=0, dy=0.4);
//   %g5 = $GROUND @ATTACH &0 => @PLACE(16, -20.5);
//   &0 @WIRE {#CLPHI_B:2 %g5:p};
//   #CLPHI_BB:1 @TEXT("${net}", key="netname", size=0.6, halign="start", valign="middle", rotate=90, dx=0, dy=0.4);
//   %g6 = $GROUND @ATTACH &0 => @PLACE(24, -20.5);
//   &0 @WIRE {#CLPHI_BB:2 %g6:p};
//   #CLCONV:1 @TEXT("${net}", key="netname", size=0.6, halign="start", valign="middle", rotate=90, dx=0, dy=0.4);
//   %g7 = $GROUND @ATTACH &0 => @PLACE(32, -20.5);
//   &0 @WIRE {#CLCONV:2 %g7:p};
//   #VAVDD:1 @TEXT("${net}", key="netname", size=0.6, halign="start", valign="middle", rotate=90, dx=0, dy=0.4);
//   %g8 = $GROUND @ATTACH &0 => @PLACE(0, 15.5);
//   &0 @WIRE {#VAVDD:2 %g8:p};
//   #IMAVDD:P @TEXT("${net}", key="netname", size=0.6, halign="start", valign="middle", rotate=90, dx=0, dy=0.4);
//   #IMAVDD:N @TEXT("${net}", key="netname", size=0.6, halign="end", valign="middle", rotate=90, dx=0, dy=-0.4);
//   (-30, 33) @TEXT("tb_clkgen_timing: phase order, delays, skews and edge rates", halign="start") => @SET-STYLE $title_style;
//   (-30, 31.4) @TEXT("output loads from adc_clkgen.yaml operating.loads, 530 fF in total", halign="start") => @SET-STYLE $note_style;
//   (-30, 29.8) @TEXT("power.txt: average AVDD current over 10-80 ns, output-load charging included (CLK-10)", halign="start") => @SET-STYLE $note_style;
//   (-30, 28.2) @TEXT("CLK-11: the run deck also saves the d/g/s nodes of every thin-oxide MOS in XDUT (adcflow soa); whole run from t = 0", halign="start") => @SET-STYLE $note_style;
//   (-30, 26.6) @TEXT("transient settings from the spec (numerics): reltol 1e-07, vabstol 1e-08, maxstep 1p, method traponly, errpreset conservative; convergence cross-check: adcflow sim --crosscheck", halign="start") => @SET-STYLE $note_style
// }
