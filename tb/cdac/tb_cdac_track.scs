// tb_cdac_track: sampling-network linearity of the two CDACs from 50 ohm
// @RNL(type="header") {
//   @VERSION("0.3");
//   @USE-PACKAGE(name="adc28", version="0.1", path="../../design/rnl/adc28.rnl")
// }
// generated by `python -m adcflow gen` from specs/ -- do not edit (tools/adcflow/gen_tb.py)
// Globals vdd, vdd18, tempc, noise_en, devnoise, beh_speed, vref_in come from the run deck.
simulator lang=spectre
// fin here is only a placeholder: the test's prepare step (adcflow.measure.top:prepare) replaces it with the coherent frequency (odd bin) for npts; run the test through python -m adcflow sim
parameters fin=49.8046875e6 amp_dbfs=-1 npts=256 nskip=4 tper=10n fs_peak=0.9930 vcm_in=0.45 rsrc=50 ctop=20f
parameters amp=fs_peak*pow(10, amp_dbfs/20) tstart=nskip*tper tstop=(nskip+npts+0.5)*tper
XDACP (VINP VGP TOPP VCM VREFP 0 PHI_S PHI_SB CONV LO LO LO LO LO LO LO LO LO LO LO LO LO LO \
        LO LO LO LO LO LO LO LO LO LO LO LO VDDA 0) adc_cdac
XDACN (VINN VGN TOPN VCM VREFP 0 PHI_S PHI_SB CONV LO LO LO LO LO LO LO LO LO LO LO LO LO LO \
        LO LO LO LO LO LO LO LO LO LO LO LO VDDA 0) adc_cdac
VSP (SRCP 0) vsource type=sine sinedc=vcm_in ampl=amp/2 freq=fin
VSN (SRCN 0) vsource type=sine sinedc=vcm_in ampl=-amp/2 freq=fin
RSP (SRCP VINP) resistor r=rsrc
RSN (SRCN VINN) resistor r=rsrc
// all controls low: neutral DAC
VLO (LO 0) vsource dc=0
CTP (TOPP 0) capacitor c=ctop
CTN (TOPN 0) capacitor c=ctop
IBSP (VINP PHI_B PHI_BB VGP VDDA 0) adc_bootstrap_va kboost=1
IBSN (VINN PHI_B PHI_BB VGN VDDA 0) adc_bootstrap_va kboost=1
ISMP (TOPP TOPN CONV 0) tb_sampler_va dir=1 delay=0.3n tstart=tstart fname="samples.txt"
VCLK (CLK 0) vsource type=pulse val0=0 val1=vdd period=tper width=tper/2-20p rise=20p fall=20p
// ideal sampling phases
ICG (CLK PHI_S PHI_SB PHI_B PHI_BB CONV VDDA 0) adc_clkgen_va
VDDA (VDDA 0) vsource dc=vdd
VREFP (VREFP 0) vsource dc=vref_in
VVCM (VCM 0) vsource dc=vref_in/2
tran1 tran stop=tstop outputstart=tstop maxstep=1p method=traponly
tbopts options save=none reltol=1e-07 vabstol=1e-08
// @RNL {
//   /* pins connected by net name: the net-name label of rnl-std-fill on every unwired pin, placed below by its key netname */
//   $LABEL_TERMINAL_SET @TEXT("${net}", key="netname", size=0.6);
//   /* --- semantics --- */
//   &0 @ADD-TO $GROUND_NET_SET;
//   #XDACP @PLACE(11, 0);
//   #XDACN @PLACE(49, 0);
//   #VSP @PLACE(-16, 8);
//   #VSN @PLACE(-16, -1);
//   #RSP @PLACE(-16, -10);
//   #RSN @PLACE(-16, -19);
//   #VLO @PLACE(-16, -28);
//   #VCLK @PLACE(-16, -37);
//   #IBSP @PLACE(82, 3);
//   #IBSN @PLACE(82, -17);
//   #ISMP @PLACE(81, -33);
//   #ICG @PLACE(82, -54);
//   #CTP @PLACE(0, -18);
//   #CTN @PLACE(8, -18);
//   #VDDA @PLACE(0, 20);
//   #VREFP @PLACE(12, 20);
//   #VVCM @PLACE(24, 20);
//   #XDACP:VIN @TEXT("${net}", key="netname", size=0.6, halign="end", valign="middle", dx=-0.4, dy=0);
//   #XDACP:VG @TEXT("${net}", key="netname", size=0.6, halign="end", valign="middle", dx=-0.4, dy=0);
//   #XDACP:TOP @TEXT("${net}", key="netname", size=0.6, halign="start", valign="middle", dx=0.4, dy=0);
//   #XDACP:VCM @TEXT("${net}", key="netname", size=0.6, halign="start", valign="middle", rotate=90, dx=0, dy=0.4);
//   #XDACP:VREFP @TEXT("${net}", key="netname", size=0.6, halign="start", valign="middle", rotate=90, dx=0, dy=0.4);
//   %g1 = $GROUND @ATTACH &0 => @PLACE(15.5, 9);
//   &0 @WIRE {#XDACP:VREFN (14, 9) (15.5, 9) %g1:p};
//   #XDACP:PHI_S @TEXT("${net}", key="netname", size=0.6, halign="end", valign="middle", dx=-0.4, dy=0);
//   #XDACP:PHI_SB @TEXT("${net}", key="netname", size=0.6, halign="end", valign="middle", dx=-0.4, dy=0);
//   #XDACP:CONV @TEXT("${net}", key="netname", size=0.6, halign="end", valign="middle", dx=-0.4, dy=0);
//   %bs1 = {&LO &LO &LO &LO &LO &LO &LO &LO &LO &LO &LO &LO &LO} @WIRE {#XDACP:DH12 (7, -10)};
//   %bs1 @TEXT("LO,LO,LO,LO,LO,LO,LO,LO,LO,LO,LO,LO,LO", size=0.6, halign="end", valign="middle", rotate=90) => @PLACE(7, -10.3);
//   %bs2 = {&LO &LO &LO &LO &LO &LO &LO &LO &LO &LO &LO &LO &LO} @WIRE {#XDACP:RL12 (13, -10)};
//   %bs2 @TEXT("LO,LO,LO,LO,LO,LO,LO,LO,LO,LO,LO,LO,LO", size=0.6, halign="end", valign="middle", rotate=90) => @PLACE(13, -10.3);
//   #XDACP:DVDD @TEXT("${net}", key="netname", size=0.6, halign="start", valign="middle", dx=0.4, dy=0);
//   %g2 = $GROUND @ATTACH &0 => @PLACE(23.5, -4);
//   &0 @WIRE {#XDACP:VSS (23.5, -4) (23.5, -4) %g2:p};
//   #XDACN:VIN @TEXT("${net}", key="netname", size=0.6, halign="end", valign="middle", dx=-0.4, dy=0);
//   #XDACN:VG @TEXT("${net}", key="netname", size=0.6, halign="end", valign="middle", dx=-0.4, dy=0);
//   #XDACN:TOP @TEXT("${net}", key="netname", size=0.6, halign="start", valign="middle", dx=0.4, dy=0);
//   #XDACN:VCM @TEXT("${net}", key="netname", size=0.6, halign="start", valign="middle", rotate=90, dx=0, dy=0.4);
//   #XDACN:VREFP @TEXT("${net}", key="netname", size=0.6, halign="start", valign="middle", rotate=90, dx=0, dy=0.4);
//   %g3 = $GROUND @ATTACH &0 => @PLACE(53.5, 9);
//   &0 @WIRE {#XDACN:VREFN (52, 9) (53.5, 9) %g3:p};
//   #XDACN:PHI_S @TEXT("${net}", key="netname", size=0.6, halign="end", valign="middle", dx=-0.4, dy=0);
//   #XDACN:PHI_SB @TEXT("${net}", key="netname", size=0.6, halign="end", valign="middle", dx=-0.4, dy=0);
//   #XDACN:CONV @TEXT("${net}", key="netname", size=0.6, halign="end", valign="middle", dx=-0.4, dy=0);
//   %bs3 = {&LO &LO &LO &LO &LO &LO &LO &LO &LO &LO &LO &LO &LO} @WIRE {#XDACN:DH12 (45, -10)};
//   %bs3 @TEXT("LO,LO,LO,LO,LO,LO,LO,LO,LO,LO,LO,LO,LO", size=0.6, halign="end", valign="middle", rotate=90) => @PLACE(45, -10.3);
//   %bs4 = {&LO &LO &LO &LO &LO &LO &LO &LO &LO &LO &LO &LO &LO} @WIRE {#XDACN:RL12 (51, -10)};
//   %bs4 @TEXT("LO,LO,LO,LO,LO,LO,LO,LO,LO,LO,LO,LO,LO", size=0.6, halign="end", valign="middle", rotate=90) => @PLACE(51, -10.3);
//   #XDACN:DVDD @TEXT("${net}", key="netname", size=0.6, halign="start", valign="middle", dx=0.4, dy=0);
//   %g4 = $GROUND @ATTACH &0 => @PLACE(61.5, -4);
//   &0 @WIRE {#XDACN:VSS (61.5, -4) (61.5, -4) %g4:p};
//   #VSP:1 @TEXT("${net}", key="netname", size=0.6, halign="start", valign="middle", rotate=90, dx=0, dy=0.4);
//   %g5 = $GROUND @ATTACH &0 => @PLACE(-16, 4.5);
//   &0 @WIRE {#VSP:2 %g5:p};
//   #VSN:1 @TEXT("${net}", key="netname", size=0.6, halign="start", valign="middle", rotate=90, dx=0, dy=0.4);
//   %g6 = $GROUND @ATTACH &0 => @PLACE(-16, -4.5);
//   &0 @WIRE {#VSN:2 %g6:p};
//   #RSP:1 @TEXT("${net}", key="netname", size=0.6, halign="start", valign="middle", rotate=90, dx=0, dy=0.4);
//   #RSP:2 @TEXT("${net}", key="netname", size=0.6, halign="end", valign="middle", rotate=90, dx=0, dy=-0.4);
//   #RSN:1 @TEXT("${net}", key="netname", size=0.6, halign="start", valign="middle", rotate=90, dx=0, dy=0.4);
//   #RSN:2 @TEXT("${net}", key="netname", size=0.6, halign="end", valign="middle", rotate=90, dx=0, dy=-0.4);
//   #VLO:1 @TEXT("${net}", key="netname", size=0.6, halign="start", valign="middle", rotate=90, dx=0, dy=0.4);
//   %g7 = $GROUND @ATTACH &0 => @PLACE(-16, -31.5);
//   &0 @WIRE {#VLO:2 %g7:p};
//   #CTP:1 @TEXT("${net}", key="netname", size=0.6, halign="start", valign="middle", rotate=90, dx=0, dy=0.4);
//   %g8 = $GROUND @ATTACH &0 => @PLACE(0, -21.5);
//   &0 @WIRE {#CTP:2 %g8:p};
//   #CTN:1 @TEXT("${net}", key="netname", size=0.6, halign="start", valign="middle", rotate=90, dx=0, dy=0.4);
//   %g9 = $GROUND @ATTACH &0 => @PLACE(8, -21.5);
//   &0 @WIRE {#CTN:2 %g9:p};
//   #IBSP:VIN @TEXT("${net}", key="netname", size=0.6, halign="end", valign="middle", dx=-0.4, dy=0);
//   #IBSP:PHI_B @TEXT("${net}", key="netname", size=0.6, halign="end", valign="middle", dx=-0.4, dy=0);
//   #IBSP:PHI_BB @TEXT("${net}", key="netname", size=0.6, halign="end", valign="middle", dx=-0.4, dy=0);
//   #IBSP:VG @TEXT("${net}", key="netname", size=0.6, halign="start", valign="middle", dx=0.4, dy=0);
//   #IBSP:AVDD @TEXT("${net}", key="netname", size=0.6, halign="start", valign="middle", rotate=90, dx=0, dy=0.4);
//   %g10 = $GROUND @ATTACH &0 => @PLACE(86, -3.5);
//   &0 @WIRE {#IBSP:VSS %g10:p};
//   #IBSN:VIN @TEXT("${net}", key="netname", size=0.6, halign="end", valign="middle", dx=-0.4, dy=0);
//   #IBSN:PHI_B @TEXT("${net}", key="netname", size=0.6, halign="end", valign="middle", dx=-0.4, dy=0);
//   #IBSN:PHI_BB @TEXT("${net}", key="netname", size=0.6, halign="end", valign="middle", dx=-0.4, dy=0);
//   #IBSN:VG @TEXT("${net}", key="netname", size=0.6, halign="start", valign="middle", dx=0.4, dy=0);
//   #IBSN:AVDD @TEXT("${net}", key="netname", size=0.6, halign="start", valign="middle", rotate=90, dx=0, dy=0.4);
//   %g11 = $GROUND @ATTACH &0 => @PLACE(86, -23.5);
//   &0 @WIRE {#IBSN:VSS %g11:p};
//   #ISMP:P @TEXT("${net}", key="netname", size=0.6, halign="end", valign="middle", dx=-0.4, dy=0);
//   #ISMP:N @TEXT("${net}", key="netname", size=0.6, halign="end", valign="middle", dx=-0.4, dy=0);
//   #ISMP:TRIG @TEXT("${net}", key="netname", size=0.6, halign="end", valign="middle", rotate=90, dx=0, dy=-0.4);
//   %g12 = $GROUND @ATTACH &0 => @PLACE(83, -38.5);
//   &0 @WIRE {#ISMP:VSS %g12:p};
//   #VCLK:1 @TEXT("${net}", key="netname", size=0.6, halign="start", valign="middle", rotate=90, dx=0, dy=0.4);
//   %g13 = $GROUND @ATTACH &0 => @PLACE(-16, -40.5);
//   &0 @WIRE {#VCLK:2 %g13:p};
//   #ICG:CLK @TEXT("${net}", key="netname", size=0.6, halign="end", valign="middle", dx=-0.4, dy=0);
//   #ICG:PHI_S @TEXT("${net}", key="netname", size=0.6, halign="start", valign="middle", dx=0.4, dy=0);
//   #ICG:PHI_SB @TEXT("${net}", key="netname", size=0.6, halign="start", valign="middle", dx=0.4, dy=0);
//   #ICG:PHI_B @TEXT("${net}", key="netname", size=0.6, halign="start", valign="middle", dx=0.4, dy=0);
//   #ICG:PHI_BB @TEXT("${net}", key="netname", size=0.6, halign="start", valign="middle", dx=0.4, dy=0);
//   #ICG:CONV @TEXT("${net}", key="netname", size=0.6, halign="start", valign="middle", dx=0.4, dy=0);
//   #ICG:AVDD @TEXT("${net}", key="netname", size=0.6, halign="start", valign="middle", rotate=90, dx=0, dy=0.4);
//   %g14 = $GROUND @ATTACH &0 => @PLACE(82, -62.5);
//   &0 @WIRE {#ICG:VSS %g14:p};
//   #VDDA:1 @TEXT("${net}", key="netname", size=0.6, halign="start", valign="middle", rotate=90, dx=0, dy=0.4);
//   %g15 = $GROUND @ATTACH &0 => @PLACE(0, 16.5);
//   &0 @WIRE {#VDDA:2 %g15:p};
//   #VREFP:1 @TEXT("${net}", key="netname", size=0.6, halign="start", valign="middle", rotate=90, dx=0, dy=0.4);
//   %g16 = $GROUND @ATTACH &0 => @PLACE(12, 16.5);
//   &0 @WIRE {#VREFP:2 %g16:p};
//   #VVCM:1 @TEXT("${net}", key="netname", size=0.6, halign="start", valign="middle", rotate=90, dx=0, dy=0.4);
//   %g17 = $GROUND @ATTACH &0 => @PLACE(24, 16.5);
//   &0 @WIRE {#VVCM:2 %g17:p};
//   (-30, 34) @TEXT("tb_cdac_track: sampling-network linearity of the two CDACs from 50 ohm", halign="start") => @SET-STYLE $title_style;
//   (-30, 32.4) @TEXT("V(TOPP) - V(TOPN) 300 ps after CONV rises (neutral DAC, no decisions) is the sampled input", halign="start") => @SET-STYLE $note_style;
//   (-30, 30.8) @TEXT("transient settings from the spec (numerics): reltol 1e-07, vabstol 1e-08, maxstep 1p, method traponly; convergence cross-check: adcflow sim --crosscheck", halign="start") => @SET-STYLE $note_style
// }
