// tb_cdac_soa: per-device SOA at the full-scale input and the steps that push the top plate furthest
// @RNL(type="header") {
//   @VERSION("0.3");
//   @USE-PACKAGE(name="adc28", version="0.1", path="../../design/rnl/adc28.rnl")
// }
// generated by `python -m adcflow gen` from specs/ -- do not edit (tools/adcflow/gen_tb.py)
// Globals vdd, vdd18, tempc, noise_en, devnoise, beh_speed, vref_in come from the run deck.
simulator lang=spectre
parameters tper=10n ctop=20f
parameters tstop=7*tper
XDUT (VIN VG TOP VCM VREFP 0 PHI_S PHI_SB CONV DH12 DH11 DH10 DH9 DH8 DH7 DH6 DH5 DH4 DH3 \
        DH2 DH1 DH0 RL12 RL11 RL10 RL9 RL8 RL7 RL6 RL5 RL4 RL3 RL2 RL1 RL0 VDDA 0) adc_cdac
// the input extremes in turn: low in odd conversions, high in even ones
VVIN (VIN 0) vsource type=pulse val0=0.946488 val1=-0.0464876 period=2*tper width=tper-100p rise=100p fall=100p
CTOP (TOP 0) capacitor c=ctop
IBS (VIN PHI_B PHI_BB VG VDDA 0) adc_bootstrap_va kboost=1
// conv 3 (input low): DH12, conv 4 (high): RL12, conv 5 (low): DH0 at 1 ns; conv 6 (high): RL12..RL0 every 150 ps
ISEQ (CONV DH12 DH11 DH10 DH9 DH8 DH7 DH6 DH5 DH4 DH3 DH2 DH1 DH0 RL12 RL11 RL10 RL9 RL8 RL7 \
        RL6 RL5 RL4 RL3 RL2 RL1 RL0 VDDA 0) tb_cdac_seq_va mode=1 n0=3 sel0=0 sel1=1 sel2=24
VCLK (CLK 0) vsource type=pulse val0=0 val1=vdd period=tper width=tper/2-20p rise=20p fall=20p
// ideal sampling phases
ICG (CLK PHI_S PHI_SB PHI_B PHI_BB CONV VDDA 0) adc_clkgen_va
VDDA (VDDA 0) vsource dc=vdd
VREFP (VREFP 0) vsource dc=vref_in
VVCM (VCM 0) vsource dc=vref_in/2
tran1 tran stop=tstop errpreset=conservative
save VIN VG TOP CONV PHI_S
waveopts options save=selected
// @RNL {
//   /* pins connected by net name: the net-name label of rnl-std-fill on every unwired pin, placed below by its key netname */
//   $LABEL_TERMINAL_SET @TEXT("${net}", key="netname", size=0.6);
//   /* --- semantics --- */
//   &0 @ADD-TO $GROUND_NET_SET;
//   #XDUT @PLACE(11, 0);
//   #VVIN @PLACE(-16, 8);
//   #VCLK @PLACE(-16, -1);
//   #IBS @PLACE(44, 3);
//   #ISEQ @PLACE(44, -17);
//   #ICG @PLACE(44, -39);
//   #CTOP @PLACE(0, -18);
//   #VDDA @PLACE(0, 20);
//   #VREFP @PLACE(12, 20);
//   #VVCM @PLACE(24, 20);
//   #XDUT:VIN @TEXT("${net}", key="netname", size=0.6, halign="end", valign="middle", dx=-0.4, dy=0);
//   #XDUT:VG @TEXT("${net}", key="netname", size=0.6, halign="end", valign="middle", dx=-0.4, dy=0);
//   #XDUT:TOP @TEXT("${net}", key="netname", size=0.6, halign="start", valign="middle", dx=0.4, dy=0);
//   #XDUT:VCM @TEXT("${net}", key="netname", size=0.6, halign="start", valign="middle", rotate=90, dx=0, dy=0.4);
//   #XDUT:VREFP @TEXT("${net}", key="netname", size=0.6, halign="start", valign="middle", rotate=90, dx=0, dy=0.4);
//   %g1 = $GROUND @ATTACH &0 => @PLACE(15.5, 9);
//   &0 @WIRE {#XDUT:VREFN (14, 9) (15.5, 9) %g1:p};
//   #XDUT:PHI_S @TEXT("${net}", key="netname", size=0.6, halign="end", valign="middle", dx=-0.4, dy=0);
//   #XDUT:PHI_SB @TEXT("${net}", key="netname", size=0.6, halign="end", valign="middle", dx=-0.4, dy=0);
//   #XDUT:CONV @TEXT("${net}", key="netname", size=0.6, halign="end", valign="middle", dx=-0.4, dy=0);
//   %bs1 = {&DH12 &DH11 &DH10 &DH9 &DH8 &DH7 &DH6 &DH5 &DH4 &DH3 &DH2 &DH1 &DH0} @WIRE {#XDUT:DH12 (7, -10)};
//   %bs1 @TEXT("DH<12:0>", size=0.6, halign="end", valign="middle", rotate=90) => @PLACE(7, -10.3);
//   %bs2 = {&RL12 &RL11 &RL10 &RL9 &RL8 &RL7 &RL6 &RL5 &RL4 &RL3 &RL2 &RL1 &RL0} @WIRE {#XDUT:RL12 (13, -10)};
//   %bs2 @TEXT("RL<12:0>", size=0.6, halign="end", valign="middle", rotate=90) => @PLACE(13, -10.3);
//   #XDUT:DVDD @TEXT("${net}", key="netname", size=0.6, halign="start", valign="middle", dx=0.4, dy=0);
//   %g2 = $GROUND @ATTACH &0 => @PLACE(23.5, -4);
//   &0 @WIRE {#XDUT:VSS (23.5, -4) (23.5, -4) %g2:p};
//   #VVIN:1 @TEXT("${net}", key="netname", size=0.6, halign="start", valign="middle", rotate=90, dx=0, dy=0.4);
//   %g3 = $GROUND @ATTACH &0 => @PLACE(-16, 4.5);
//   &0 @WIRE {#VVIN:2 %g3:p};
//   #CTOP:1 @TEXT("${net}", key="netname", size=0.6, halign="start", valign="middle", rotate=90, dx=0, dy=0.4);
//   %g4 = $GROUND @ATTACH &0 => @PLACE(0, -21.5);
//   &0 @WIRE {#CTOP:2 %g4:p};
//   #IBS:VIN @TEXT("${net}", key="netname", size=0.6, halign="end", valign="middle", dx=-0.4, dy=0);
//   #IBS:PHI_B @TEXT("${net}", key="netname", size=0.6, halign="end", valign="middle", dx=-0.4, dy=0);
//   #IBS:PHI_BB @TEXT("${net}", key="netname", size=0.6, halign="end", valign="middle", dx=-0.4, dy=0);
//   #IBS:VG @TEXT("${net}", key="netname", size=0.6, halign="start", valign="middle", dx=0.4, dy=0);
//   #IBS:AVDD @TEXT("${net}", key="netname", size=0.6, halign="start", valign="middle", rotate=90, dx=0, dy=0.4);
//   %g5 = $GROUND @ATTACH &0 => @PLACE(48, -3.5);
//   &0 @WIRE {#IBS:VSS %g5:p};
//   #ISEQ:CONV @TEXT("${net}", key="netname", size=0.6, halign="end", valign="middle", dx=-0.4, dy=0);
//   %bs3 = {&DH12 &DH11 &DH10 &DH9 &DH8 &DH7 &DH6 &DH5 &DH4 &DH3 &DH2 &DH1 &DH0} @WIRE {#ISEQ:DH12 (53, -15)};
//   %bs3 @TEXT("DH<12:0>", size=0.6, halign="start", valign="middle") => @PLACE(53.3, -15);
//   %bs4 = {&RL12 &RL11 &RL10 &RL9 &RL8 &RL7 &RL6 &RL5 &RL4 &RL3 &RL2 &RL1 &RL0} @WIRE {#ISEQ:RL12 (53, -19)};
//   %bs4 @TEXT("RL<12:0>", size=0.6, halign="start", valign="middle") => @PLACE(53.3, -19);
//   #ISEQ:VDD @TEXT("${net}", key="netname", size=0.6, halign="start", valign="middle", rotate=90, dx=0, dy=0.4);
//   %g6 = $GROUND @ATTACH &0 => @PLACE(44, -23.5);
//   &0 @WIRE {#ISEQ:VSS %g6:p};
//   #VCLK:1 @TEXT("${net}", key="netname", size=0.6, halign="start", valign="middle", rotate=90, dx=0, dy=0.4);
//   %g7 = $GROUND @ATTACH &0 => @PLACE(-16, -4.5);
//   &0 @WIRE {#VCLK:2 %g7:p};
//   #ICG:CLK @TEXT("${net}", key="netname", size=0.6, halign="end", valign="middle", dx=-0.4, dy=0);
//   #ICG:PHI_S @TEXT("${net}", key="netname", size=0.6, halign="start", valign="middle", dx=0.4, dy=0);
//   #ICG:PHI_SB @TEXT("${net}", key="netname", size=0.6, halign="start", valign="middle", dx=0.4, dy=0);
//   #ICG:PHI_B @TEXT("${net}", key="netname", size=0.6, halign="start", valign="middle", dx=0.4, dy=0);
//   #ICG:PHI_BB @TEXT("${net}", key="netname", size=0.6, halign="start", valign="middle", dx=0.4, dy=0);
//   #ICG:CONV @TEXT("${net}", key="netname", size=0.6, halign="start", valign="middle", dx=0.4, dy=0);
//   #ICG:AVDD @TEXT("${net}", key="netname", size=0.6, halign="start", valign="middle", rotate=90, dx=0, dy=0.4);
//   %g8 = $GROUND @ATTACH &0 => @PLACE(44, -47.5);
//   &0 @WIRE {#ICG:VSS %g8:p};
//   #VDDA:1 @TEXT("${net}", key="netname", size=0.6, halign="start", valign="middle", rotate=90, dx=0, dy=0.4);
//   %g9 = $GROUND @ATTACH &0 => @PLACE(0, 16.5);
//   &0 @WIRE {#VDDA:2 %g9:p};
//   #VREFP:1 @TEXT("${net}", key="netname", size=0.6, halign="start", valign="middle", rotate=90, dx=0, dy=0.4);
//   %g10 = $GROUND @ATTACH &0 => @PLACE(12, 16.5);
//   &0 @WIRE {#VREFP:2 %g10:p};
//   #VVCM:1 @TEXT("${net}", key="netname", size=0.6, halign="start", valign="middle", rotate=90, dx=0, dy=0.4);
//   %g11 = $GROUND @ATTACH &0 => @PLACE(24, 16.5);
//   &0 @WIRE {#VVCM:2 %g11:p};
//   (-30, 34) @TEXT("tb_cdac_soa: per-device SOA at the full-scale input and the steps that push the top plate furthest", halign="start") => @SET-STYLE $title_style;
//   (-30, 32.4) @TEXT("conv 4 and conv 6 sample the high input and step down: conv 6 is an all-RL pattern, past any real code", halign="start") => @SET-STYLE $note_style;
//   (-30, 30.8) @TEXT("conv 3 samples the low input and steps DH12 up", halign="start") => @SET-STYLE $note_style
// }
